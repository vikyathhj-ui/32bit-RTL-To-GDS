* NGSPICE file created from alu32.ext - technology: sky130A

* Black-box entry subcircuit for sky130_fd_sc_hd__fill_2 abstract view
.subckt sky130_fd_sc_hd__fill_2 VGND VNB VPB VPWR
.ends

* Black-box entry subcircuit for sky130_fd_sc_hd__fill_1 abstract view
.subckt sky130_fd_sc_hd__fill_1 VGND VNB VPB VPWR
.ends

* Black-box entry subcircuit for sky130_fd_sc_hd__decap_3 abstract view
.subckt sky130_fd_sc_hd__decap_3 VGND VNB VPB VPWR
.ends

* Black-box entry subcircuit for sky130_fd_sc_hd__o21a_2 abstract view
.subckt sky130_fd_sc_hd__o21a_2 A1 A2 B1 VGND VNB VPB VPWR X
.ends

* Black-box entry subcircuit for sky130_fd_sc_hd__or3b_2 abstract view
.subckt sky130_fd_sc_hd__or3b_2 A B C_N VGND VNB VPB VPWR X
.ends

* Black-box entry subcircuit for sky130_fd_sc_hd__a21o_2 abstract view
.subckt sky130_fd_sc_hd__a21o_2 A1 A2 B1 VGND VNB VPB VPWR X
.ends

* Black-box entry subcircuit for sky130_fd_sc_hd__xnor2_2 abstract view
.subckt sky130_fd_sc_hd__xnor2_2 A B VGND VNB VPB VPWR Y
.ends

* Black-box entry subcircuit for sky130_fd_sc_hd__nand2_2 abstract view
.subckt sky130_fd_sc_hd__nand2_2 A B VGND VNB VPB VPWR Y
.ends

* Black-box entry subcircuit for sky130_fd_sc_hd__inv_2 abstract view
.subckt sky130_fd_sc_hd__inv_2 A VGND VNB VPB VPWR Y
.ends

* Black-box entry subcircuit for sky130_fd_sc_hd__tapvpwrvgnd_1 abstract view
.subckt sky130_fd_sc_hd__tapvpwrvgnd_1 VGND VPWR
.ends

* Black-box entry subcircuit for sky130_fd_sc_hd__a32o_2 abstract view
.subckt sky130_fd_sc_hd__a32o_2 A1 A2 A3 B1 B2 VGND VNB VPB VPWR X
.ends

* Black-box entry subcircuit for sky130_fd_sc_hd__a22oi_2 abstract view
.subckt sky130_fd_sc_hd__a22oi_2 A1 A2 B1 B2 VGND VNB VPB VPWR Y
.ends

* Black-box entry subcircuit for sky130_fd_sc_hd__and2b_2 abstract view
.subckt sky130_fd_sc_hd__and2b_2 A_N B VGND VNB VPB VPWR X
.ends

* Black-box entry subcircuit for sky130_fd_sc_hd__or3b_4 abstract view
.subckt sky130_fd_sc_hd__or3b_4 A B C_N VGND VNB VPB VPWR X
.ends

* Black-box entry subcircuit for sky130_fd_sc_hd__o21ai_2 abstract view
.subckt sky130_fd_sc_hd__o21ai_2 A1 A2 B1 VGND VNB VPB VPWR Y
.ends

* Black-box entry subcircuit for sky130_fd_sc_hd__or3_2 abstract view
.subckt sky130_fd_sc_hd__or3_2 A B C VGND VNB VPB VPWR X
.ends

* Black-box entry subcircuit for sky130_fd_sc_hd__nand3_2 abstract view
.subckt sky130_fd_sc_hd__nand3_2 A B C VGND VNB VPB VPWR Y
.ends

* Black-box entry subcircuit for sky130_fd_sc_hd__nor2_2 abstract view
.subckt sky130_fd_sc_hd__nor2_2 A B VGND VNB VPB VPWR Y
.ends

* Black-box entry subcircuit for sky130_fd_sc_hd__mux4_2 abstract view
.subckt sky130_fd_sc_hd__mux4_2 A0 A1 A2 A3 S0 S1 VGND VNB VPB VPWR X
.ends

* Black-box entry subcircuit for sky130_fd_sc_hd__and3_2 abstract view
.subckt sky130_fd_sc_hd__and3_2 A B C VGND VNB VPB VPWR X
.ends

* Black-box entry subcircuit for sky130_fd_sc_hd__o211a_2 abstract view
.subckt sky130_fd_sc_hd__o211a_2 A1 A2 B1 C1 VGND VNB VPB VPWR X
.ends

* Black-box entry subcircuit for sky130_fd_sc_hd__clkdlybuf4s25_1 abstract view
.subckt sky130_fd_sc_hd__clkdlybuf4s25_1 A VGND VNB VPB VPWR X
.ends

* Black-box entry subcircuit for sky130_fd_sc_hd__a21oi_2 abstract view
.subckt sky130_fd_sc_hd__a21oi_2 A1 A2 B1 VGND VNB VPB VPWR Y
.ends

* Black-box entry subcircuit for sky130_fd_sc_hd__a221o_2 abstract view
.subckt sky130_fd_sc_hd__a221o_2 A1 A2 B1 B2 C1 VGND VNB VPB VPWR X
.ends

* Black-box entry subcircuit for sky130_fd_sc_hd__clkbuf_2 abstract view
.subckt sky130_fd_sc_hd__clkbuf_2 A VGND VNB VPB VPWR X
.ends

* Black-box entry subcircuit for sky130_fd_sc_hd__a22o_2 abstract view
.subckt sky130_fd_sc_hd__a22o_2 A1 A2 B1 B2 VGND VNB VPB VPWR X
.ends

* Black-box entry subcircuit for sky130_fd_sc_hd__a211o_2 abstract view
.subckt sky130_fd_sc_hd__a211o_2 A1 A2 B1 C1 VGND VNB VPB VPWR X
.ends

* Black-box entry subcircuit for sky130_fd_sc_hd__o211ai_2 abstract view
.subckt sky130_fd_sc_hd__o211ai_2 A1 A2 B1 C1 VGND VNB VPB VPWR Y
.ends

* Black-box entry subcircuit for sky130_fd_sc_hd__and4_2 abstract view
.subckt sky130_fd_sc_hd__and4_2 A B C D VGND VNB VPB VPWR X
.ends

* Black-box entry subcircuit for sky130_fd_sc_hd__o21ba_2 abstract view
.subckt sky130_fd_sc_hd__o21ba_2 A1 A2 B1_N VGND VNB VPB VPWR X
.ends

* Black-box entry subcircuit for sky130_fd_sc_hd__o2bb2a_2 abstract view
.subckt sky130_fd_sc_hd__o2bb2a_2 A1_N A2_N B1 B2 VGND VNB VPB VPWR X
.ends

* Black-box entry subcircuit for sky130_fd_sc_hd__and2_4 abstract view
.subckt sky130_fd_sc_hd__and2_4 A B VGND VNB VPB VPWR X
.ends

* Black-box entry subcircuit for sky130_fd_sc_hd__xor2_2 abstract view
.subckt sky130_fd_sc_hd__xor2_2 A B VGND VNB VPB VPWR X
.ends

* Black-box entry subcircuit for sky130_fd_sc_hd__and4bb_2 abstract view
.subckt sky130_fd_sc_hd__and4bb_2 A_N B_N C D VGND VNB VPB VPWR X
.ends

* Black-box entry subcircuit for sky130_fd_sc_hd__or2_2 abstract view
.subckt sky130_fd_sc_hd__or2_2 A B VGND VNB VPB VPWR X
.ends

* Black-box entry subcircuit for sky130_fd_sc_hd__nand4_2 abstract view
.subckt sky130_fd_sc_hd__nand4_2 A B C D VGND VNB VPB VPWR Y
.ends

* Black-box entry subcircuit for sky130_fd_sc_hd__a31o_2 abstract view
.subckt sky130_fd_sc_hd__a31o_2 A1 A2 A3 B1 VGND VNB VPB VPWR X
.ends

* Black-box entry subcircuit for sky130_fd_sc_hd__a31oi_2 abstract view
.subckt sky130_fd_sc_hd__a31oi_2 A1 A2 A3 B1 VGND VNB VPB VPWR Y
.ends

* Black-box entry subcircuit for sky130_fd_sc_hd__clkbuf_4 abstract view
.subckt sky130_fd_sc_hd__clkbuf_4 A VGND VNB VPB VPWR X
.ends

* Black-box entry subcircuit for sky130_fd_sc_hd__a21o_4 abstract view
.subckt sky130_fd_sc_hd__a21o_4 A1 A2 B1 VGND VNB VPB VPWR X
.ends

* Black-box entry subcircuit for sky130_fd_sc_hd__or3_4 abstract view
.subckt sky130_fd_sc_hd__or3_4 A B C VGND VNB VPB VPWR X
.ends

* Black-box entry subcircuit for sky130_fd_sc_hd__diode_2 abstract view
.subckt sky130_fd_sc_hd__diode_2 DIODE VGND VNB VPB VPWR
.ends

* Black-box entry subcircuit for sky130_fd_sc_hd__or4b_2 abstract view
.subckt sky130_fd_sc_hd__or4b_2 A B C D_N VGND VNB VPB VPWR X
.ends

* Black-box entry subcircuit for sky130_fd_sc_hd__a21bo_2 abstract view
.subckt sky130_fd_sc_hd__a21bo_2 A1 A2 B1_N VGND VNB VPB VPWR X
.ends

* Black-box entry subcircuit for sky130_fd_sc_hd__nor2_4 abstract view
.subckt sky130_fd_sc_hd__nor2_4 A B VGND VNB VPB VPWR Y
.ends

* Black-box entry subcircuit for sky130_fd_sc_hd__buf_4 abstract view
.subckt sky130_fd_sc_hd__buf_4 A VGND VNB VPB VPWR X
.ends

* Black-box entry subcircuit for sky130_fd_sc_hd__and2_2 abstract view
.subckt sky130_fd_sc_hd__and2_2 A B VGND VNB VPB VPWR X
.ends

* Black-box entry subcircuit for sky130_fd_sc_hd__buf_2 abstract view
.subckt sky130_fd_sc_hd__buf_2 A VGND VNB VPB VPWR X
.ends

* Black-box entry subcircuit for sky130_fd_sc_hd__dlymetal6s4s_1 abstract view
.subckt sky130_fd_sc_hd__dlymetal6s4s_1 A VGND VNB VPB VPWR X
.ends

* Black-box entry subcircuit for sky130_fd_sc_hd__nand2b_2 abstract view
.subckt sky130_fd_sc_hd__nand2b_2 A_N B VGND VNB VPB VPWR Y
.ends

* Black-box entry subcircuit for sky130_fd_sc_hd__xnor2_4 abstract view
.subckt sky130_fd_sc_hd__xnor2_4 A B VGND VNB VPB VPWR Y
.ends

* Black-box entry subcircuit for sky130_fd_sc_hd__buf_6 abstract view
.subckt sky130_fd_sc_hd__buf_6 A VGND VNB VPB VPWR X
.ends

* Black-box entry subcircuit for sky130_fd_sc_hd__and3_4 abstract view
.subckt sky130_fd_sc_hd__and3_4 A B C VGND VNB VPB VPWR X
.ends

* Black-box entry subcircuit for sky130_fd_sc_hd__a2bb2o_2 abstract view
.subckt sky130_fd_sc_hd__a2bb2o_2 A1_N A2_N B1 B2 VGND VNB VPB VPWR X
.ends

* Black-box entry subcircuit for sky130_fd_sc_hd__and3b_2 abstract view
.subckt sky130_fd_sc_hd__and3b_2 A_N B C VGND VNB VPB VPWR X
.ends

* Black-box entry subcircuit for sky130_fd_sc_hd__a211oi_2 abstract view
.subckt sky130_fd_sc_hd__a211oi_2 A1 A2 B1 C1 VGND VNB VPB VPWR Y
.ends

* Black-box entry subcircuit for sky130_fd_sc_hd__dlymetal6s2s_1 abstract view
.subckt sky130_fd_sc_hd__dlymetal6s2s_1 A VGND VNB VPB VPWR X
.ends

* Black-box entry subcircuit for sky130_fd_sc_hd__o221a_2 abstract view
.subckt sky130_fd_sc_hd__o221a_2 A1 A2 B1 B2 C1 VGND VNB VPB VPWR X
.ends

* Black-box entry subcircuit for sky130_fd_sc_hd__mux2_1 abstract view
.subckt sky130_fd_sc_hd__mux2_1 A0 A1 S VGND VNB VPB VPWR X
.ends

* Black-box entry subcircuit for sky130_fd_sc_hd__or4_2 abstract view
.subckt sky130_fd_sc_hd__or4_2 A B C D VGND VNB VPB VPWR X
.ends

* Black-box entry subcircuit for sky130_fd_sc_hd__o21bai_2 abstract view
.subckt sky130_fd_sc_hd__o21bai_2 A1 A2 B1_N VGND VNB VPB VPWR Y
.ends

* Black-box entry subcircuit for sky130_fd_sc_hd__a21boi_2 abstract view
.subckt sky130_fd_sc_hd__a21boi_2 A1 A2 B1_N VGND VNB VPB VPWR Y
.ends

* Black-box entry subcircuit for sky130_fd_sc_hd__nor4_4 abstract view
.subckt sky130_fd_sc_hd__nor4_4 A B C D VGND VNB VPB VPWR Y
.ends

* Black-box entry subcircuit for sky130_fd_sc_hd__or4_4 abstract view
.subckt sky130_fd_sc_hd__or4_4 A B C D VGND VNB VPB VPWR X
.ends

* Black-box entry subcircuit for sky130_fd_sc_hd__o22a_2 abstract view
.subckt sky130_fd_sc_hd__o22a_2 A1 A2 B1 B2 VGND VNB VPB VPWR X
.ends

* Black-box entry subcircuit for sky130_fd_sc_hd__nor3_4 abstract view
.subckt sky130_fd_sc_hd__nor3_4 A B C VGND VNB VPB VPWR Y
.ends

* Black-box entry subcircuit for sky130_fd_sc_hd__and4b_2 abstract view
.subckt sky130_fd_sc_hd__and4b_2 A_N B C D VGND VNB VPB VPWR X
.ends

* Black-box entry subcircuit for sky130_fd_sc_hd__a21boi_4 abstract view
.subckt sky130_fd_sc_hd__a21boi_4 A1 A2 B1_N VGND VNB VPB VPWR Y
.ends

* Black-box entry subcircuit for sky130_fd_sc_hd__o41a_2 abstract view
.subckt sky130_fd_sc_hd__o41a_2 A1 A2 A3 A4 B1 VGND VNB VPB VPWR X
.ends

* Black-box entry subcircuit for sky130_fd_sc_hd__o32a_2 abstract view
.subckt sky130_fd_sc_hd__o32a_2 A1 A2 A3 B1 B2 VGND VNB VPB VPWR X
.ends

* Black-box entry subcircuit for sky130_fd_sc_hd__nand3b_2 abstract view
.subckt sky130_fd_sc_hd__nand3b_2 A_N B C VGND VNB VPB VPWR Y
.ends

* Black-box entry subcircuit for sky130_fd_sc_hd__o31ai_2 abstract view
.subckt sky130_fd_sc_hd__o31ai_2 A1 A2 A3 B1 VGND VNB VPB VPWR Y
.ends

* Black-box entry subcircuit for sky130_fd_sc_hd__nor3_2 abstract view
.subckt sky130_fd_sc_hd__nor3_2 A B C VGND VNB VPB VPWR Y
.ends

* Black-box entry subcircuit for sky130_fd_sc_hd__or2_4 abstract view
.subckt sky130_fd_sc_hd__or2_4 A B VGND VNB VPB VPWR X
.ends

* Black-box entry subcircuit for sky130_fd_sc_hd__a311oi_2 abstract view
.subckt sky130_fd_sc_hd__a311oi_2 A1 A2 A3 B1 C1 VGND VNB VPB VPWR Y
.ends

* Black-box entry subcircuit for sky130_fd_sc_hd__a21bo_4 abstract view
.subckt sky130_fd_sc_hd__a21bo_4 A1 A2 B1_N VGND VNB VPB VPWR X
.ends

* Black-box entry subcircuit for sky130_fd_sc_hd__a21oi_4 abstract view
.subckt sky130_fd_sc_hd__a21oi_4 A1 A2 B1 VGND VNB VPB VPWR Y
.ends

* Black-box entry subcircuit for sky130_fd_sc_hd__and4_4 abstract view
.subckt sky130_fd_sc_hd__and4_4 A B C D VGND VNB VPB VPWR X
.ends

* Black-box entry subcircuit for sky130_fd_sc_hd__nor3b_4 abstract view
.subckt sky130_fd_sc_hd__nor3b_4 A B C_N VGND VNB VPB VPWR Y
.ends

* Black-box entry subcircuit for sky130_fd_sc_hd__a211o_4 abstract view
.subckt sky130_fd_sc_hd__a211o_4 A1 A2 B1 C1 VGND VNB VPB VPWR X
.ends

* Black-box entry subcircuit for sky130_fd_sc_hd__a311o_2 abstract view
.subckt sky130_fd_sc_hd__a311o_2 A1 A2 A3 B1 C1 VGND VNB VPB VPWR X
.ends

* Black-box entry subcircuit for sky130_fd_sc_hd__o22ai_2 abstract view
.subckt sky130_fd_sc_hd__o22ai_2 A1 A2 B1 B2 VGND VNB VPB VPWR Y
.ends

* Black-box entry subcircuit for sky130_fd_sc_hd__a22o_4 abstract view
.subckt sky130_fd_sc_hd__a22o_4 A1 A2 B1 B2 VGND VNB VPB VPWR X
.ends

* Black-box entry subcircuit for sky130_fd_sc_hd__o211a_4 abstract view
.subckt sky130_fd_sc_hd__o211a_4 A1 A2 B1 C1 VGND VNB VPB VPWR X
.ends

* Black-box entry subcircuit for sky130_fd_sc_hd__a2111o_2 abstract view
.subckt sky130_fd_sc_hd__a2111o_2 A1 A2 B1 C1 D1 VGND VNB VPB VPWR X
.ends

* Black-box entry subcircuit for sky130_fd_sc_hd__nor4_1 abstract view
.subckt sky130_fd_sc_hd__nor4_1 A B C D VGND VNB VPB VPWR Y
.ends

* Black-box entry subcircuit for sky130_fd_sc_hd__dlygate4sd1_1 abstract view
.subckt sky130_fd_sc_hd__dlygate4sd1_1 A VGND VNB VPB VPWR X
.ends

* Black-box entry subcircuit for sky130_fd_sc_hd__o21ai_4 abstract view
.subckt sky130_fd_sc_hd__o21ai_4 A1 A2 B1 VGND VNB VPB VPWR Y
.ends

* Black-box entry subcircuit for sky130_fd_sc_hd__a31o_4 abstract view
.subckt sky130_fd_sc_hd__a31o_4 A1 A2 A3 B1 VGND VNB VPB VPWR X
.ends

* Black-box entry subcircuit for sky130_fd_sc_hd__a2bb2o_4 abstract view
.subckt sky130_fd_sc_hd__a2bb2o_4 A1_N A2_N B1 B2 VGND VNB VPB VPWR X
.ends

* Black-box entry subcircuit for sky130_fd_sc_hd__o31a_2 abstract view
.subckt sky130_fd_sc_hd__o31a_2 A1 A2 A3 B1 VGND VNB VPB VPWR X
.ends

* Black-box entry subcircuit for sky130_fd_sc_hd__o31ai_4 abstract view
.subckt sky130_fd_sc_hd__o31ai_4 A1 A2 A3 B1 VGND VNB VPB VPWR Y
.ends

* Black-box entry subcircuit for sky130_fd_sc_hd__nand3_4 abstract view
.subckt sky130_fd_sc_hd__nand3_4 A B C VGND VNB VPB VPWR Y
.ends

* Black-box entry subcircuit for sky130_fd_sc_hd__a211oi_4 abstract view
.subckt sky130_fd_sc_hd__a211oi_4 A1 A2 B1 C1 VGND VNB VPB VPWR Y
.ends

* Black-box entry subcircuit for sky130_fd_sc_hd__o211ai_4 abstract view
.subckt sky130_fd_sc_hd__o211ai_4 A1 A2 B1 C1 VGND VNB VPB VPWR Y
.ends

* Black-box entry subcircuit for sky130_fd_sc_hd__nor4_2 abstract view
.subckt sky130_fd_sc_hd__nor4_2 A B C D VGND VNB VPB VPWR Y
.ends

* Black-box entry subcircuit for sky130_fd_sc_hd__nand2b_4 abstract view
.subckt sky130_fd_sc_hd__nand2b_4 A_N B VGND VNB VPB VPWR Y
.ends

* Black-box entry subcircuit for sky130_fd_sc_hd__o221ai_2 abstract view
.subckt sky130_fd_sc_hd__o221ai_2 A1 A2 B1 B2 C1 VGND VNB VPB VPWR Y
.ends

* Black-box entry subcircuit for sky130_fd_sc_hd__o311a_2 abstract view
.subckt sky130_fd_sc_hd__o311a_2 A1 A2 A3 B1 C1 VGND VNB VPB VPWR X
.ends

* Black-box entry subcircuit for sky130_fd_sc_hd__buf_8 abstract view
.subckt sky130_fd_sc_hd__buf_8 A VGND VNB VPB VPWR X
.ends

* Black-box entry subcircuit for sky130_fd_sc_hd__nor3b_2 abstract view
.subckt sky130_fd_sc_hd__nor3b_2 A B C_N VGND VNB VPB VPWR Y
.ends

* Black-box entry subcircuit for sky130_fd_sc_hd__a32oi_2 abstract view
.subckt sky130_fd_sc_hd__a32oi_2 A1 A2 A3 B1 B2 VGND VNB VPB VPWR Y
.ends

* Black-box entry subcircuit for sky130_fd_sc_hd__or4b_4 abstract view
.subckt sky130_fd_sc_hd__or4b_4 A B C D_N VGND VNB VPB VPWR X
.ends

* Black-box entry subcircuit for sky130_fd_sc_hd__buf_1 abstract view
.subckt sky130_fd_sc_hd__buf_1 A VGND VNB VPB VPWR X
.ends

* Black-box entry subcircuit for sky130_fd_sc_hd__a41o_2 abstract view
.subckt sky130_fd_sc_hd__a41o_2 A1 A2 A3 A4 B1 VGND VNB VPB VPWR X
.ends

* Black-box entry subcircuit for sky130_fd_sc_hd__mux2_4 abstract view
.subckt sky130_fd_sc_hd__mux2_4 A0 A1 S VGND VNB VPB VPWR X
.ends

* Black-box entry subcircuit for sky130_fd_sc_hd__o311ai_1 abstract view
.subckt sky130_fd_sc_hd__o311ai_1 A1 A2 A3 B1 C1 VGND VNB VPB VPWR Y
.ends

* Black-box entry subcircuit for sky130_fd_sc_hd__o21ba_4 abstract view
.subckt sky130_fd_sc_hd__o21ba_4 A1 A2 B1_N VGND VNB VPB VPWR X
.ends

* Black-box entry subcircuit for sky130_fd_sc_hd__nor4b_2 abstract view
.subckt sky130_fd_sc_hd__nor4b_2 A B C D_N VGND VNB VPB VPWR Y
.ends

* Black-box entry subcircuit for sky130_fd_sc_hd__or4bb_4 abstract view
.subckt sky130_fd_sc_hd__or4bb_4 A B C_N D_N VGND VNB VPB VPWR X
.ends

* Black-box entry subcircuit for sky130_fd_sc_hd__nand3b_4 abstract view
.subckt sky130_fd_sc_hd__nand3b_4 A_N B C VGND VNB VPB VPWR Y
.ends

* Black-box entry subcircuit for sky130_fd_sc_hd__clkbuf_1 abstract view
.subckt sky130_fd_sc_hd__clkbuf_1 A VGND VNB VPB VPWR X
.ends

* Black-box entry subcircuit for sky130_fd_sc_hd__a41oi_4 abstract view
.subckt sky130_fd_sc_hd__a41oi_4 A1 A2 A3 A4 B1 VGND VNB VPB VPWR Y
.ends

* Black-box entry subcircuit for sky130_fd_sc_hd__xor2_4 abstract view
.subckt sky130_fd_sc_hd__xor2_4 A B VGND VNB VPB VPWR X
.ends

* Black-box entry subcircuit for sky130_fd_sc_hd__or4bb_2 abstract view
.subckt sky130_fd_sc_hd__or4bb_2 A B C_N D_N VGND VNB VPB VPWR X
.ends

* Black-box entry subcircuit for sky130_fd_sc_hd__nand4_4 abstract view
.subckt sky130_fd_sc_hd__nand4_4 A B C D VGND VNB VPB VPWR Y
.ends

.subckt alu32 A[0] A[10] A[11] A[12] A[13] A[14] A[15] A[16] A[17] A[18] A[19] A[1]
+ A[20] A[21] A[22] A[23] A[24] A[25] A[26] A[27] A[28] A[29] A[2] A[30] A[31] A[3]
+ A[4] A[5] A[6] A[7] A[8] A[9] B[0] B[10] B[11] B[12] B[13] B[14] B[15] B[16] B[17]
+ B[18] B[19] B[1] B[20] B[21] B[22] B[23] B[24] B[25] B[26] B[27] B[28] B[29] B[2]
+ B[30] B[31] B[3] B[4] B[5] B[6] B[7] B[8] B[9] VGND VPWR carry opcode[0] opcode[1]
+ opcode[2] opcode[3] overflow result[0] result[10] result[11] result[12] result[13]
+ result[14] result[15] result[16] result[17] result[18] result[19] result[1] result[20]
+ result[21] result[22] result[23] result[24] result[25] result[26] result[27] result[28]
+ result[29] result[2] result[30] result[31] result[3] result[4] result[5] result[6]
+ result[7] result[8] result[9] zero
XFILLER_39_222 VGND VGND VPWR VPWR sky130_fd_sc_hd__fill_2
XFILLER_79_391 VGND VGND VPWR VPWR sky130_fd_sc_hd__fill_1
XFILLER_27_417 VGND VGND VPWR VPWR sky130_fd_sc_hd__decap_3
XFILLER_39_266 VGND VGND VPWR VPWR sky130_fd_sc_hd__decap_3
XFILLER_54_203 VGND VGND VPWR VPWR sky130_fd_sc_hd__decap_3
XFILLER_82_501 VGND VGND VPWR VPWR sky130_fd_sc_hd__fill_2
X_6914_ _6275_/B _6978_/B1 _6913_/X VGND VGND VPWR VPWR _6914_/X sky130_fd_sc_hd__o21a_2
XFILLER_82_589 VGND VGND VPWR VPWR sky130_fd_sc_hd__decap_3
XFILLER_52_29 VGND VGND VPWR VPWR sky130_fd_sc_hd__decap_3
X_6845_ _6845_/A _6930_/A _6843_/X VGND VGND VPWR VPWR _6845_/X sky130_fd_sc_hd__or3b_2
XFILLER_10_306 VGND VGND VPWR VPWR sky130_fd_sc_hd__fill_2
X_6776_ _6775_/B _6775_/C _6775_/A VGND VGND VPWR VPWR _6776_/X sky130_fd_sc_hd__a21o_2
X_3988_ _3988_/A _3988_/B VGND VGND VPWR VPWR _4029_/A sky130_fd_sc_hd__xnor2_2
XFILLER_22_177 VGND VGND VPWR VPWR sky130_fd_sc_hd__fill_2
XFILLER_50_486 VGND VGND VPWR VPWR sky130_fd_sc_hd__decap_3
X_5727_ _5779_/A _5727_/B VGND VGND VPWR VPWR _5761_/A sky130_fd_sc_hd__nand2_2
X_5658_ _5711_/A VGND VGND VPWR VPWR _5678_/B sky130_fd_sc_hd__inv_2
XTAP_TAPCELL_ROW_75_1008 VGND VPWR sky130_fd_sc_hd__tapvpwrvgnd_1
X_5589_ _5588_/A _5778_/C _5588_/D _6122_/A _6120_/A VGND VGND VPWR VPWR _5591_/B
+ sky130_fd_sc_hd__a32o_2
X_4609_ _4607_/A _4607_/C _4607_/D _4607_/B VGND VGND VPWR VPWR _4610_/C sky130_fd_sc_hd__a22oi_2
XFILLER_89_122 VGND VGND VPWR VPWR sky130_fd_sc_hd__fill_2
XFILLER_89_155 VGND VGND VPWR VPWR sky130_fd_sc_hd__decap_3
XFILLER_77_317 VGND VGND VPWR VPWR sky130_fd_sc_hd__decap_3
XFILLER_58_531 VGND VGND VPWR VPWR sky130_fd_sc_hd__fill_1
XFILLER_92_309 VGND VGND VPWR VPWR sky130_fd_sc_hd__decap_3
XFILLER_45_225 VGND VGND VPWR VPWR sky130_fd_sc_hd__fill_1
XFILLER_58_597 VGND VGND VPWR VPWR sky130_fd_sc_hd__fill_1
XFILLER_73_534 VGND VGND VPWR VPWR sky130_fd_sc_hd__fill_2
XFILLER_85_372 VGND VGND VPWR VPWR sky130_fd_sc_hd__decap_3
XTAP_TAPCELL_ROW_86_1115 VGND VPWR sky130_fd_sc_hd__tapvpwrvgnd_1
XFILLER_60_206 VGND VGND VPWR VPWR sky130_fd_sc_hd__fill_1
XFILLER_60_217 VGND VGND VPWR VPWR sky130_fd_sc_hd__decap_3
XFILLER_60_228 VGND VGND VPWR VPWR sky130_fd_sc_hd__decap_3
XFILLER_41_431 VGND VGND VPWR VPWR sky130_fd_sc_hd__decap_3
XFILLER_53_291 VGND VGND VPWR VPWR sky130_fd_sc_hd__decap_3
XFILLER_13_199 VGND VGND VPWR VPWR sky130_fd_sc_hd__decap_3
XFILLER_42_95 VGND VGND VPWR VPWR sky130_fd_sc_hd__fill_1
XTAP_TAPCELL_ROW_11_334 VGND VPWR sky130_fd_sc_hd__tapvpwrvgnd_1
XFILLER_5_321 VGND VGND VPWR VPWR sky130_fd_sc_hd__decap_3
XTAP_TAPCELL_ROW_97_1233 VGND VPWR sky130_fd_sc_hd__tapvpwrvgnd_1
XFILLER_5_376 VGND VGND VPWR VPWR sky130_fd_sc_hd__decap_3
XFILLER_68_328 VGND VGND VPWR VPWR sky130_fd_sc_hd__fill_1
XFILLER_1_593 VGND VGND VPWR VPWR sky130_fd_sc_hd__decap_3
XFILLER_49_531 VGND VGND VPWR VPWR sky130_fd_sc_hd__decap_3
XFILLER_64_501 VGND VGND VPWR VPWR sky130_fd_sc_hd__decap_3
XFILLER_67_70 VGND VGND VPWR VPWR sky130_fd_sc_hd__decap_3
XFILLER_49_597 VGND VGND VPWR VPWR sky130_fd_sc_hd__fill_1
XFILLER_76_394 VGND VGND VPWR VPWR sky130_fd_sc_hd__decap_3
XTAP_TAPCELL_ROW_47_710 VGND VPWR sky130_fd_sc_hd__tapvpwrvgnd_1
XTAP_TAPCELL_ROW_19_412 VGND VPWR sky130_fd_sc_hd__tapvpwrvgnd_1
XFILLER_51_217 VGND VGND VPWR VPWR sky130_fd_sc_hd__decap_3
XFILLER_51_228 VGND VGND VPWR VPWR sky130_fd_sc_hd__decap_3
XFILLER_64_589 VGND VGND VPWR VPWR sky130_fd_sc_hd__decap_3
XFILLER_91_364 VGND VGND VPWR VPWR sky130_fd_sc_hd__decap_3
X_4960_ _4957_/X _4960_/B VGND VGND VPWR VPWR _5041_/B sky130_fd_sc_hd__and2b_2
XFILLER_17_494 VGND VGND VPWR VPWR sky130_fd_sc_hd__decap_3
XFILLER_32_431 VGND VGND VPWR VPWR sky130_fd_sc_hd__decap_3
XFILLER_44_280 VGND VGND VPWR VPWR sky130_fd_sc_hd__decap_3
X_4891_ _5885_/B _4891_/B _4855_/B VGND VGND VPWR VPWR _4911_/A sky130_fd_sc_hd__or3b_4
X_3911_ _3909_/X _3911_/B VGND VGND VPWR VPWR _3912_/B sky130_fd_sc_hd__and2b_2
X_6630_ _6236_/B _6781_/A2 _6629_/X VGND VGND VPWR VPWR _6630_/Y sky130_fd_sc_hd__o21ai_2
X_3842_ _3842_/A _3842_/B _3842_/C VGND VGND VPWR VPWR _3952_/B sky130_fd_sc_hd__or3_2
X_6561_ _6561_/A _6561_/B _6561_/C VGND VGND VPWR VPWR _6986_/A sky130_fd_sc_hd__nand3_2
X_5512_ _5511_/B _5511_/C _5511_/A VGND VGND VPWR VPWR _5512_/Y sky130_fd_sc_hd__o21ai_2
X_3773_ _3773_/A _4180_/A VGND VGND VPWR VPWR _3775_/B sky130_fd_sc_hd__nor2_2
X_6492_ _4176_/A _3872_/A _3868_/A _3867_/A _6492_/S0 _3868_/B VGND VGND VPWR VPWR
+ _6493_/B sky130_fd_sc_hd__mux4_2
X_5443_ _5443_/A _5443_/B VGND VGND VPWR VPWR _5445_/B sky130_fd_sc_hd__nand2_2
X_5374_ _5374_/A _5487_/B _5375_/B VGND VGND VPWR VPWR _5374_/X sky130_fd_sc_hd__and3_2
X_4325_ _4321_/A _4319_/X _3779_/A _3780_/Y VGND VGND VPWR VPWR _4325_/X sky130_fd_sc_hd__o211a_2
XFILLER_59_328 VGND VGND VPWR VPWR sky130_fd_sc_hd__decap_3
XFILLER_86_103 VGND VGND VPWR VPWR sky130_fd_sc_hd__decap_3
Xfanout127 _6296_/Y VGND VGND VPWR VPWR _6960_/A sky130_fd_sc_hd__clkdlybuf4s25_1
Xfanout138 _6978_/A2 VGND VGND VPWR VPWR _6927_/B1 sky130_fd_sc_hd__clkdlybuf4s25_1
XFILLER_99_464 VGND VGND VPWR VPWR sky130_fd_sc_hd__decap_3
Xfanout149 _6061_/Y VGND VGND VPWR VPWR _6982_/A2 sky130_fd_sc_hd__clkdlybuf4s25_1
X_4256_ _4192_/A _4192_/B _4192_/C VGND VGND VPWR VPWR _4256_/Y sky130_fd_sc_hd__a21oi_2
XFILLER_74_309 VGND VGND VPWR VPWR sky130_fd_sc_hd__decap_3
X_4187_ _4432_/A _4568_/B _4187_/C VGND VGND VPWR VPWR _4304_/A sky130_fd_sc_hd__and3_2
XFILLER_27_225 VGND VGND VPWR VPWR sky130_fd_sc_hd__decap_3
XFILLER_94_180 VGND VGND VPWR VPWR sky130_fd_sc_hd__decap_3
XFILLER_15_409 VGND VGND VPWR VPWR sky130_fd_sc_hd__decap_3
XFILLER_55_545 VGND VGND VPWR VPWR sky130_fd_sc_hd__decap_3
XFILLER_55_567 VGND VGND VPWR VPWR sky130_fd_sc_hd__fill_2
XFILLER_27_269 VGND VGND VPWR VPWR sky130_fd_sc_hd__decap_3
XFILLER_42_206 VGND VGND VPWR VPWR sky130_fd_sc_hd__decap_3
XFILLER_55_589 VGND VGND VPWR VPWR sky130_fd_sc_hd__decap_3
XFILLER_70_515 VGND VGND VPWR VPWR sky130_fd_sc_hd__decap_3
XFILLER_42_239 VGND VGND VPWR VPWR sky130_fd_sc_hd__decap_3
XFILLER_70_559 VGND VGND VPWR VPWR sky130_fd_sc_hd__decap_3
X_6828_ _6266_/C _6339_/Y _6363_/Y _6557_/X _6827_/Y VGND VGND VPWR VPWR _6834_/B
+ sky130_fd_sc_hd__a221o_2
XTAP_TAPCELL_ROW_81_1067 VGND VPWR sky130_fd_sc_hd__tapvpwrvgnd_1
XFILLER_23_486 VGND VGND VPWR VPWR sky130_fd_sc_hd__fill_1
XFILLER_50_283 VGND VGND VPWR VPWR sky130_fd_sc_hd__decap_3
XFILLER_10_147 VGND VGND VPWR VPWR sky130_fd_sc_hd__fill_2
XFILLER_10_158 VGND VGND VPWR VPWR sky130_fd_sc_hd__decap_3
X_6759_ _6758_/A _6758_/B _6758_/C VGND VGND VPWR VPWR _6759_/X sky130_fd_sc_hd__a21o_2
XFILLER_12_32 VGND VGND VPWR VPWR sky130_fd_sc_hd__decap_3
XFILLER_2_302 VGND VGND VPWR VPWR sky130_fd_sc_hd__decap_3
XFILLER_2_335 VGND VGND VPWR VPWR sky130_fd_sc_hd__decap_3
XFILLER_88_47 VGND VGND VPWR VPWR sky130_fd_sc_hd__fill_1
XTAP_TAPCELL_ROW_92_1185 VGND VPWR sky130_fd_sc_hd__tapvpwrvgnd_1
XFILLER_77_136 VGND VGND VPWR VPWR sky130_fd_sc_hd__decap_3
Xfanout650 input11/X VGND VGND VPWR VPWR _4165_/A sky130_fd_sc_hd__clkbuf_2
XFILLER_65_309 VGND VGND VPWR VPWR sky130_fd_sc_hd__decap_3
XFILLER_77_158 VGND VGND VPWR VPWR sky130_fd_sc_hd__decap_3
XFILLER_100_480 VGND VGND VPWR VPWR sky130_fd_sc_hd__decap_3
XFILLER_18_225 VGND VGND VPWR VPWR sky130_fd_sc_hd__fill_2
XFILLER_46_523 VGND VGND VPWR VPWR sky130_fd_sc_hd__decap_3
XFILLER_58_383 VGND VGND VPWR VPWR sky130_fd_sc_hd__decap_3
XFILLER_92_139 VGND VGND VPWR VPWR sky130_fd_sc_hd__fill_1
XFILLER_46_567 VGND VGND VPWR VPWR sky130_fd_sc_hd__fill_2
XFILLER_33_228 VGND VGND VPWR VPWR sky130_fd_sc_hd__decap_3
XFILLER_61_548 VGND VGND VPWR VPWR sky130_fd_sc_hd__decap_3
XFILLER_14_475 VGND VGND VPWR VPWR sky130_fd_sc_hd__fill_1
XFILLER_53_94 VGND VGND VPWR VPWR sky130_fd_sc_hd__decap_3
XTAP_TAPCELL_ROW_24_470 VGND VPWR sky130_fd_sc_hd__tapvpwrvgnd_1
XFILLER_68_103 VGND VGND VPWR VPWR sky130_fd_sc_hd__decap_3
XFILLER_96_401 VGND VGND VPWR VPWR sky130_fd_sc_hd__decap_3
XFILLER_68_136 VGND VGND VPWR VPWR sky130_fd_sc_hd__decap_3
X_5090_ _4998_/A _4998_/B _4998_/C _4998_/D VGND VGND VPWR VPWR _5090_/X sky130_fd_sc_hd__a22o_2
X_4110_ _4111_/A _4111_/B _4225_/A VGND VGND VPWR VPWR _4139_/A sky130_fd_sc_hd__and3_2
XFILLER_96_445 VGND VGND VPWR VPWR sky130_fd_sc_hd__decap_3
XFILLER_56_309 VGND VGND VPWR VPWR sky130_fd_sc_hd__decap_3
XFILLER_68_147 VGND VGND VPWR VPWR sky130_fd_sc_hd__decap_3
XFILLER_68_158 VGND VGND VPWR VPWR sky130_fd_sc_hd__decap_3
X_4041_ _4036_/A _4036_/B _4036_/C VGND VGND VPWR VPWR _4042_/B sky130_fd_sc_hd__o21ai_2
XFILLER_83_128 VGND VGND VPWR VPWR sky130_fd_sc_hd__decap_3
XFILLER_37_545 VGND VGND VPWR VPWR sky130_fd_sc_hd__decap_3
XFILLER_37_567 VGND VGND VPWR VPWR sky130_fd_sc_hd__decap_3
XFILLER_64_342 VGND VGND VPWR VPWR sky130_fd_sc_hd__decap_3
XFILLER_76_191 VGND VGND VPWR VPWR sky130_fd_sc_hd__decap_3
XFILLER_52_504 VGND VGND VPWR VPWR sky130_fd_sc_hd__decap_3
XFILLER_64_386 VGND VGND VPWR VPWR sky130_fd_sc_hd__decap_3
X_5992_ _5992_/A _5992_/B VGND VGND VPWR VPWR _5997_/A sky130_fd_sc_hd__nand2_2
X_4943_ _4942_/A _4942_/C _5030_/A VGND VGND VPWR VPWR _4998_/B sky130_fd_sc_hd__a21o_2
XFILLER_20_412 VGND VGND VPWR VPWR sky130_fd_sc_hd__fill_1
XFILLER_60_570 VGND VGND VPWR VPWR sky130_fd_sc_hd__decap_3
XFILLER_60_592 VGND VGND VPWR VPWR sky130_fd_sc_hd__decap_3
X_6613_ _6597_/X _6598_/Y _6600_/Y _6612_/X VGND VGND VPWR VPWR _6987_/A sky130_fd_sc_hd__a211o_2
X_4874_ _4871_/A _4872_/Y _4828_/A _4830_/B VGND VGND VPWR VPWR _4876_/D sky130_fd_sc_hd__o211ai_2
XTAP_TAPCELL_ROW_50_738 VGND VPWR sky130_fd_sc_hd__tapvpwrvgnd_1
XFILLER_32_294 VGND VGND VPWR VPWR sky130_fd_sc_hd__fill_1
X_3825_ _6025_/B _6024_/B _3933_/B _3933_/D VGND VGND VPWR VPWR _3938_/A sky130_fd_sc_hd__and4_2
XFILLER_20_489 VGND VGND VPWR VPWR sky130_fd_sc_hd__decap_3
X_6544_ _6339_/Y _6542_/X _6543_/X VGND VGND VPWR VPWR _6544_/X sky130_fd_sc_hd__o21ba_2
X_3756_ _4282_/A _4406_/C _4406_/D _4165_/A VGND VGND VPWR VPWR _3757_/D sky130_fd_sc_hd__a22o_2
X_6475_ _6569_/B _6474_/X _5777_/Y _6474_/S VGND VGND VPWR VPWR _6476_/A sky130_fd_sc_hd__o2bb2a_2
X_5426_ _5428_/A _5428_/B _5428_/C VGND VGND VPWR VPWR _5426_/Y sky130_fd_sc_hd__a21oi_2
X_3687_ _3757_/A _4406_/C _4406_/D _6083_/B VGND VGND VPWR VPWR _3688_/D sky130_fd_sc_hd__a22o_2
X_5357_ _5320_/Y _5393_/B _5355_/Y _5356_/X VGND VGND VPWR VPWR _5377_/A sky130_fd_sc_hd__o211ai_2
XFILLER_99_250 VGND VGND VPWR VPWR sky130_fd_sc_hd__decap_3
XFILLER_58_39 VGND VGND VPWR VPWR sky130_fd_sc_hd__fill_2
XFILLER_87_423 VGND VGND VPWR VPWR sky130_fd_sc_hd__decap_3
X_5288_ _5288_/A _5288_/B VGND VGND VPWR VPWR _5431_/B sky130_fd_sc_hd__and2_4
X_4308_ _4309_/A _4309_/B _4309_/C VGND VGND VPWR VPWR _4308_/X sky130_fd_sc_hd__and3_2
XFILLER_59_169 VGND VGND VPWR VPWR sky130_fd_sc_hd__decap_3
X_4239_ _4483_/A _4361_/C _4361_/D _4362_/A VGND VGND VPWR VPWR _4240_/D sky130_fd_sc_hd__a22o_2
XFILLER_74_117 VGND VGND VPWR VPWR sky130_fd_sc_hd__decap_3
XFILLER_74_139 VGND VGND VPWR VPWR sky130_fd_sc_hd__fill_1
XTAP_TAPCELL_ROW_58_827 VGND VPWR sky130_fd_sc_hd__tapvpwrvgnd_1
XFILLER_15_206 VGND VGND VPWR VPWR sky130_fd_sc_hd__decap_3
XFILLER_28_589 VGND VGND VPWR VPWR sky130_fd_sc_hd__decap_3
XFILLER_55_375 VGND VGND VPWR VPWR sky130_fd_sc_hd__decap_3
XFILLER_82_161 VGND VGND VPWR VPWR sky130_fd_sc_hd__decap_3
XFILLER_70_323 VGND VGND VPWR VPWR sky130_fd_sc_hd__decap_3
XFILLER_82_194 VGND VGND VPWR VPWR sky130_fd_sc_hd__fill_2
XFILLER_23_20 VGND VGND VPWR VPWR sky130_fd_sc_hd__fill_1
XFILLER_23_261 VGND VGND VPWR VPWR sky130_fd_sc_hd__decap_3
XFILLER_51_570 VGND VGND VPWR VPWR sky130_fd_sc_hd__decap_3
XFILLER_11_434 VGND VGND VPWR VPWR sky130_fd_sc_hd__decap_3
XFILLER_23_53 VGND VGND VPWR VPWR sky130_fd_sc_hd__decap_3
XFILLER_7_416 VGND VGND VPWR VPWR sky130_fd_sc_hd__decap_3
XFILLER_7_449 VGND VGND VPWR VPWR sky130_fd_sc_hd__decap_3
XTAP_TAPCELL_ROW_21_440 VGND VPWR sky130_fd_sc_hd__tapvpwrvgnd_1
XTAP_TAPCELL_ROW_94_1203 VGND VPWR sky130_fd_sc_hd__tapvpwrvgnd_1
XFILLER_2_132 VGND VGND VPWR VPWR sky130_fd_sc_hd__decap_3
XFILLER_78_412 VGND VGND VPWR VPWR sky130_fd_sc_hd__decap_3
XFILLER_78_445 VGND VGND VPWR VPWR sky130_fd_sc_hd__decap_3
XFILLER_38_309 VGND VGND VPWR VPWR sky130_fd_sc_hd__decap_3
XFILLER_17_9 VGND VGND VPWR VPWR sky130_fd_sc_hd__fill_1
XFILLER_48_72 VGND VGND VPWR VPWR sky130_fd_sc_hd__decap_3
XFILLER_48_94 VGND VGND VPWR VPWR sky130_fd_sc_hd__decap_3
XFILLER_65_128 VGND VGND VPWR VPWR sky130_fd_sc_hd__decap_3
Xfanout491 _4362_/A VGND VGND VPWR VPWR _3639_/A sky130_fd_sc_hd__clkbuf_2
XFILLER_93_437 VGND VGND VPWR VPWR sky130_fd_sc_hd__decap_3
XFILLER_93_426 VGND VGND VPWR VPWR sky130_fd_sc_hd__decap_3
XFILLER_0_24 VGND VGND VPWR VPWR sky130_fd_sc_hd__decap_3
XFILLER_46_375 VGND VGND VPWR VPWR sky130_fd_sc_hd__decap_3
XFILLER_73_150 VGND VGND VPWR VPWR sky130_fd_sc_hd__decap_3
XFILLER_64_82 VGND VGND VPWR VPWR sky130_fd_sc_hd__fill_2
XFILLER_73_172 VGND VGND VPWR VPWR sky130_fd_sc_hd__decap_3
XFILLER_61_378 VGND VGND VPWR VPWR sky130_fd_sc_hd__decap_3
XFILLER_14_250 VGND VGND VPWR VPWR sky130_fd_sc_hd__fill_2
XFILLER_80_81 VGND VGND VPWR VPWR sky130_fd_sc_hd__decap_3
X_4590_ _4590_/A _4590_/B VGND VGND VPWR VPWR _4867_/B sky130_fd_sc_hd__xor2_2
X_3610_ _3605_/A _3605_/C _3605_/B VGND VGND VPWR VPWR _3611_/C sky130_fd_sc_hd__a21o_2
X_3541_ _3542_/A _3540_/Y _3990_/A _6077_/A VGND VGND VPWR VPWR _4090_/A sky130_fd_sc_hd__and4bb_2
X_6260_ _6266_/C _6260_/B VGND VGND VPWR VPWR _6851_/B sky130_fd_sc_hd__or2_2
XFILLER_88_209 VGND VGND VPWR VPWR sky130_fd_sc_hd__decap_3
X_6191_ _6172_/A _6172_/B _6190_/X VGND VGND VPWR VPWR _6191_/X sky130_fd_sc_hd__a21o_2
X_5211_ _5211_/A _5313_/B _5212_/A _5211_/D VGND VGND VPWR VPWR _5349_/A sky130_fd_sc_hd__nand4_2
XFILLER_69_412 VGND VGND VPWR VPWR sky130_fd_sc_hd__decap_3
X_5142_ _5142_/A _5142_/B _5142_/C VGND VGND VPWR VPWR _5200_/A sky130_fd_sc_hd__nand3_2
XFILLER_96_231 VGND VGND VPWR VPWR sky130_fd_sc_hd__decap_3
X_5073_ _5075_/A _5075_/B VGND VGND VPWR VPWR _5073_/X sky130_fd_sc_hd__and2b_2
XFILLER_96_297 VGND VGND VPWR VPWR sky130_fd_sc_hd__decap_3
XFILLER_56_139 VGND VGND VPWR VPWR sky130_fd_sc_hd__fill_1
XFILLER_84_448 VGND VGND VPWR VPWR sky130_fd_sc_hd__decap_3
X_4024_ _4024_/A _4024_/B VGND VGND VPWR VPWR _4030_/B sky130_fd_sc_hd__xnor2_2
XFILLER_25_526 VGND VGND VPWR VPWR sky130_fd_sc_hd__decap_3
XFILLER_37_386 VGND VGND VPWR VPWR sky130_fd_sc_hd__decap_3
X_5975_ _5976_/A _3977_/A _5976_/C _5976_/D VGND VGND VPWR VPWR _5977_/A sky130_fd_sc_hd__a22o_2
XTAP_TAPCELL_ROW_63_874 VGND VPWR sky130_fd_sc_hd__tapvpwrvgnd_1
XFILLER_33_570 VGND VGND VPWR VPWR sky130_fd_sc_hd__decap_3
XFILLER_40_529 VGND VGND VPWR VPWR sky130_fd_sc_hd__decap_3
X_4926_ _5382_/A _5018_/B VGND VGND VPWR VPWR _5020_/A sky130_fd_sc_hd__nand2_2
XTAP_TAPCELL_ROW_35_587 VGND VPWR sky130_fd_sc_hd__tapvpwrvgnd_1
X_4857_ _4615_/A _4614_/B _4612_/X VGND VGND VPWR VPWR _4859_/B sky130_fd_sc_hd__a21o_2
XFILLER_20_253 VGND VGND VPWR VPWR sky130_fd_sc_hd__decap_3
X_3808_ _3808_/A _3808_/B VGND VGND VPWR VPWR _4048_/C sky130_fd_sc_hd__xor2_2
X_6527_ _6373_/A _6527_/A2 _6354_/C _6526_/X VGND VGND VPWR VPWR _6528_/B sky130_fd_sc_hd__a31o_2
X_4788_ _5162_/A _4785_/B _4787_/B _4784_/X VGND VGND VPWR VPWR _4790_/B sky130_fd_sc_hd__a31oi_2
X_3739_ _4659_/A _4518_/A _4387_/C _4387_/D VGND VGND VPWR VPWR _3742_/A sky130_fd_sc_hd__nand4_2
X_6458_ _6527_/A2 _6569_/B _6569_/C _6457_/X VGND VGND VPWR VPWR _6458_/X sky130_fd_sc_hd__a31o_2
X_6389_ _6897_/S _6625_/B VGND VGND VPWR VPWR _6731_/B sky130_fd_sc_hd__nor2_2
X_5409_ _5409_/A _5409_/B _5410_/A VGND VGND VPWR VPWR _5409_/X sky130_fd_sc_hd__or3_2
XFILLER_87_242 VGND VGND VPWR VPWR sky130_fd_sc_hd__decap_3
XFILLER_85_37 VGND VGND VPWR VPWR sky130_fd_sc_hd__fill_1
XFILLER_28_331 VGND VGND VPWR VPWR sky130_fd_sc_hd__decap_3
XFILLER_18_75 VGND VGND VPWR VPWR sky130_fd_sc_hd__decap_3
XFILLER_90_429 VGND VGND VPWR VPWR sky130_fd_sc_hd__decap_3
XFILLER_28_397 VGND VGND VPWR VPWR sky130_fd_sc_hd__decap_3
XFILLER_43_334 VGND VGND VPWR VPWR sky130_fd_sc_hd__fill_2
XFILLER_55_172 VGND VGND VPWR VPWR sky130_fd_sc_hd__decap_3
XFILLER_70_153 VGND VGND VPWR VPWR sky130_fd_sc_hd__decap_3
XFILLER_31_529 VGND VGND VPWR VPWR sky130_fd_sc_hd__decap_3
XFILLER_43_389 VGND VGND VPWR VPWR sky130_fd_sc_hd__decap_3
XFILLER_70_186 VGND VGND VPWR VPWR sky130_fd_sc_hd__decap_3
XFILLER_24_592 VGND VGND VPWR VPWR sky130_fd_sc_hd__decap_3
XFILLER_34_85 VGND VGND VPWR VPWR sky130_fd_sc_hd__decap_3
XFILLER_70_197 VGND VGND VPWR VPWR sky130_fd_sc_hd__decap_3
XFILLER_7_213 VGND VGND VPWR VPWR sky130_fd_sc_hd__decap_3
XFILLER_7_246 VGND VGND VPWR VPWR sky130_fd_sc_hd__decap_3
Xwire144 _6331_/B VGND VGND VPWR VPWR _6809_/B sky130_fd_sc_hd__clkbuf_4
XFILLER_59_71 VGND VGND VPWR VPWR sky130_fd_sc_hd__decap_3
XFILLER_78_242 VGND VGND VPWR VPWR sky130_fd_sc_hd__decap_3
XFILLER_78_253 VGND VGND VPWR VPWR sky130_fd_sc_hd__fill_1
XFILLER_66_404 VGND VGND VPWR VPWR sky130_fd_sc_hd__decap_3
XFILLER_66_437 VGND VGND VPWR VPWR sky130_fd_sc_hd__decap_3
XFILLER_78_264 VGND VGND VPWR VPWR sky130_fd_sc_hd__decap_3
XFILLER_78_297 VGND VGND VPWR VPWR sky130_fd_sc_hd__decap_3
XFILLER_93_234 VGND VGND VPWR VPWR sky130_fd_sc_hd__fill_1
XFILLER_81_407 VGND VGND VPWR VPWR sky130_fd_sc_hd__decap_3
XFILLER_93_278 VGND VGND VPWR VPWR sky130_fd_sc_hd__fill_2
XFILLER_34_334 VGND VGND VPWR VPWR sky130_fd_sc_hd__decap_3
XFILLER_34_356 VGND VGND VPWR VPWR sky130_fd_sc_hd__decap_3
XFILLER_61_164 VGND VGND VPWR VPWR sky130_fd_sc_hd__decap_3
XFILLER_61_175 VGND VGND VPWR VPWR sky130_fd_sc_hd__fill_1
X_5760_ _5760_/A _5760_/B VGND VGND VPWR VPWR _5772_/A sky130_fd_sc_hd__xor2_2
XFILLER_98_3 VGND VGND VPWR VPWR sky130_fd_sc_hd__fill_2
XFILLER_61_197 VGND VGND VPWR VPWR sky130_fd_sc_hd__decap_3
X_5691_ _5680_/A _6116_/B _5576_/D _5695_/A VGND VGND VPWR VPWR _5692_/B sky130_fd_sc_hd__a22oi_2
X_4711_ _4692_/X _4710_/Y _4678_/X _4684_/Y VGND VGND VPWR VPWR _4713_/B sky130_fd_sc_hd__o211ai_2
XTAP_TAPCELL_ROW_60_844 VGND VPWR sky130_fd_sc_hd__tapvpwrvgnd_1
XTAP_TAPCELL_ROW_32_557 VGND VPWR sky130_fd_sc_hd__tapvpwrvgnd_1
X_4642_ _4642_/A _4642_/B _4642_/C VGND VGND VPWR VPWR _4643_/B sky130_fd_sc_hd__and3_2
XFILLER_30_584 VGND VGND VPWR VPWR sky130_fd_sc_hd__decap_3
X_4573_ _4570_/X _4573_/B VGND VGND VPWR VPWR _4578_/B sky130_fd_sc_hd__and2b_2
X_6312_ _6731_/A _6354_/C VGND VGND VPWR VPWR _6589_/C sky130_fd_sc_hd__nand2_2
X_3524_ _3525_/A _3523_/Y _4432_/A _6924_/S VGND VGND VPWR VPWR _3769_/A sky130_fd_sc_hd__and4bb_2
X_6243_ _6102_/A _3493_/Y _6242_/Y VGND VGND VPWR VPWR _6707_/B sky130_fd_sc_hd__a21oi_2
XFILLER_69_231 VGND VGND VPWR VPWR sky130_fd_sc_hd__decap_3
X_6174_ _6175_/A _6175_/B VGND VGND VPWR VPWR _6174_/Y sky130_fd_sc_hd__nor2_2
XFILLER_69_264 VGND VGND VPWR VPWR sky130_fd_sc_hd__decap_3
X_5125_ _5059_/B _5059_/A _5059_/C VGND VGND VPWR VPWR _5126_/A sky130_fd_sc_hd__a21o_4
XFILLER_84_245 VGND VGND VPWR VPWR sky130_fd_sc_hd__decap_3
X_5056_ _5056_/A _5056_/B _5056_/C VGND VGND VPWR VPWR _5133_/A sky130_fd_sc_hd__or3_4
XTAP_TAPCELL_ROW_68_933 VGND VPWR sky130_fd_sc_hd__tapvpwrvgnd_1
XFILLER_72_407 VGND VGND VPWR VPWR sky130_fd_sc_hd__decap_3
XFILLER_84_256 VGND VGND VPWR VPWR sky130_fd_sc_hd__decap_3
X_4007_ _4007_/A _4016_/B VGND VGND VPWR VPWR _4024_/B sky130_fd_sc_hd__nor2_2
XFILLER_65_470 VGND VGND VPWR VPWR sky130_fd_sc_hd__decap_3
XPHY_EDGE_ROW_9_Left_110 VGND VGND VPWR VPWR sky130_fd_sc_hd__decap_3
XFILLER_25_367 VGND VGND VPWR VPWR sky130_fd_sc_hd__decap_3
XFILLER_52_153 VGND VGND VPWR VPWR sky130_fd_sc_hd__decap_3
XFILLER_80_462 VGND VGND VPWR VPWR sky130_fd_sc_hd__decap_3
XFILLER_40_315 VGND VGND VPWR VPWR sky130_fd_sc_hd__decap_3
XFILLER_52_175 VGND VGND VPWR VPWR sky130_fd_sc_hd__fill_2
X_5958_ _6313_/A _6175_/B _6313_/B _6205_/A VGND VGND VPWR VPWR _5959_/D sky130_fd_sc_hd__nand4_2
XFILLER_40_348 VGND VGND VPWR VPWR sky130_fd_sc_hd__decap_3
XFILLER_52_197 VGND VGND VPWR VPWR sky130_fd_sc_hd__decap_3
X_4909_ _4868_/A _4870_/B _4906_/Y _4908_/X VGND VGND VPWR VPWR _4911_/C sky130_fd_sc_hd__a211o_2
X_5889_ _5888_/B _5891_/C1 _5890_/B1 _5883_/Y VGND VGND VPWR VPWR _5889_/X sky130_fd_sc_hd__o211a_2
XFILLER_21_595 VGND VGND VPWR VPWR sky130_fd_sc_hd__decap_3
XTAP_TAPCELL_ROW_78_1039 VGND VPWR sky130_fd_sc_hd__tapvpwrvgnd_1
XFILLER_4_249 VGND VGND VPWR VPWR sky130_fd_sc_hd__decap_3
XFILLER_20_54 VGND VGND VPWR VPWR sky130_fd_sc_hd__decap_3
XFILLER_20_76 VGND VGND VPWR VPWR sky130_fd_sc_hd__fill_2
XFILLER_0_433 VGND VGND VPWR VPWR sky130_fd_sc_hd__fill_1
XFILLER_0_444 VGND VGND VPWR VPWR sky130_fd_sc_hd__decap_3
XFILLER_0_455 VGND VGND VPWR VPWR sky130_fd_sc_hd__decap_3
XFILLER_88_551 VGND VGND VPWR VPWR sky130_fd_sc_hd__decap_3
XFILLER_96_47 VGND VGND VPWR VPWR sky130_fd_sc_hd__fill_2
XFILLER_0_488 VGND VGND VPWR VPWR sky130_fd_sc_hd__decap_3
XFILLER_48_415 VGND VGND VPWR VPWR sky130_fd_sc_hd__decap_3
XFILLER_75_212 VGND VGND VPWR VPWR sky130_fd_sc_hd__fill_1
XFILLER_88_573 VGND VGND VPWR VPWR sky130_fd_sc_hd__fill_1
XFILLER_88_595 VGND VGND VPWR VPWR sky130_fd_sc_hd__decap_3
XFILLER_29_74 VGND VGND VPWR VPWR sky130_fd_sc_hd__decap_3
XFILLER_48_448 VGND VGND VPWR VPWR sky130_fd_sc_hd__decap_3
XFILLER_75_267 VGND VGND VPWR VPWR sky130_fd_sc_hd__decap_3
XFILLER_16_323 VGND VGND VPWR VPWR sky130_fd_sc_hd__decap_3
XFILLER_90_215 VGND VGND VPWR VPWR sky130_fd_sc_hd__decap_3
XFILLER_16_356 VGND VGND VPWR VPWR sky130_fd_sc_hd__decap_3
XFILLER_28_194 VGND VGND VPWR VPWR sky130_fd_sc_hd__fill_2
XFILLER_45_73 VGND VGND VPWR VPWR sky130_fd_sc_hd__decap_3
XFILLER_90_259 VGND VGND VPWR VPWR sky130_fd_sc_hd__decap_3
XFILLER_31_315 VGND VGND VPWR VPWR sky130_fd_sc_hd__decap_3
XFILLER_43_153 VGND VGND VPWR VPWR sky130_fd_sc_hd__fill_2
XFILLER_31_337 VGND VGND VPWR VPWR sky130_fd_sc_hd__fill_1
XFILLER_12_573 VGND VGND VPWR VPWR sky130_fd_sc_hd__decap_3
XFILLER_84_9 VGND VGND VPWR VPWR sky130_fd_sc_hd__fill_2
XFILLER_8_533 VGND VGND VPWR VPWR sky130_fd_sc_hd__decap_3
XFILLER_8_544 VGND VGND VPWR VPWR sky130_fd_sc_hd__decap_3
XANTENNA_5 input30/X VGND VGND VPWR VPWR sky130_fd_sc_hd__diode_2
XFILLER_6_67 VGND VGND VPWR VPWR sky130_fd_sc_hd__decap_3
XFILLER_98_315 VGND VGND VPWR VPWR sky130_fd_sc_hd__decap_3
XFILLER_100_309 VGND VGND VPWR VPWR sky130_fd_sc_hd__decap_3
XFILLER_39_404 VGND VGND VPWR VPWR sky130_fd_sc_hd__fill_2
XFILLER_13_3 VGND VGND VPWR VPWR sky130_fd_sc_hd__decap_3
XFILLER_66_212 VGND VGND VPWR VPWR sky130_fd_sc_hd__fill_2
XFILLER_86_80 VGND VGND VPWR VPWR sky130_fd_sc_hd__decap_3
XFILLER_86_91 VGND VGND VPWR VPWR sky130_fd_sc_hd__decap_3
XFILLER_66_256 VGND VGND VPWR VPWR sky130_fd_sc_hd__fill_1
XFILLER_66_267 VGND VGND VPWR VPWR sky130_fd_sc_hd__decap_3
XFILLER_66_278 VGND VGND VPWR VPWR sky130_fd_sc_hd__decap_3
XTAP_TAPCELL_ROW_65_903 VGND VPWR sky130_fd_sc_hd__tapvpwrvgnd_1
XTAP_TAPCELL_ROW_37_605 VGND VPWR sky130_fd_sc_hd__tapvpwrvgnd_1
XFILLER_19_161 VGND VGND VPWR VPWR sky130_fd_sc_hd__decap_3
XFILLER_81_237 VGND VGND VPWR VPWR sky130_fd_sc_hd__decap_3
X_6930_ _6930_/A _6930_/B _6930_/C _6926_/X VGND VGND VPWR VPWR _6934_/B sky130_fd_sc_hd__or4b_2
X_6861_ _6265_/Y _6852_/X _6860_/A VGND VGND VPWR VPWR _6861_/X sky130_fd_sc_hd__a21bo_2
XFILLER_22_304 VGND VGND VPWR VPWR sky130_fd_sc_hd__decap_3
XFILLER_22_315 VGND VGND VPWR VPWR sky130_fd_sc_hd__fill_2
X_6792_ _5843_/X _5874_/B _6776_/X _6777_/A VGND VGND VPWR VPWR _6792_/X sky130_fd_sc_hd__a31o_2
X_5812_ _5754_/B _6597_/B _5752_/X VGND VGND VPWR VPWR _5812_/X sky130_fd_sc_hd__a21o_2
XTAP_TAPCELL_ROW_73_980 VGND VPWR sky130_fd_sc_hd__tapvpwrvgnd_1
X_5743_ _5743_/A _5743_/B _5743_/C VGND VGND VPWR VPWR _5752_/A sky130_fd_sc_hd__or3_4
XTAP_TAPCELL_ROW_45_693 VGND VPWR sky130_fd_sc_hd__tapvpwrvgnd_1
XTAP_TAPCELL_ROW_17_395 VGND VPWR sky130_fd_sc_hd__tapvpwrvgnd_1
X_5674_ _5674_/A _5674_/B VGND VGND VPWR VPWR _5675_/A sky130_fd_sc_hd__nor2_4
X_4625_ _4625_/A _4625_/B _4625_/C VGND VGND VPWR VPWR _4627_/A sky130_fd_sc_hd__and3_2
X_4556_ _4501_/X _4502_/Y _4554_/A _4554_/Y VGND VGND VPWR VPWR _4558_/C sky130_fd_sc_hd__o211a_2
X_3507_ _4432_/A _4290_/A _6929_/A _3869_/D VGND VGND VPWR VPWR _3507_/X sky130_fd_sc_hd__and4_2
XTAP_TAPCELL_ROW_9_308 VGND VPWR sky130_fd_sc_hd__tapvpwrvgnd_1
XFILLER_89_326 VGND VGND VPWR VPWR sky130_fd_sc_hd__fill_2
XFILLER_89_337 VGND VGND VPWR VPWR sky130_fd_sc_hd__fill_2
X_4487_ _4481_/A _4481_/C _4481_/B VGND VGND VPWR VPWR _4488_/C sky130_fd_sc_hd__a21o_2
X_6226_ _6219_/A _6608_/S _6381_/D _6223_/B _6225_/B VGND VGND VPWR VPWR _6227_/C
+ sky130_fd_sc_hd__a221o_2
X_6157_ _3597_/A _6151_/Y _6156_/X _6153_/A VGND VGND VPWR VPWR _6157_/X sky130_fd_sc_hd__o211a_2
XFILLER_57_234 VGND VGND VPWR VPWR sky130_fd_sc_hd__decap_3
XFILLER_66_39 VGND VGND VPWR VPWR sky130_fd_sc_hd__decap_3
Xload_slew480 _3969_/C VGND VGND VPWR VPWR _3900_/A sky130_fd_sc_hd__buf_4
X_5108_ _5108_/A _5108_/B _5108_/C VGND VGND VPWR VPWR _5166_/A sky130_fd_sc_hd__or3_4
XFILLER_57_256 VGND VGND VPWR VPWR sky130_fd_sc_hd__decap_3
X_6088_ _6090_/A _6254_/B VGND VGND VPWR VPWR _6088_/X sky130_fd_sc_hd__and2_2
XFILLER_72_215 VGND VGND VPWR VPWR sky130_fd_sc_hd__decap_3
X_5039_ _5038_/A _5038_/C _5038_/B VGND VGND VPWR VPWR _5040_/B sky130_fd_sc_hd__a21o_2
XFILLER_72_259 VGND VGND VPWR VPWR sky130_fd_sc_hd__decap_3
XFILLER_82_38 VGND VGND VPWR VPWR sky130_fd_sc_hd__decap_3
XFILLER_40_123 VGND VGND VPWR VPWR sky130_fd_sc_hd__decap_3
XFILLER_80_281 VGND VGND VPWR VPWR sky130_fd_sc_hd__decap_3
XTAP_TAPCELL_ROW_84_1098 VGND VPWR sky130_fd_sc_hd__tapvpwrvgnd_1
XFILLER_15_76 VGND VGND VPWR VPWR sky130_fd_sc_hd__decap_3
XFILLER_9_308 VGND VGND VPWR VPWR sky130_fd_sc_hd__decap_3
Xrebuffer685 _5441_/Y VGND VGND VPWR VPWR _5517_/A1 sky130_fd_sc_hd__buf_2
Xrebuffer674 _6705_/B1 VGND VGND VPWR VPWR _6723_/A2 sky130_fd_sc_hd__buf_2
XFILLER_5_569 VGND VGND VPWR VPWR sky130_fd_sc_hd__fill_2
Xrebuffer696 _4834_/D VGND VGND VPWR VPWR _4879_/B1 sky130_fd_sc_hd__buf_2
Xoutput75 _6989_/A VGND VGND VPWR VPWR result[13] sky130_fd_sc_hd__dlymetal6s4s_1
XFILLER_0_263 VGND VGND VPWR VPWR sky130_fd_sc_hd__decap_3
Xoutput97 _6985_/D VGND VGND VPWR VPWR result[4] sky130_fd_sc_hd__clkbuf_2
Xoutput86 _6992_/B VGND VGND VPWR VPWR result[23] sky130_fd_sc_hd__dlymetal6s4s_1
XFILLER_0_296 VGND VGND VPWR VPWR sky130_fd_sc_hd__decap_3
XFILLER_76_521 VGND VGND VPWR VPWR sky130_fd_sc_hd__decap_3
XFILLER_36_418 VGND VGND VPWR VPWR sky130_fd_sc_hd__fill_2
XFILLER_48_245 VGND VGND VPWR VPWR sky130_fd_sc_hd__decap_3
XFILLER_76_576 VGND VGND VPWR VPWR sky130_fd_sc_hd__decap_3
XFILLER_48_289 VGND VGND VPWR VPWR sky130_fd_sc_hd__decap_3
XFILLER_63_215 VGND VGND VPWR VPWR sky130_fd_sc_hd__decap_3
XFILLER_63_237 VGND VGND VPWR VPWR sky130_fd_sc_hd__decap_3
XFILLER_56_94 VGND VGND VPWR VPWR sky130_fd_sc_hd__fill_2
XFILLER_16_164 VGND VGND VPWR VPWR sky130_fd_sc_hd__decap_3
XFILLER_44_484 VGND VGND VPWR VPWR sky130_fd_sc_hd__decap_3
XFILLER_71_270 VGND VGND VPWR VPWR sky130_fd_sc_hd__decap_3
XFILLER_71_281 VGND VGND VPWR VPWR sky130_fd_sc_hd__decap_3
XFILLER_31_167 VGND VGND VPWR VPWR sky130_fd_sc_hd__fill_1
XTAP_TAPCELL_ROW_70_950 VGND VPWR sky130_fd_sc_hd__tapvpwrvgnd_1
XTAP_TAPCELL_ROW_42_663 VGND VPWR sky130_fd_sc_hd__tapvpwrvgnd_1
XFILLER_82_6 VGND VGND VPWR VPWR sky130_fd_sc_hd__fill_2
XTAP_TAPCELL_ROW_14_365 VGND VPWR sky130_fd_sc_hd__tapvpwrvgnd_1
X_4410_ _4409_/A _4523_/A VGND VGND VPWR VPWR _4412_/B sky130_fd_sc_hd__nand2b_2
X_5390_ _5390_/A _5390_/B VGND VGND VPWR VPWR _5475_/B sky130_fd_sc_hd__xnor2_4
X_4341_ _4341_/A _4341_/B VGND VGND VPWR VPWR _4455_/B sky130_fd_sc_hd__xor2_2
Xfanout309 input55/X VGND VGND VPWR VPWR _6527_/A2 sky130_fd_sc_hd__buf_6
X_4272_ _4272_/A _4272_/B _4272_/C VGND VGND VPWR VPWR _4272_/X sky130_fd_sc_hd__and3_4
XFILLER_98_123 VGND VGND VPWR VPWR sky130_fd_sc_hd__fill_1
XFILLER_39_201 VGND VGND VPWR VPWR sky130_fd_sc_hd__fill_1
XFILLER_79_370 VGND VGND VPWR VPWR sky130_fd_sc_hd__decap_3
XFILLER_86_329 VGND VGND VPWR VPWR sky130_fd_sc_hd__decap_3
X_6011_ _6011_/A _6011_/B VGND VGND VPWR VPWR _6012_/B sky130_fd_sc_hd__xnor2_2
XFILLER_39_234 VGND VGND VPWR VPWR sky130_fd_sc_hd__decap_3
XFILLER_27_429 VGND VGND VPWR VPWR sky130_fd_sc_hd__decap_3
XFILLER_39_278 VGND VGND VPWR VPWR sky130_fd_sc_hd__fill_2
XFILLER_82_513 VGND VGND VPWR VPWR sky130_fd_sc_hd__decap_3
X_6913_ _6180_/A _6809_/B _6927_/B1 _6919_/B VGND VGND VPWR VPWR _6913_/X sky130_fd_sc_hd__o2bb2a_2
XFILLER_35_462 VGND VGND VPWR VPWR sky130_fd_sc_hd__decap_3
XFILLER_50_410 VGND VGND VPWR VPWR sky130_fd_sc_hd__decap_3
X_6844_ _6842_/A _6928_/B1 _6809_/B _6080_/B VGND VGND VPWR VPWR _6845_/A sky130_fd_sc_hd__a2bb2o_2
XPHY_EDGE_ROW_99_Left_200 VGND VGND VPWR VPWR sky130_fd_sc_hd__decap_3
XFILLER_22_156 VGND VGND VPWR VPWR sky130_fd_sc_hd__decap_3
X_6775_ _6775_/A _6775_/B _6775_/C VGND VGND VPWR VPWR _6777_/B sky130_fd_sc_hd__and3_2
X_3987_ _3913_/A _3913_/B _3906_/X VGND VGND VPWR VPWR _3988_/B sky130_fd_sc_hd__a21oi_2
XFILLER_10_318 VGND VGND VPWR VPWR sky130_fd_sc_hd__decap_3
X_5726_ _5763_/C _5726_/B _5726_/C VGND VGND VPWR VPWR _5726_/X sky130_fd_sc_hd__and3b_2
X_5657_ _5657_/A _5657_/B VGND VGND VPWR VPWR _5711_/A sky130_fd_sc_hd__or2_2
X_5588_ _5588_/A _5778_/C _5588_/C _5588_/D VGND VGND VPWR VPWR _5629_/A sky130_fd_sc_hd__nand4_2
X_4608_ _4608_/A _4608_/B VGND VGND VPWR VPWR _4610_/B sky130_fd_sc_hd__nand2_2
XTAP_TAPCELL_ROW_75_1009 VGND VPWR sky130_fd_sc_hd__tapvpwrvgnd_1
XFILLER_89_101 VGND VGND VPWR VPWR sky130_fd_sc_hd__decap_3
X_4539_ _4585_/A _4539_/B VGND VGND VPWR VPWR _4569_/A sky130_fd_sc_hd__nand2_2
XFILLER_77_329 VGND VGND VPWR VPWR sky130_fd_sc_hd__decap_3
XFILLER_89_167 VGND VGND VPWR VPWR sky130_fd_sc_hd__fill_1
X_6209_ _6209_/A _6255_/A _6795_/B _6758_/C VGND VGND VPWR VPWR _6386_/A sky130_fd_sc_hd__nand4_2
XFILLER_18_407 VGND VGND VPWR VPWR sky130_fd_sc_hd__decap_3
XFILLER_58_565 VGND VGND VPWR VPWR sky130_fd_sc_hd__fill_1
XFILLER_58_576 VGND VGND VPWR VPWR sky130_fd_sc_hd__decap_3
XFILLER_85_340 VGND VGND VPWR VPWR sky130_fd_sc_hd__decap_3
XFILLER_85_384 VGND VGND VPWR VPWR sky130_fd_sc_hd__decap_3
XTAP_TAPCELL_ROW_86_1116 VGND VPWR sky130_fd_sc_hd__tapvpwrvgnd_1
XFILLER_26_53 VGND VGND VPWR VPWR sky130_fd_sc_hd__decap_3
XFILLER_13_101 VGND VGND VPWR VPWR sky130_fd_sc_hd__decap_3
XFILLER_13_123 VGND VGND VPWR VPWR sky130_fd_sc_hd__decap_3
XFILLER_41_410 VGND VGND VPWR VPWR sky130_fd_sc_hd__decap_3
XFILLER_53_270 VGND VGND VPWR VPWR sky130_fd_sc_hd__decap_3
XFILLER_53_281 VGND VGND VPWR VPWR sky130_fd_sc_hd__fill_1
XFILLER_9_149 VGND VGND VPWR VPWR sky130_fd_sc_hd__fill_1
XTAP_TAPCELL_ROW_11_335 VGND VPWR sky130_fd_sc_hd__tapvpwrvgnd_1
XFILLER_5_300 VGND VGND VPWR VPWR sky130_fd_sc_hd__decap_3
XTAP_TAPCELL_ROW_97_1234 VGND VPWR sky130_fd_sc_hd__tapvpwrvgnd_1
XFILLER_1_561 VGND VGND VPWR VPWR sky130_fd_sc_hd__decap_3
XFILLER_3_79 VGND VGND VPWR VPWR sky130_fd_sc_hd__decap_3
XFILLER_95_148 VGND VGND VPWR VPWR sky130_fd_sc_hd__fill_1
XFILLER_67_82 VGND VGND VPWR VPWR sky130_fd_sc_hd__decap_3
XFILLER_64_513 VGND VGND VPWR VPWR sky130_fd_sc_hd__decap_3
XFILLER_91_321 VGND VGND VPWR VPWR sky130_fd_sc_hd__decap_3
XTAP_TAPCELL_ROW_47_711 VGND VPWR sky130_fd_sc_hd__tapvpwrvgnd_1
XTAP_TAPCELL_ROW_19_413 VGND VPWR sky130_fd_sc_hd__tapvpwrvgnd_1
XFILLER_91_343 VGND VGND VPWR VPWR sky130_fd_sc_hd__decap_3
XFILLER_83_81 VGND VGND VPWR VPWR sky130_fd_sc_hd__decap_3
XFILLER_83_92 VGND VGND VPWR VPWR sky130_fd_sc_hd__fill_2
X_4890_ _4889_/A _4889_/B _4889_/C VGND VGND VPWR VPWR _4891_/B sky130_fd_sc_hd__a21oi_2
X_3910_ _3972_/A _3977_/B _3909_/D _3977_/A VGND VGND VPWR VPWR _3911_/B sky130_fd_sc_hd__a22o_2
X_3841_ _3861_/B _3841_/B VGND VGND VPWR VPWR _3842_/C sky130_fd_sc_hd__or2_2
XFILLER_80_3 VGND VGND VPWR VPWR sky130_fd_sc_hd__decap_3
X_6560_ _5806_/B _6541_/Y _6544_/X _6559_/X VGND VGND VPWR VPWR _6561_/C sky130_fd_sc_hd__a211oi_2
X_3772_ _3773_/A _3771_/Y _4551_/A _4539_/B VGND VGND VPWR VPWR _4180_/A sky130_fd_sc_hd__and4bb_2
X_5511_ _5511_/A _5511_/B _5511_/C VGND VGND VPWR VPWR _5511_/X sky130_fd_sc_hd__or3_4
X_6491_ _6589_/A _6491_/B VGND VGND VPWR VPWR _6491_/X sky130_fd_sc_hd__and2_2
X_5442_ _5240_/A _5240_/C _5240_/B VGND VGND VPWR VPWR _5443_/B sky130_fd_sc_hd__a21o_2
X_5373_ _5373_/A _5373_/B VGND VGND VPWR VPWR _5375_/B sky130_fd_sc_hd__xnor2_2
X_4324_ _4324_/A VGND VGND VPWR VPWR _6969_/A sky130_fd_sc_hd__inv_2
XFILLER_59_307 VGND VGND VPWR VPWR sky130_fd_sc_hd__decap_3
Xfanout128 _6928_/B1 VGND VGND VPWR VPWR _6810_/B1 sky130_fd_sc_hd__clkdlybuf4s25_1
XFILLER_99_476 VGND VGND VPWR VPWR sky130_fd_sc_hd__decap_3
XFILLER_86_115 VGND VGND VPWR VPWR sky130_fd_sc_hd__decap_3
Xfanout139 _6978_/A2 VGND VGND VPWR VPWR _6891_/B1 sky130_fd_sc_hd__clkdlybuf4s25_1
X_4255_ _4224_/Y _4254_/Y _4139_/X _4207_/Y VGND VGND VPWR VPWR _4313_/A sky130_fd_sc_hd__o211ai_2
X_4186_ _4186_/A _4186_/B VGND VGND VPWR VPWR _4187_/C sky130_fd_sc_hd__xnor2_2
XFILLER_27_204 VGND VGND VPWR VPWR sky130_fd_sc_hd__decap_3
XFILLER_55_557 VGND VGND VPWR VPWR sky130_fd_sc_hd__decap_3
XFILLER_82_354 VGND VGND VPWR VPWR sky130_fd_sc_hd__fill_1
XFILLER_94_192 VGND VGND VPWR VPWR sky130_fd_sc_hd__decap_3
XFILLER_63_18 VGND VGND VPWR VPWR sky130_fd_sc_hd__fill_2
XFILLER_82_365 VGND VGND VPWR VPWR sky130_fd_sc_hd__decap_3
XFILLER_23_421 VGND VGND VPWR VPWR sky130_fd_sc_hd__decap_3
XFILLER_35_281 VGND VGND VPWR VPWR sky130_fd_sc_hd__decap_3
XFILLER_63_590 VGND VGND VPWR VPWR sky130_fd_sc_hd__decap_3
XFILLER_50_251 VGND VGND VPWR VPWR sky130_fd_sc_hd__fill_1
X_6827_ _3680_/A _6928_/A2 _6826_/X VGND VGND VPWR VPWR _6827_/Y sky130_fd_sc_hd__o21ai_2
XTAP_TAPCELL_ROW_53_769 VGND VPWR sky130_fd_sc_hd__tapvpwrvgnd_1
XFILLER_50_262 VGND VGND VPWR VPWR sky130_fd_sc_hd__decap_3
XTAP_TAPCELL_ROW_81_1068 VGND VPWR sky130_fd_sc_hd__tapvpwrvgnd_1
XFILLER_6_108 VGND VGND VPWR VPWR sky130_fd_sc_hd__decap_3
X_6758_ _6758_/A _6758_/B _6758_/C VGND VGND VPWR VPWR _6758_/Y sky130_fd_sc_hd__nand3_2
Xwire507 wire507/A VGND VGND VPWR VPWR _5995_/B sky130_fd_sc_hd__clkbuf_4
X_6689_ _3738_/Y _6146_/Y _6104_/X VGND VGND VPWR VPWR _6689_/Y sky130_fd_sc_hd__a21oi_2
X_5709_ _5710_/A _5748_/B _5710_/C VGND VGND VPWR VPWR _5709_/X sky130_fd_sc_hd__and3_2
XTAP_TAPCELL_ROW_92_1186 VGND VPWR sky130_fd_sc_hd__tapvpwrvgnd_1
Xfanout640 _5543_/A VGND VGND VPWR VPWR _5778_/A sky130_fd_sc_hd__dlymetal6s2s_1
Xfanout651 input11/X VGND VGND VPWR VPWR _3657_/C sky130_fd_sc_hd__clkdlybuf4s25_1
XFILLER_58_351 VGND VGND VPWR VPWR sky130_fd_sc_hd__decap_3
XFILLER_77_148 VGND VGND VPWR VPWR sky130_fd_sc_hd__fill_1
Xfanout662 fanout662/A VGND VGND VPWR VPWR _4925_/B sky130_fd_sc_hd__clkdlybuf4s25_1
XFILLER_100_470 VGND VGND VPWR VPWR sky130_fd_sc_hd__decap_3
XFILLER_46_502 VGND VGND VPWR VPWR sky130_fd_sc_hd__decap_3
XFILLER_100_492 VGND VGND VPWR VPWR sky130_fd_sc_hd__decap_3
XFILLER_18_259 VGND VGND VPWR VPWR sky130_fd_sc_hd__fill_2
XFILLER_46_557 VGND VGND VPWR VPWR sky130_fd_sc_hd__fill_2
XFILLER_73_321 VGND VGND VPWR VPWR sky130_fd_sc_hd__decap_3
XFILLER_85_181 VGND VGND VPWR VPWR sky130_fd_sc_hd__decap_3
XFILLER_61_505 VGND VGND VPWR VPWR sky130_fd_sc_hd__fill_2
XFILLER_73_376 VGND VGND VPWR VPWR sky130_fd_sc_hd__decap_3
XFILLER_14_454 VGND VGND VPWR VPWR sky130_fd_sc_hd__decap_3
XFILLER_53_51 VGND VGND VPWR VPWR sky130_fd_sc_hd__decap_3
XFILLER_41_284 VGND VGND VPWR VPWR sky130_fd_sc_hd__decap_3
XTAP_TAPCELL_ROW_24_471 VGND VPWR sky130_fd_sc_hd__tapvpwrvgnd_1
XFILLER_45_6 VGND VGND VPWR VPWR sky130_fd_sc_hd__decap_3
XFILLER_78_70 VGND VGND VPWR VPWR sky130_fd_sc_hd__decap_3
XFILLER_49_340 VGND VGND VPWR VPWR sky130_fd_sc_hd__decap_3
X_4040_ _4040_/A _4040_/B VGND VGND VPWR VPWR _4059_/A sky130_fd_sc_hd__xnor2_2
XFILLER_49_373 VGND VGND VPWR VPWR sky130_fd_sc_hd__decap_3
XFILLER_37_557 VGND VGND VPWR VPWR sky130_fd_sc_hd__decap_3
XFILLER_64_321 VGND VGND VPWR VPWR sky130_fd_sc_hd__decap_3
XFILLER_64_354 VGND VGND VPWR VPWR sky130_fd_sc_hd__decap_3
X_5991_ _3975_/A _3975_/B _3983_/A VGND VGND VPWR VPWR _6001_/A sky130_fd_sc_hd__a21o_2
XFILLER_17_281 VGND VGND VPWR VPWR sky130_fd_sc_hd__decap_3
XFILLER_64_398 VGND VGND VPWR VPWR sky130_fd_sc_hd__decap_3
X_4942_ _4942_/A _5030_/A _4942_/C VGND VGND VPWR VPWR _4998_/A sky130_fd_sc_hd__nand3_2
XFILLER_32_240 VGND VGND VPWR VPWR sky130_fd_sc_hd__decap_3
XFILLER_32_262 VGND VGND VPWR VPWR sky130_fd_sc_hd__decap_3
X_6612_ _6138_/B _6601_/Y _6611_/X VGND VGND VPWR VPWR _6612_/X sky130_fd_sc_hd__a21o_2
X_4873_ _4828_/A _4830_/B _4871_/A _4872_/Y VGND VGND VPWR VPWR _4876_/C sky130_fd_sc_hd__a211o_2
XTAP_TAPCELL_ROW_50_739 VGND VPWR sky130_fd_sc_hd__tapvpwrvgnd_1
XFILLER_20_435 VGND VGND VPWR VPWR sky130_fd_sc_hd__decap_3
X_3824_ _3824_/A _3824_/B _3824_/C VGND VGND VPWR VPWR _3842_/B sky130_fd_sc_hd__and3_2
X_6543_ _6131_/Y _6778_/B1 _6229_/X _6853_/A _6133_/Y VGND VGND VPWR VPWR _6543_/X
+ sky130_fd_sc_hd__o221a_2
X_3755_ _4282_/A _4165_/A _4406_/C _4406_/D VGND VGND VPWR VPWR _3758_/A sky130_fd_sc_hd__nand4_2
X_6474_ _6224_/A _6439_/A _6474_/S VGND VGND VPWR VPWR _6474_/X sky130_fd_sc_hd__mux2_1
X_3686_ _3707_/A VGND VGND VPWR VPWR _3688_/C sky130_fd_sc_hd__inv_2
X_5425_ _5425_/A _5425_/B VGND VGND VPWR VPWR _5428_/C sky130_fd_sc_hd__xnor2_2
XPHY_EDGE_ROW_18_Left_119 VGND VGND VPWR VPWR sky130_fd_sc_hd__decap_3
XPHY_EDGE_ROW_12_Right_12 VGND VGND VPWR VPWR sky130_fd_sc_hd__decap_3
XFILLER_58_18 VGND VGND VPWR VPWR sky130_fd_sc_hd__decap_3
XFILLER_58_29 VGND VGND VPWR VPWR sky130_fd_sc_hd__fill_2
XFILLER_87_402 VGND VGND VPWR VPWR sky130_fd_sc_hd__decap_3
X_5356_ _5355_/B _5355_/C _5355_/A VGND VGND VPWR VPWR _5356_/X sky130_fd_sc_hd__a21o_2
XFILLER_99_262 VGND VGND VPWR VPWR sky130_fd_sc_hd__decap_3
XFILLER_87_435 VGND VGND VPWR VPWR sky130_fd_sc_hd__decap_3
X_5287_ _5287_/A _5287_/B _5287_/C VGND VGND VPWR VPWR _5288_/B sky130_fd_sc_hd__or3_2
X_4307_ _4307_/A _4307_/B VGND VGND VPWR VPWR _4309_/C sky130_fd_sc_hd__xnor2_2
XFILLER_99_284 VGND VGND VPWR VPWR sky130_fd_sc_hd__fill_1
X_4238_ _4483_/A _4362_/A _4361_/C _4361_/D VGND VGND VPWR VPWR _4241_/A sky130_fd_sc_hd__nand4_2
XTAP_TAPCELL_ROW_58_828 VGND VPWR sky130_fd_sc_hd__tapvpwrvgnd_1
XFILLER_67_181 VGND VGND VPWR VPWR sky130_fd_sc_hd__decap_3
X_4169_ _4163_/A _4163_/C _4163_/B VGND VGND VPWR VPWR _4170_/C sky130_fd_sc_hd__a21o_2
XPHY_EDGE_ROW_27_Left_128 VGND VGND VPWR VPWR sky130_fd_sc_hd__decap_3
XFILLER_43_505 VGND VGND VPWR VPWR sky130_fd_sc_hd__decap_3
XFILLER_43_516 VGND VGND VPWR VPWR sky130_fd_sc_hd__decap_3
XFILLER_70_302 VGND VGND VPWR VPWR sky130_fd_sc_hd__decap_3
XPHY_EDGE_ROW_21_Right_21 VGND VGND VPWR VPWR sky130_fd_sc_hd__decap_3
XFILLER_15_218 VGND VGND VPWR VPWR sky130_fd_sc_hd__decap_3
XFILLER_43_549 VGND VGND VPWR VPWR sky130_fd_sc_hd__decap_3
XFILLER_55_387 VGND VGND VPWR VPWR sky130_fd_sc_hd__decap_3
XFILLER_82_173 VGND VGND VPWR VPWR sky130_fd_sc_hd__decap_3
XFILLER_23_240 VGND VGND VPWR VPWR sky130_fd_sc_hd__decap_3
XFILLER_70_379 VGND VGND VPWR VPWR sky130_fd_sc_hd__decap_3
XFILLER_11_402 VGND VGND VPWR VPWR sky130_fd_sc_hd__fill_1
XFILLER_23_273 VGND VGND VPWR VPWR sky130_fd_sc_hd__decap_3
XFILLER_11_446 VGND VGND VPWR VPWR sky130_fd_sc_hd__fill_2
XFILLER_23_284 VGND VGND VPWR VPWR sky130_fd_sc_hd__decap_3
XFILLER_11_479 VGND VGND VPWR VPWR sky130_fd_sc_hd__decap_3
XTAP_TAPCELL_ROW_21_441 VGND VPWR sky130_fd_sc_hd__tapvpwrvgnd_1
XTAP_TAPCELL_ROW_94_1204 VGND VPWR sky130_fd_sc_hd__tapvpwrvgnd_1
XPHY_EDGE_ROW_36_Left_137 VGND VGND VPWR VPWR sky130_fd_sc_hd__decap_3
XPHY_EDGE_ROW_30_Right_30 VGND VGND VPWR VPWR sky130_fd_sc_hd__decap_3
XFILLER_99_47 VGND VGND VPWR VPWR sky130_fd_sc_hd__decap_3
XFILLER_99_36 VGND VGND VPWR VPWR sky130_fd_sc_hd__fill_2
XFILLER_78_424 VGND VGND VPWR VPWR sky130_fd_sc_hd__decap_3
XFILLER_78_457 VGND VGND VPWR VPWR sky130_fd_sc_hd__decap_3
XFILLER_93_405 VGND VGND VPWR VPWR sky130_fd_sc_hd__decap_3
XFILLER_19_513 VGND VGND VPWR VPWR sky130_fd_sc_hd__decap_3
Xfanout470 fanout475/X VGND VGND VPWR VPWR wire471/A sky130_fd_sc_hd__dlymetal6s2s_1
Xfanout481 wire482/X VGND VGND VPWR VPWR _5981_/B sky130_fd_sc_hd__clkdlybuf4s25_1
XPHY_EDGE_ROW_45_Left_146 VGND VGND VPWR VPWR sky130_fd_sc_hd__decap_3
XFILLER_58_181 VGND VGND VPWR VPWR sky130_fd_sc_hd__fill_2
XFILLER_58_192 VGND VGND VPWR VPWR sky130_fd_sc_hd__decap_3
XFILLER_93_449 VGND VGND VPWR VPWR sky130_fd_sc_hd__decap_3
XFILLER_34_505 VGND VGND VPWR VPWR sky130_fd_sc_hd__decap_3
XFILLER_61_302 VGND VGND VPWR VPWR sky130_fd_sc_hd__fill_2
XFILLER_73_140 VGND VGND VPWR VPWR sky130_fd_sc_hd__fill_2
XFILLER_73_162 VGND VGND VPWR VPWR sky130_fd_sc_hd__decap_3
XFILLER_46_387 VGND VGND VPWR VPWR sky130_fd_sc_hd__decap_3
XFILLER_61_313 VGND VGND VPWR VPWR sky130_fd_sc_hd__decap_3
XFILLER_73_184 VGND VGND VPWR VPWR sky130_fd_sc_hd__decap_3
XFILLER_14_273 VGND VGND VPWR VPWR sky130_fd_sc_hd__decap_3
XFILLER_42_560 VGND VGND VPWR VPWR sky130_fd_sc_hd__fill_1
XPHY_EDGE_ROW_54_Left_155 VGND VGND VPWR VPWR sky130_fd_sc_hd__decap_3
X_3540_ _3996_/B _3961_/C _3961_/D _3955_/A VGND VGND VPWR VPWR _3540_/Y sky130_fd_sc_hd__a22oi_2
XFILLER_6_483 VGND VGND VPWR VPWR sky130_fd_sc_hd__decap_3
X_5210_ _5311_/B _5311_/C _5311_/D _5313_/A VGND VGND VPWR VPWR _5211_/D sky130_fd_sc_hd__a22o_2
X_6190_ _6931_/A _6904_/A _6190_/C _6890_/A VGND VGND VPWR VPWR _6190_/X sky130_fd_sc_hd__or4_2
X_5141_ _5133_/A _5133_/C _5133_/B VGND VGND VPWR VPWR _5142_/C sky130_fd_sc_hd__a21o_4
X_5072_ _5072_/A _5072_/B VGND VGND VPWR VPWR _5075_/B sky130_fd_sc_hd__xnor2_2
XPHY_EDGE_ROW_63_Left_164 VGND VGND VPWR VPWR sky130_fd_sc_hd__decap_3
XFILLER_96_243 VGND VGND VPWR VPWR sky130_fd_sc_hd__decap_3
XFILLER_84_427 VGND VGND VPWR VPWR sky130_fd_sc_hd__decap_3
X_4023_ _4023_/A _4023_/B VGND VGND VPWR VPWR _4030_/A sky130_fd_sc_hd__xnor2_2
XFILLER_96_276 VGND VGND VPWR VPWR sky130_fd_sc_hd__decap_3
XFILLER_37_310 VGND VGND VPWR VPWR sky130_fd_sc_hd__decap_3
XFILLER_49_181 VGND VGND VPWR VPWR sky130_fd_sc_hd__fill_1
XFILLER_25_505 VGND VGND VPWR VPWR sky130_fd_sc_hd__decap_3
XFILLER_25_549 VGND VGND VPWR VPWR sky130_fd_sc_hd__decap_3
XFILLER_64_173 VGND VGND VPWR VPWR sky130_fd_sc_hd__decap_3
X_5974_ _4018_/A _4020_/B _4018_/B VGND VGND VPWR VPWR _5988_/A sky130_fd_sc_hd__o21bai_2
XFILLER_100_26 VGND VGND VPWR VPWR sky130_fd_sc_hd__fill_2
X_4925_ _4925_/A _4925_/B _4925_/C _4925_/D VGND VGND VPWR VPWR _4925_/X sky130_fd_sc_hd__and4_2
XTAP_TAPCELL_ROW_63_875 VGND VPWR sky130_fd_sc_hd__tapvpwrvgnd_1
XTAP_TAPCELL_ROW_35_588 VGND VPWR sky130_fd_sc_hd__tapvpwrvgnd_1
XFILLER_20_232 VGND VGND VPWR VPWR sky130_fd_sc_hd__fill_1
XFILLER_60_390 VGND VGND VPWR VPWR sky130_fd_sc_hd__decap_3
X_4856_ _4855_/B _4855_/C _4854_/A VGND VGND VPWR VPWR _4876_/B sky130_fd_sc_hd__o21ai_2
XPHY_EDGE_ROW_72_Left_173 VGND VGND VPWR VPWR sky130_fd_sc_hd__decap_3
XFILLER_20_265 VGND VGND VPWR VPWR sky130_fd_sc_hd__fill_2
X_3807_ _3807_/A _3807_/B VGND VGND VPWR VPWR _3808_/B sky130_fd_sc_hd__or2_2
X_6526_ _6939_/S _6526_/B VGND VGND VPWR VPWR _6526_/X sky130_fd_sc_hd__and2_2
X_4787_ _4784_/X _4787_/B VGND VGND VPWR VPWR _4797_/B sky130_fd_sc_hd__and2b_2
X_3738_ _6144_/A _6144_/B VGND VGND VPWR VPWR _3738_/Y sky130_fd_sc_hd__nand2_2
X_6457_ _6569_/A _6457_/B VGND VGND VPWR VPWR _6457_/X sky130_fd_sc_hd__and2_2
X_3669_ _3661_/Y _3669_/B _3669_/C VGND VGND VPWR VPWR _3670_/B sky130_fd_sc_hd__and3b_2
X_6388_ _6388_/A _6388_/B _6388_/C VGND VGND VPWR VPWR _6388_/Y sky130_fd_sc_hd__nand3_2
X_5408_ _5407_/B _5407_/C _5407_/A VGND VGND VPWR VPWR _5410_/A sky130_fd_sc_hd__a21boi_2
XFILLER_87_210 VGND VGND VPWR VPWR sky130_fd_sc_hd__decap_3
X_5339_ _5321_/B _5290_/C _5304_/B _5300_/B VGND VGND VPWR VPWR _5345_/B sky130_fd_sc_hd__a22o_2
XPHY_EDGE_ROW_81_Left_182 VGND VGND VPWR VPWR sky130_fd_sc_hd__decap_3
XFILLER_87_232 VGND VGND VPWR VPWR sky130_fd_sc_hd__decap_3
XFILLER_75_416 VGND VGND VPWR VPWR sky130_fd_sc_hd__decap_3
XFILLER_85_49 VGND VGND VPWR VPWR sky130_fd_sc_hd__decap_3
XFILLER_18_32 VGND VGND VPWR VPWR sky130_fd_sc_hd__decap_3
XFILLER_28_321 VGND VGND VPWR VPWR sky130_fd_sc_hd__fill_2
XFILLER_87_298 VGND VGND VPWR VPWR sky130_fd_sc_hd__decap_3
XFILLER_55_151 VGND VGND VPWR VPWR sky130_fd_sc_hd__fill_2
XFILLER_55_184 VGND VGND VPWR VPWR sky130_fd_sc_hd__decap_3
XFILLER_83_482 VGND VGND VPWR VPWR sky130_fd_sc_hd__decap_3
XFILLER_31_508 VGND VGND VPWR VPWR sky130_fd_sc_hd__decap_3
XFILLER_70_121 VGND VGND VPWR VPWR sky130_fd_sc_hd__decap_3
XPHY_EDGE_ROW_90_Left_191 VGND VGND VPWR VPWR sky130_fd_sc_hd__decap_3
XFILLER_70_165 VGND VGND VPWR VPWR sky130_fd_sc_hd__decap_3
XFILLER_34_97 VGND VGND VPWR VPWR sky130_fd_sc_hd__decap_3
XFILLER_11_254 VGND VGND VPWR VPWR sky130_fd_sc_hd__decap_3
XFILLER_11_265 VGND VGND VPWR VPWR sky130_fd_sc_hd__decap_3
XFILLER_11_276 VGND VGND VPWR VPWR sky130_fd_sc_hd__decap_3
XFILLER_7_225 VGND VGND VPWR VPWR sky130_fd_sc_hd__fill_1
XFILLER_7_236 VGND VGND VPWR VPWR sky130_fd_sc_hd__fill_2
XFILLER_50_85 VGND VGND VPWR VPWR sky130_fd_sc_hd__decap_3
XFILLER_3_420 VGND VGND VPWR VPWR sky130_fd_sc_hd__fill_2
XFILLER_3_442 VGND VGND VPWR VPWR sky130_fd_sc_hd__decap_3
XFILLER_78_221 VGND VGND VPWR VPWR sky130_fd_sc_hd__decap_3
XFILLER_66_416 VGND VGND VPWR VPWR sky130_fd_sc_hd__decap_3
XFILLER_78_276 VGND VGND VPWR VPWR sky130_fd_sc_hd__decap_3
XFILLER_93_213 VGND VGND VPWR VPWR sky130_fd_sc_hd__decap_3
XTAP_TAPCELL_ROW_6_280 VGND VPWR sky130_fd_sc_hd__tapvpwrvgnd_1
XFILLER_19_321 VGND VGND VPWR VPWR sky130_fd_sc_hd__decap_3
XFILLER_66_449 VGND VGND VPWR VPWR sky130_fd_sc_hd__decap_3
XFILLER_19_354 VGND VGND VPWR VPWR sky130_fd_sc_hd__decap_3
XFILLER_93_257 VGND VGND VPWR VPWR sky130_fd_sc_hd__decap_3
XFILLER_19_387 VGND VGND VPWR VPWR sky130_fd_sc_hd__fill_2
XFILLER_46_173 VGND VGND VPWR VPWR sky130_fd_sc_hd__decap_3
XFILLER_74_482 VGND VGND VPWR VPWR sky130_fd_sc_hd__decap_3
XFILLER_34_368 VGND VGND VPWR VPWR sky130_fd_sc_hd__decap_3
XFILLER_46_195 VGND VGND VPWR VPWR sky130_fd_sc_hd__fill_1
XFILLER_61_121 VGND VGND VPWR VPWR sky130_fd_sc_hd__decap_3
XFILLER_22_519 VGND VGND VPWR VPWR sky130_fd_sc_hd__decap_3
XFILLER_61_154 VGND VGND VPWR VPWR sky130_fd_sc_hd__fill_1
X_5690_ _5690_/A _5690_/B VGND VGND VPWR VPWR _5720_/A sky130_fd_sc_hd__xor2_2
X_4710_ _4923_/A _4923_/B VGND VGND VPWR VPWR _4710_/Y sky130_fd_sc_hd__nor2_2
XTAP_TAPCELL_ROW_60_845 VGND VPWR sky130_fd_sc_hd__tapvpwrvgnd_1
XFILLER_30_574 VGND VGND VPWR VPWR sky130_fd_sc_hd__fill_1
X_4641_ _4642_/B _4642_/C _4642_/A VGND VGND VPWR VPWR _4641_/X sky130_fd_sc_hd__a21o_2
XTAP_TAPCELL_ROW_32_558 VGND VPWR sky130_fd_sc_hd__tapvpwrvgnd_1
X_4572_ _5162_/A _4978_/C _4978_/D _6248_/B VGND VGND VPWR VPWR _4573_/B sky130_fd_sc_hd__a22o_2
XFILLER_6_280 VGND VGND VPWR VPWR sky130_fd_sc_hd__decap_3
X_6311_ _6311_/A _6395_/S VGND VGND VPWR VPWR _6354_/C sky130_fd_sc_hd__nor2_2
X_3523_ _6263_/B _6929_/A _3869_/D _4551_/A VGND VGND VPWR VPWR _3523_/Y sky130_fd_sc_hd__a22oi_2
X_6242_ _6383_/A _6242_/B VGND VGND VPWR VPWR _6242_/Y sky130_fd_sc_hd__nor2_2
XFILLER_69_221 VGND VGND VPWR VPWR sky130_fd_sc_hd__decap_3
XFILLER_69_243 VGND VGND VPWR VPWR sky130_fd_sc_hd__decap_3
X_6173_ _6175_/A _6175_/B VGND VGND VPWR VPWR _6176_/A sky130_fd_sc_hd__nand2_2
XFILLER_69_276 VGND VGND VPWR VPWR sky130_fd_sc_hd__decap_3
XFILLER_69_287 VGND VGND VPWR VPWR sky130_fd_sc_hd__decap_3
Xload_slew673 input1/X VGND VGND VPWR VPWR _6006_/A sky130_fd_sc_hd__buf_2
X_5124_ _5122_/B _5238_/B _5120_/X VGND VGND VPWR VPWR _5126_/B sky130_fd_sc_hd__a21o_2
XFILLER_97_596 VGND VGND VPWR VPWR sky130_fd_sc_hd__fill_2
XFILLER_97_574 VGND VGND VPWR VPWR sky130_fd_sc_hd__fill_1
XFILLER_29_129 VGND VGND VPWR VPWR sky130_fd_sc_hd__decap_3
XFILLER_84_235 VGND VGND VPWR VPWR sky130_fd_sc_hd__decap_3
X_5055_ _5138_/B2 _5311_/C _5311_/D _5137_/A VGND VGND VPWR VPWR _5056_/C sky130_fd_sc_hd__a22oi_2
XTAP_TAPCELL_ROW_68_934 VGND VPWR sky130_fd_sc_hd__tapvpwrvgnd_1
XFILLER_37_140 VGND VGND VPWR VPWR sky130_fd_sc_hd__decap_3
XFILLER_37_151 VGND VGND VPWR VPWR sky130_fd_sc_hd__decap_3
XFILLER_72_419 VGND VGND VPWR VPWR sky130_fd_sc_hd__fill_1
XFILLER_84_268 VGND VGND VPWR VPWR sky130_fd_sc_hd__decap_3
X_4006_ _4006_/A _6008_/A _4006_/C VGND VGND VPWR VPWR _4016_/B sky130_fd_sc_hd__and3_2
XFILLER_65_482 VGND VGND VPWR VPWR sky130_fd_sc_hd__decap_3
XFILLER_25_346 VGND VGND VPWR VPWR sky130_fd_sc_hd__decap_3
XFILLER_80_430 VGND VGND VPWR VPWR sky130_fd_sc_hd__decap_3
XFILLER_92_290 VGND VGND VPWR VPWR sky130_fd_sc_hd__decap_3
XFILLER_80_474 VGND VGND VPWR VPWR sky130_fd_sc_hd__fill_2
X_5957_ _6392_/A _6175_/B _6313_/B _6205_/A VGND VGND VPWR VPWR _5959_/C sky130_fd_sc_hd__a22o_2
X_4908_ _4904_/A _4905_/Y _4848_/Y _4852_/B VGND VGND VPWR VPWR _4908_/X sky130_fd_sc_hd__o211a_2
X_5888_ _5888_/A _5888_/B _5888_/C _5888_/D VGND VGND VPWR VPWR _5888_/Y sky130_fd_sc_hd__nor4_4
X_4839_ _4489_/A _4488_/C _4488_/B VGND VGND VPWR VPWR _4841_/B sky130_fd_sc_hd__a21o_2
XFILLER_4_206 VGND VGND VPWR VPWR sky130_fd_sc_hd__decap_3
X_6509_ _6219_/A _6605_/A2 _6508_/X VGND VGND VPWR VPWR _6509_/Y sky130_fd_sc_hd__o21ai_2
XFILLER_0_467 VGND VGND VPWR VPWR sky130_fd_sc_hd__decap_3
XFILLER_48_427 VGND VGND VPWR VPWR sky130_fd_sc_hd__decap_3
XFILLER_88_585 VGND VGND VPWR VPWR sky130_fd_sc_hd__decap_3
XFILLER_29_86 VGND VGND VPWR VPWR sky130_fd_sc_hd__decap_3
XFILLER_75_235 VGND VGND VPWR VPWR sky130_fd_sc_hd__fill_1
XFILLER_75_246 VGND VGND VPWR VPWR sky130_fd_sc_hd__decap_3
XFILLER_75_279 VGND VGND VPWR VPWR sky130_fd_sc_hd__fill_1
XTAP_TAPCELL_ROW_89_1147 VGND VPWR sky130_fd_sc_hd__tapvpwrvgnd_1
XTAP_TAPCELL_ROW_3_250 VGND VPWR sky130_fd_sc_hd__tapvpwrvgnd_1
XFILLER_28_173 VGND VGND VPWR VPWR sky130_fd_sc_hd__decap_3
XFILLER_56_493 VGND VGND VPWR VPWR sky130_fd_sc_hd__decap_3
XFILLER_90_227 VGND VGND VPWR VPWR sky130_fd_sc_hd__decap_3
XFILLER_43_132 VGND VGND VPWR VPWR sky130_fd_sc_hd__decap_3
XFILLER_45_41 VGND VGND VPWR VPWR sky130_fd_sc_hd__fill_2
XFILLER_45_52 VGND VGND VPWR VPWR sky130_fd_sc_hd__decap_3
XFILLER_71_430 VGND VGND VPWR VPWR sky130_fd_sc_hd__decap_3
XFILLER_83_290 VGND VGND VPWR VPWR sky130_fd_sc_hd__decap_3
XFILLER_90_249 VGND VGND VPWR VPWR sky130_fd_sc_hd__decap_3
XFILLER_12_552 VGND VGND VPWR VPWR sky130_fd_sc_hd__decap_3
XFILLER_61_51 VGND VGND VPWR VPWR sky130_fd_sc_hd__decap_3
XFILLER_61_84 VGND VGND VPWR VPWR sky130_fd_sc_hd__decap_3
XFILLER_77_9 VGND VGND VPWR VPWR sky130_fd_sc_hd__decap_3
XFILLER_6_24 VGND VGND VPWR VPWR sky130_fd_sc_hd__decap_3
XFILLER_8_556 VGND VGND VPWR VPWR sky130_fd_sc_hd__decap_3
XFILLER_8_589 VGND VGND VPWR VPWR sky130_fd_sc_hd__decap_3
XANTENNA_6 _3628_/C VGND VGND VPWR VPWR sky130_fd_sc_hd__diode_2
XFILLER_79_530 VGND VGND VPWR VPWR sky130_fd_sc_hd__decap_3
XFILLER_39_416 VGND VGND VPWR VPWR sky130_fd_sc_hd__fill_2
XFILLER_79_574 VGND VGND VPWR VPWR sky130_fd_sc_hd__fill_2
XFILLER_94_511 VGND VGND VPWR VPWR sky130_fd_sc_hd__decap_3
XFILLER_39_449 VGND VGND VPWR VPWR sky130_fd_sc_hd__decap_3
XFILLER_66_224 VGND VGND VPWR VPWR sky130_fd_sc_hd__decap_3
XFILLER_94_533 VGND VGND VPWR VPWR sky130_fd_sc_hd__decap_3
XFILLER_19_140 VGND VGND VPWR VPWR sky130_fd_sc_hd__fill_1
XTAP_TAPCELL_ROW_65_904 VGND VPWR sky130_fd_sc_hd__tapvpwrvgnd_1
XTAP_TAPCELL_ROW_37_606 VGND VPWR sky130_fd_sc_hd__tapvpwrvgnd_1
XFILLER_81_205 VGND VGND VPWR VPWR sky130_fd_sc_hd__decap_3
XFILLER_62_430 VGND VGND VPWR VPWR sky130_fd_sc_hd__decap_3
XFILLER_74_290 VGND VGND VPWR VPWR sky130_fd_sc_hd__decap_3
X_6860_ _6860_/A _6860_/B _6852_/X VGND VGND VPWR VPWR _6860_/X sky130_fd_sc_hd__or3b_2
XFILLER_62_474 VGND VGND VPWR VPWR sky130_fd_sc_hd__fill_2
X_6791_ _5874_/B _6776_/X _5843_/X VGND VGND VPWR VPWR _6791_/Y sky130_fd_sc_hd__a21oi_2
X_5811_ _5810_/A _5810_/B _5759_/Y VGND VGND VPWR VPWR _6597_/B sky130_fd_sc_hd__a21o_2
XTAP_TAPCELL_ROW_73_981 VGND VPWR sky130_fd_sc_hd__tapvpwrvgnd_1
XFILLER_22_349 VGND VGND VPWR VPWR sky130_fd_sc_hd__decap_3
X_5742_ _5717_/A _5740_/B _5740_/C VGND VGND VPWR VPWR _5743_/C sky130_fd_sc_hd__a21oi_2
XTAP_TAPCELL_ROW_45_694 VGND VPWR sky130_fd_sc_hd__tapvpwrvgnd_1
XTAP_TAPCELL_ROW_17_396 VGND VPWR sky130_fd_sc_hd__tapvpwrvgnd_1
XFILLER_30_371 VGND VGND VPWR VPWR sky130_fd_sc_hd__decap_3
X_5673_ _5672_/A _5672_/B _5672_/C VGND VGND VPWR VPWR _5674_/A sky130_fd_sc_hd__a21oi_2
X_4624_ _4623_/A _4623_/C _4623_/B VGND VGND VPWR VPWR _4625_/C sky130_fd_sc_hd__a21o_2
XPHY_EDGE_ROW_6_Right_6 VGND VGND VPWR VPWR sky130_fd_sc_hd__decap_3
X_4555_ _4554_/A _4554_/Y _4501_/X _4502_/Y VGND VGND VPWR VPWR _4558_/B sky130_fd_sc_hd__a211oi_2
X_3506_ _4176_/A _6924_/S VGND VGND VPWR VPWR _3510_/A sky130_fd_sc_hd__nand2_2
XTAP_TAPCELL_ROW_9_309 VGND VPWR sky130_fd_sc_hd__tapvpwrvgnd_1
XFILLER_89_305 VGND VGND VPWR VPWR sky130_fd_sc_hd__decap_3
X_4486_ _4485_/B _4623_/A VGND VGND VPWR VPWR _4488_/B sky130_fd_sc_hd__nand2b_2
X_6225_ _6467_/A _6225_/B VGND VGND VPWR VPWR _6485_/B sky130_fd_sc_hd__or2_2
XFILLER_57_202 VGND VGND VPWR VPWR sky130_fd_sc_hd__decap_3
X_6156_ _3663_/Y _3738_/Y _6104_/B _6155_/D VGND VGND VPWR VPWR _6156_/X sky130_fd_sc_hd__a211o_2
XFILLER_85_533 VGND VGND VPWR VPWR sky130_fd_sc_hd__fill_2
Xload_slew492 _3639_/A VGND VGND VPWR VPWR _4607_/B sky130_fd_sc_hd__buf_6
X_5107_ _5107_/A _5107_/B VGND VGND VPWR VPWR _5108_/C sky130_fd_sc_hd__nor2_2
XFILLER_97_393 VGND VGND VPWR VPWR sky130_fd_sc_hd__decap_3
XFILLER_57_268 VGND VGND VPWR VPWR sky130_fd_sc_hd__decap_3
XFILLER_85_555 VGND VGND VPWR VPWR sky130_fd_sc_hd__decap_3
X_6087_ _6087_/A _6809_/A VGND VGND VPWR VPWR _6807_/A sky130_fd_sc_hd__nand2_2
XFILLER_72_227 VGND VGND VPWR VPWR sky130_fd_sc_hd__decap_3
XFILLER_85_588 VGND VGND VPWR VPWR sky130_fd_sc_hd__decap_3
X_5038_ _5038_/A _5038_/B _5038_/C VGND VGND VPWR VPWR _5038_/X sky130_fd_sc_hd__and3_4
XTAP_TAPCELL_ROW_0_220 VGND VPWR sky130_fd_sc_hd__tapvpwrvgnd_1
XFILLER_53_430 VGND VGND VPWR VPWR sky130_fd_sc_hd__decap_3
XFILLER_25_143 VGND VGND VPWR VPWR sky130_fd_sc_hd__fill_2
XFILLER_25_165 VGND VGND VPWR VPWR sky130_fd_sc_hd__decap_3
XFILLER_53_452 VGND VGND VPWR VPWR sky130_fd_sc_hd__decap_3
XFILLER_15_66 VGND VGND VPWR VPWR sky130_fd_sc_hd__fill_1
XFILLER_40_102 VGND VGND VPWR VPWR sky130_fd_sc_hd__decap_3
X_6989_ _6989_/A _6989_/B _6989_/C _6989_/D VGND VGND VPWR VPWR _6990_/C sky130_fd_sc_hd__or4_4
XTAP_TAPCELL_ROW_84_1099 VGND VPWR sky130_fd_sc_hd__tapvpwrvgnd_1
XFILLER_15_99 VGND VGND VPWR VPWR sky130_fd_sc_hd__decap_3
XFILLER_40_157 VGND VGND VPWR VPWR sky130_fd_sc_hd__decap_3
XFILLER_40_168 VGND VGND VPWR VPWR sky130_fd_sc_hd__decap_3
XFILLER_31_43 VGND VGND VPWR VPWR sky130_fd_sc_hd__decap_3
XFILLER_31_65 VGND VGND VPWR VPWR sky130_fd_sc_hd__fill_1
Xrebuffer675 _5818_/Y VGND VGND VPWR VPWR _6774_/A1 sky130_fd_sc_hd__buf_2
XFILLER_31_87 VGND VGND VPWR VPWR sky130_fd_sc_hd__decap_3
Xrebuffer697 _5244_/X VGND VGND VPWR VPWR _5835_/B1 sky130_fd_sc_hd__buf_2
Xrebuffer686 _5828_/B1 VGND VGND VPWR VPWR _5849_/B1 sky130_fd_sc_hd__buf_2
Xoutput76 _6989_/B VGND VGND VPWR VPWR result[14] sky130_fd_sc_hd__clkbuf_2
XFILLER_0_231 VGND VGND VPWR VPWR sky130_fd_sc_hd__decap_3
XFILLER_0_253 VGND VGND VPWR VPWR sky130_fd_sc_hd__fill_2
Xoutput98 _6986_/A VGND VGND VPWR VPWR result[5] sky130_fd_sc_hd__clkbuf_2
Xoutput87 _6991_/A VGND VGND VPWR VPWR result[24] sky130_fd_sc_hd__dlymetal6s4s_1
XFILLER_0_275 VGND VGND VPWR VPWR sky130_fd_sc_hd__decap_3
XFILLER_48_224 VGND VGND VPWR VPWR sky130_fd_sc_hd__decap_3
XFILLER_76_533 VGND VGND VPWR VPWR sky130_fd_sc_hd__fill_1
XFILLER_88_371 VGND VGND VPWR VPWR sky130_fd_sc_hd__decap_3
XFILLER_76_555 VGND VGND VPWR VPWR sky130_fd_sc_hd__decap_3
XFILLER_91_503 VGND VGND VPWR VPWR sky130_fd_sc_hd__fill_1
XFILLER_56_62 VGND VGND VPWR VPWR sky130_fd_sc_hd__decap_3
XFILLER_29_493 VGND VGND VPWR VPWR sky130_fd_sc_hd__decap_3
XFILLER_56_290 VGND VGND VPWR VPWR sky130_fd_sc_hd__decap_3
XFILLER_63_249 VGND VGND VPWR VPWR sky130_fd_sc_hd__decap_3
XFILLER_71_293 VGND VGND VPWR VPWR sky130_fd_sc_hd__decap_3
XFILLER_72_61 VGND VGND VPWR VPWR sky130_fd_sc_hd__decap_3
XTAP_TAPCELL_ROW_70_951 VGND VPWR sky130_fd_sc_hd__tapvpwrvgnd_1
XTAP_TAPCELL_ROW_42_653 VGND VPWR sky130_fd_sc_hd__tapvpwrvgnd_1
XFILLER_12_360 VGND VGND VPWR VPWR sky130_fd_sc_hd__decap_3
XFILLER_12_371 VGND VGND VPWR VPWR sky130_fd_sc_hd__decap_3
XFILLER_31_179 VGND VGND VPWR VPWR sky130_fd_sc_hd__decap_3
XTAP_TAPCELL_ROW_14_366 VGND VPWR sky130_fd_sc_hd__tapvpwrvgnd_1
XPHY_EDGE_ROW_59_Right_59 VGND VGND VPWR VPWR sky130_fd_sc_hd__decap_3
X_4340_ _4340_/A _4340_/B VGND VGND VPWR VPWR _4455_/A sky130_fd_sc_hd__xnor2_2
XFILLER_4_592 VGND VGND VPWR VPWR sky130_fd_sc_hd__fill_2
X_4271_ _4170_/A _4170_/C _4170_/B VGND VGND VPWR VPWR _4272_/C sky130_fd_sc_hd__a21o_2
X_6010_ _6010_/A _6010_/B VGND VGND VPWR VPWR _6011_/B sky130_fd_sc_hd__xnor2_2
XFILLER_39_213 VGND VGND VPWR VPWR sky130_fd_sc_hd__decap_3
XFILLER_67_511 VGND VGND VPWR VPWR sky130_fd_sc_hd__decap_3
XFILLER_79_382 VGND VGND VPWR VPWR sky130_fd_sc_hd__decap_3
XFILLER_79_393 VGND VGND VPWR VPWR sky130_fd_sc_hd__decap_3
XPHY_EDGE_ROW_68_Right_68 VGND VGND VPWR VPWR sky130_fd_sc_hd__decap_3
XFILLER_27_408 VGND VGND VPWR VPWR sky130_fd_sc_hd__decap_3
XFILLER_67_555 VGND VGND VPWR VPWR sky130_fd_sc_hd__decap_3
XFILLER_54_227 VGND VGND VPWR VPWR sky130_fd_sc_hd__fill_2
XFILLER_82_525 VGND VGND VPWR VPWR sky130_fd_sc_hd__fill_1
XFILLER_82_536 VGND VGND VPWR VPWR sky130_fd_sc_hd__decap_3
XFILLER_94_396 VGND VGND VPWR VPWR sky130_fd_sc_hd__decap_3
XFILLER_35_441 VGND VGND VPWR VPWR sky130_fd_sc_hd__decap_3
XFILLER_54_238 VGND VGND VPWR VPWR sky130_fd_sc_hd__decap_3
XFILLER_82_558 VGND VGND VPWR VPWR sky130_fd_sc_hd__decap_3
X_6912_ _6643_/Y _6911_/Y _6313_/A VGND VGND VPWR VPWR _6912_/X sky130_fd_sc_hd__a21o_2
XFILLER_35_452 VGND VGND VPWR VPWR sky130_fd_sc_hd__fill_2
X_6843_ _6168_/A _6927_/B1 _6928_/A2 _6079_/B VGND VGND VPWR VPWR _6843_/X sky130_fd_sc_hd__o22a_2
XFILLER_62_293 VGND VGND VPWR VPWR sky130_fd_sc_hd__decap_3
XFILLER_50_444 VGND VGND VPWR VPWR sky130_fd_sc_hd__decap_3
X_6774_ _6774_/A1 _5820_/Y _5871_/X _5570_/Y VGND VGND VPWR VPWR _6775_/C sky130_fd_sc_hd__a211o_2
X_3986_ _3986_/A _3986_/B VGND VGND VPWR VPWR _3988_/A sky130_fd_sc_hd__nor2_2
XPHY_EDGE_ROW_77_Right_77 VGND VGND VPWR VPWR sky130_fd_sc_hd__decap_3
XFILLER_50_477 VGND VGND VPWR VPWR sky130_fd_sc_hd__decap_3
X_5725_ _5778_/A _5778_/B _5725_/C _5778_/C VGND VGND VPWR VPWR _5763_/C sky130_fd_sc_hd__nand4_2
X_5656_ _5692_/A _5656_/B VGND VGND VPWR VPWR _5657_/B sky130_fd_sc_hd__nor2_2
X_4607_ _4607_/A _4607_/B _4607_/C _4607_/D VGND VGND VPWR VPWR _4610_/A sky130_fd_sc_hd__and4_2
X_5587_ _5779_/A _5695_/C _5725_/C _5701_/A VGND VGND VPWR VPWR _5588_/D sky130_fd_sc_hd__a22o_2
XFILLER_89_113 VGND VGND VPWR VPWR sky130_fd_sc_hd__fill_2
X_4538_ _4538_/A _6254_/B _4978_/C _4538_/D VGND VGND VPWR VPWR _4538_/X sky130_fd_sc_hd__and4_2
XFILLER_7_9 VGND VGND VPWR VPWR sky130_fd_sc_hd__decap_3
X_4469_ _4469_/A _4469_/B VGND VGND VPWR VPWR _4497_/A sky130_fd_sc_hd__and2_2
XFILLER_77_308 VGND VGND VPWR VPWR sky130_fd_sc_hd__decap_3
X_6208_ _6208_/A _6208_/B VGND VGND VPWR VPWR _6758_/C sky130_fd_sc_hd__nand2_2
XPHY_EDGE_ROW_86_Right_86 VGND VGND VPWR VPWR sky130_fd_sc_hd__decap_3
XFILLER_58_533 VGND VGND VPWR VPWR sky130_fd_sc_hd__decap_3
XFILLER_85_352 VGND VGND VPWR VPWR sky130_fd_sc_hd__fill_2
X_6139_ _6381_/A _6137_/B _4705_/Y _6138_/A VGND VGND VPWR VPWR _6140_/C sky130_fd_sc_hd__o211a_2
XFILLER_45_216 VGND VGND VPWR VPWR sky130_fd_sc_hd__decap_3
XFILLER_73_503 VGND VGND VPWR VPWR sky130_fd_sc_hd__fill_1
XFILLER_73_514 VGND VGND VPWR VPWR sky130_fd_sc_hd__decap_3
XFILLER_85_363 VGND VGND VPWR VPWR sky130_fd_sc_hd__decap_3
XFILLER_85_396 VGND VGND VPWR VPWR sky130_fd_sc_hd__decap_3
XTAP_TAPCELL_ROW_86_1117 VGND VPWR sky130_fd_sc_hd__tapvpwrvgnd_1
XFILLER_73_558 VGND VGND VPWR VPWR sky130_fd_sc_hd__fill_2
XFILLER_26_485 VGND VGND VPWR VPWR sky130_fd_sc_hd__decap_3
XFILLER_41_422 VGND VGND VPWR VPWR sky130_fd_sc_hd__decap_3
XFILLER_81_591 VGND VGND VPWR VPWR sky130_fd_sc_hd__decap_3
XPHY_EDGE_ROW_95_Right_95 VGND VGND VPWR VPWR sky130_fd_sc_hd__decap_3
XFILLER_41_444 VGND VGND VPWR VPWR sky130_fd_sc_hd__decap_3
XFILLER_41_455 VGND VGND VPWR VPWR sky130_fd_sc_hd__decap_3
XTAP_TAPCELL_ROW_11_336 VGND VPWR sky130_fd_sc_hd__tapvpwrvgnd_1
XTAP_TAPCELL_ROW_97_1235 VGND VPWR sky130_fd_sc_hd__tapvpwrvgnd_1
XFILLER_68_319 VGND VGND VPWR VPWR sky130_fd_sc_hd__decap_3
XFILLER_1_573 VGND VGND VPWR VPWR sky130_fd_sc_hd__fill_2
XFILLER_67_50 VGND VGND VPWR VPWR sky130_fd_sc_hd__decap_3
XFILLER_36_205 VGND VGND VPWR VPWR sky130_fd_sc_hd__decap_3
XFILLER_64_525 VGND VGND VPWR VPWR sky130_fd_sc_hd__decap_3
XFILLER_76_363 VGND VGND VPWR VPWR sky130_fd_sc_hd__fill_1
XFILLER_76_374 VGND VGND VPWR VPWR sky130_fd_sc_hd__decap_3
XFILLER_76_385 VGND VGND VPWR VPWR sky130_fd_sc_hd__decap_3
XFILLER_91_300 VGND VGND VPWR VPWR sky130_fd_sc_hd__decap_3
XTAP_TAPCELL_ROW_47_712 VGND VPWR sky130_fd_sc_hd__tapvpwrvgnd_1
XTAP_TAPCELL_ROW_19_414 VGND VPWR sky130_fd_sc_hd__tapvpwrvgnd_1
XFILLER_17_430 VGND VGND VPWR VPWR sky130_fd_sc_hd__decap_3
XFILLER_64_558 VGND VGND VPWR VPWR sky130_fd_sc_hd__decap_3
XFILLER_91_333 VGND VGND VPWR VPWR sky130_fd_sc_hd__decap_3
XFILLER_51_208 VGND VGND VPWR VPWR sky130_fd_sc_hd__decap_3
XFILLER_83_60 VGND VGND VPWR VPWR sky130_fd_sc_hd__decap_3
XFILLER_91_355 VGND VGND VPWR VPWR sky130_fd_sc_hd__decap_3
XFILLER_91_388 VGND VGND VPWR VPWR sky130_fd_sc_hd__decap_3
XFILLER_17_485 VGND VGND VPWR VPWR sky130_fd_sc_hd__decap_3
XFILLER_44_260 VGND VGND VPWR VPWR sky130_fd_sc_hd__decap_3
X_3840_ _3840_/A _3840_/B VGND VGND VPWR VPWR _3841_/B sky130_fd_sc_hd__nor2_2
XFILLER_32_477 VGND VGND VPWR VPWR sky130_fd_sc_hd__fill_1
X_3771_ _3770_/A _4420_/C _4538_/D _6263_/B VGND VGND VPWR VPWR _3771_/Y sky130_fd_sc_hd__a22oi_2
X_5510_ _5511_/B _5511_/C VGND VGND VPWR VPWR _5514_/B sky130_fd_sc_hd__nor2_2
XFILLER_73_3 VGND VGND VPWR VPWR sky130_fd_sc_hd__decap_3
XFILLER_8_172 VGND VGND VPWR VPWR sky130_fd_sc_hd__decap_3
X_6490_ _6488_/X _6489_/X _6545_/A VGND VGND VPWR VPWR _6491_/B sky130_fd_sc_hd__mux2_1
X_5441_ _5441_/A _5441_/B _5441_/C VGND VGND VPWR VPWR _5441_/Y sky130_fd_sc_hd__nor3_4
X_5372_ _5373_/B _5373_/A VGND VGND VPWR VPWR _5372_/X sky130_fd_sc_hd__and2b_2
X_4323_ _4323_/A _4323_/B VGND VGND VPWR VPWR _4324_/A sky130_fd_sc_hd__xor2_2
XFILLER_99_444 VGND VGND VPWR VPWR sky130_fd_sc_hd__decap_3
XFILLER_59_319 VGND VGND VPWR VPWR sky130_fd_sc_hd__decap_3
Xfanout129 _6928_/B1 VGND VGND VPWR VPWR _6506_/B sky130_fd_sc_hd__clkdlybuf4s25_1
XFILLER_99_455 VGND VGND VPWR VPWR sky130_fd_sc_hd__decap_3
XFILLER_86_138 VGND VGND VPWR VPWR sky130_fd_sc_hd__fill_2
X_4254_ _4254_/A VGND VGND VPWR VPWR _4254_/Y sky130_fd_sc_hd__inv_2
X_4185_ _4186_/B _4186_/A VGND VGND VPWR VPWR _4189_/B sky130_fd_sc_hd__and2b_2
XFILLER_55_503 VGND VGND VPWR VPWR sky130_fd_sc_hd__fill_1
XFILLER_55_514 VGND VGND VPWR VPWR sky130_fd_sc_hd__decap_3
XFILLER_67_363 VGND VGND VPWR VPWR sky130_fd_sc_hd__decap_3
XFILLER_55_536 VGND VGND VPWR VPWR sky130_fd_sc_hd__decap_3
XFILLER_82_333 VGND VGND VPWR VPWR sky130_fd_sc_hd__fill_1
XFILLER_82_377 VGND VGND VPWR VPWR sky130_fd_sc_hd__decap_3
XFILLER_82_399 VGND VGND VPWR VPWR sky130_fd_sc_hd__fill_1
XFILLER_23_466 VGND VGND VPWR VPWR sky130_fd_sc_hd__decap_3
XFILLER_35_293 VGND VGND VPWR VPWR sky130_fd_sc_hd__decap_3
X_6826_ _6082_/Y _6963_/A2 _6927_/B1 _6842_/B VGND VGND VPWR VPWR _6826_/X sky130_fd_sc_hd__o22a_2
XFILLER_50_274 VGND VGND VPWR VPWR sky130_fd_sc_hd__decap_3
X_6757_ _6250_/X _6787_/C _6757_/C _6757_/D VGND VGND VPWR VPWR _6757_/X sky130_fd_sc_hd__and4b_2
XTAP_TAPCELL_ROW_81_1069 VGND VPWR sky130_fd_sc_hd__tapvpwrvgnd_1
X_5708_ _6232_/B _5791_/B _5748_/A _5707_/D VGND VGND VPWR VPWR _5710_/C sky130_fd_sc_hd__a22o_2
X_3969_ _3969_/A _3969_/B _3969_/C _3969_/D VGND VGND VPWR VPWR _3971_/A sky130_fd_sc_hd__and4_2
XFILLER_12_45 VGND VGND VPWR VPWR sky130_fd_sc_hd__decap_3
X_6688_ _6383_/A _6242_/B _6853_/A VGND VGND VPWR VPWR _6688_/X sky130_fd_sc_hd__a21o_2
XFILLER_12_67 VGND VGND VPWR VPWR sky130_fd_sc_hd__decap_3
X_5639_ _5639_/A _5639_/B VGND VGND VPWR VPWR _5641_/B sky130_fd_sc_hd__xnor2_2
XFILLER_12_89 VGND VGND VPWR VPWR sky130_fd_sc_hd__fill_2
XTAP_TAPCELL_ROW_92_1187 VGND VPWR sky130_fd_sc_hd__tapvpwrvgnd_1
XFILLER_77_105 VGND VGND VPWR VPWR sky130_fd_sc_hd__decap_3
XFILLER_77_116 VGND VGND VPWR VPWR sky130_fd_sc_hd__decap_3
XFILLER_77_127 VGND VGND VPWR VPWR sky130_fd_sc_hd__decap_3
XFILLER_58_330 VGND VGND VPWR VPWR sky130_fd_sc_hd__decap_3
Xfanout663 _5777_/A VGND VGND VPWR VPWR _5680_/A sky130_fd_sc_hd__clkbuf_2
XFILLER_46_514 VGND VGND VPWR VPWR sky130_fd_sc_hd__decap_3
XFILLER_58_363 VGND VGND VPWR VPWR sky130_fd_sc_hd__fill_1
XFILLER_85_160 VGND VGND VPWR VPWR sky130_fd_sc_hd__decap_3
XFILLER_33_208 VGND VGND VPWR VPWR sky130_fd_sc_hd__decap_3
XFILLER_37_86 VGND VGND VPWR VPWR sky130_fd_sc_hd__decap_3
XFILLER_14_411 VGND VGND VPWR VPWR sky130_fd_sc_hd__fill_1
XFILLER_73_388 VGND VGND VPWR VPWR sky130_fd_sc_hd__decap_3
XFILLER_41_230 VGND VGND VPWR VPWR sky130_fd_sc_hd__decap_3
XFILLER_53_63 VGND VGND VPWR VPWR sky130_fd_sc_hd__decap_3
XFILLER_14_477 VGND VGND VPWR VPWR sky130_fd_sc_hd__fill_1
XFILLER_41_263 VGND VGND VPWR VPWR sky130_fd_sc_hd__fill_1
XFILLER_41_274 VGND VGND VPWR VPWR sky130_fd_sc_hd__decap_3
XFILLER_53_74 VGND VGND VPWR VPWR sky130_fd_sc_hd__fill_1
XFILLER_53_85 VGND VGND VPWR VPWR sky130_fd_sc_hd__decap_3
XTAP_TAPCELL_ROW_24_472 VGND VPWR sky130_fd_sc_hd__tapvpwrvgnd_1
XFILLER_5_142 VGND VGND VPWR VPWR sky130_fd_sc_hd__fill_2
XFILLER_5_197 VGND VGND VPWR VPWR sky130_fd_sc_hd__decap_3
XFILLER_1_370 VGND VGND VPWR VPWR sky130_fd_sc_hd__fill_1
XFILLER_68_127 VGND VGND VPWR VPWR sky130_fd_sc_hd__decap_3
XFILLER_1_381 VGND VGND VPWR VPWR sky130_fd_sc_hd__decap_3
XFILLER_96_469 VGND VGND VPWR VPWR sky130_fd_sc_hd__decap_3
XFILLER_37_536 VGND VGND VPWR VPWR sky130_fd_sc_hd__decap_3
XFILLER_64_333 VGND VGND VPWR VPWR sky130_fd_sc_hd__decap_3
XFILLER_76_171 VGND VGND VPWR VPWR sky130_fd_sc_hd__fill_2
X_5990_ _3986_/A _3988_/B _3986_/B VGND VGND VPWR VPWR _6046_/A sky130_fd_sc_hd__o21ba_2
XFILLER_94_92 VGND VGND VPWR VPWR sky130_fd_sc_hd__decap_3
XFILLER_52_539 VGND VGND VPWR VPWR sky130_fd_sc_hd__decap_3
X_4941_ _4713_/B _4713_/C _4713_/A VGND VGND VPWR VPWR _4942_/C sky130_fd_sc_hd__a21o_2
X_4872_ _4870_/B _4870_/C _4870_/A VGND VGND VPWR VPWR _4872_/Y sky130_fd_sc_hd__a21oi_2
XFILLER_20_403 VGND VGND VPWR VPWR sky130_fd_sc_hd__decap_3
XFILLER_60_561 VGND VGND VPWR VPWR sky130_fd_sc_hd__decap_3
X_6611_ _6611_/A _6611_/B _6605_/X VGND VGND VPWR VPWR _6611_/X sky130_fd_sc_hd__or3b_2
X_3823_ _3824_/A _3824_/B _3824_/C VGND VGND VPWR VPWR _3842_/A sky130_fd_sc_hd__a21oi_2
XFILLER_20_447 VGND VGND VPWR VPWR sky130_fd_sc_hd__decap_3
X_6542_ _6131_/Y _6542_/A2 _6229_/X _6542_/B2 _6133_/Y VGND VGND VPWR VPWR _6542_/X
+ sky130_fd_sc_hd__a221o_2
X_3754_ _3754_/A _3754_/B _3754_/C VGND VGND VPWR VPWR _3760_/A sky130_fd_sc_hd__nand3_2
X_6473_ _6484_/B _6923_/A _6465_/X _6472_/X VGND VGND VPWR VPWR _6473_/X sky130_fd_sc_hd__a31o_2
X_3685_ _3757_/A _6083_/B _3685_/C _3685_/D VGND VGND VPWR VPWR _3707_/A sky130_fd_sc_hd__and4_2
X_5424_ _5425_/A _5425_/B VGND VGND VPWR VPWR _5451_/A sky130_fd_sc_hd__nand2_2
X_5355_ _5355_/A _5355_/B _5355_/C VGND VGND VPWR VPWR _5355_/Y sky130_fd_sc_hd__nand3_2
XFILLER_59_116 VGND VGND VPWR VPWR sky130_fd_sc_hd__decap_3
XFILLER_59_127 VGND VGND VPWR VPWR sky130_fd_sc_hd__decap_3
XFILLER_87_414 VGND VGND VPWR VPWR sky130_fd_sc_hd__decap_3
X_5286_ _5286_/A _5487_/B VGND VGND VPWR VPWR _5431_/A sky130_fd_sc_hd__nand2_2
X_4306_ _4307_/A _4307_/B VGND VGND VPWR VPWR _4306_/Y sky130_fd_sc_hd__nand2b_2
XFILLER_99_274 VGND VGND VPWR VPWR sky130_fd_sc_hd__decap_3
XFILLER_87_469 VGND VGND VPWR VPWR sky130_fd_sc_hd__decap_3
X_4237_ _4237_/A _4237_/B _4237_/C VGND VGND VPWR VPWR _4243_/A sky130_fd_sc_hd__nand3_2
XFILLER_28_503 VGND VGND VPWR VPWR sky130_fd_sc_hd__decap_3
XFILLER_55_300 VGND VGND VPWR VPWR sky130_fd_sc_hd__decap_3
XFILLER_74_108 VGND VGND VPWR VPWR sky130_fd_sc_hd__decap_3
XTAP_TAPCELL_ROW_58_829 VGND VPWR sky130_fd_sc_hd__tapvpwrvgnd_1
XFILLER_28_525 VGND VGND VPWR VPWR sky130_fd_sc_hd__decap_3
XFILLER_28_536 VGND VGND VPWR VPWR sky130_fd_sc_hd__decap_3
XFILLER_67_193 VGND VGND VPWR VPWR sky130_fd_sc_hd__fill_1
XFILLER_74_29 VGND VGND VPWR VPWR sky130_fd_sc_hd__fill_1
X_4168_ _4167_/A _4279_/A VGND VGND VPWR VPWR _4170_/B sky130_fd_sc_hd__nand2b_2
XFILLER_82_141 VGND VGND VPWR VPWR sky130_fd_sc_hd__decap_3
X_4099_ _4096_/X _4099_/B VGND VGND VPWR VPWR _4210_/B sky130_fd_sc_hd__and2b_2
XFILLER_55_399 VGND VGND VPWR VPWR sky130_fd_sc_hd__fill_2
XFILLER_70_314 VGND VGND VPWR VPWR sky130_fd_sc_hd__decap_3
XFILLER_82_185 VGND VGND VPWR VPWR sky130_fd_sc_hd__decap_3
XFILLER_23_252 VGND VGND VPWR VPWR sky130_fd_sc_hd__decap_3
XFILLER_51_583 VGND VGND VPWR VPWR sky130_fd_sc_hd__decap_3
X_6809_ _6809_/A _6809_/B VGND VGND VPWR VPWR _6812_/B sky130_fd_sc_hd__nand2_2
XFILLER_11_425 VGND VGND VPWR VPWR sky130_fd_sc_hd__decap_3
XFILLER_23_296 VGND VGND VPWR VPWR sky130_fd_sc_hd__decap_3
XFILLER_23_66 VGND VGND VPWR VPWR sky130_fd_sc_hd__decap_3
XFILLER_7_407 VGND VGND VPWR VPWR sky130_fd_sc_hd__decap_3
XTAP_TAPCELL_ROW_21_442 VGND VPWR sky130_fd_sc_hd__tapvpwrvgnd_1
XTAP_TAPCELL_ROW_94_1205 VGND VPWR sky130_fd_sc_hd__tapvpwrvgnd_1
XFILLER_2_101 VGND VGND VPWR VPWR sky130_fd_sc_hd__decap_3
XFILLER_3_3 VGND VGND VPWR VPWR sky130_fd_sc_hd__decap_3
XFILLER_78_403 VGND VGND VPWR VPWR sky130_fd_sc_hd__decap_3
XFILLER_78_436 VGND VGND VPWR VPWR sky130_fd_sc_hd__decap_3
XFILLER_48_85 VGND VGND VPWR VPWR sky130_fd_sc_hd__decap_3
XFILLER_93_417 VGND VGND VPWR VPWR sky130_fd_sc_hd__decap_3
Xfanout493 wire496/X VGND VGND VPWR VPWR _3969_/A sky130_fd_sc_hd__buf_4
XFILLER_0_15 VGND VGND VPWR VPWR sky130_fd_sc_hd__decap_3
XFILLER_19_525 VGND VGND VPWR VPWR sky130_fd_sc_hd__decap_3
XTAP_TAPCELL_ROW_29_520 VGND VPWR sky130_fd_sc_hd__tapvpwrvgnd_1
XPHY_EDGE_ROW_100_Left_201 VGND VGND VPWR VPWR sky130_fd_sc_hd__decap_3
XFILLER_34_539 VGND VGND VPWR VPWR sky130_fd_sc_hd__decap_3
XFILLER_61_325 VGND VGND VPWR VPWR sky130_fd_sc_hd__decap_3
XFILLER_64_73 VGND VGND VPWR VPWR sky130_fd_sc_hd__decap_3
XFILLER_14_241 VGND VGND VPWR VPWR sky130_fd_sc_hd__decap_3
XFILLER_42_572 VGND VGND VPWR VPWR sky130_fd_sc_hd__fill_2
XFILLER_9_35 VGND VGND VPWR VPWR sky130_fd_sc_hd__fill_2
XFILLER_14_285 VGND VGND VPWR VPWR sky130_fd_sc_hd__decap_3
XFILLER_80_72 VGND VGND VPWR VPWR sky130_fd_sc_hd__decap_3
XFILLER_6_495 VGND VGND VPWR VPWR sky130_fd_sc_hd__decap_3
XFILLER_89_70 VGND VGND VPWR VPWR sky130_fd_sc_hd__decap_3
XFILLER_36_3 VGND VGND VPWR VPWR sky130_fd_sc_hd__decap_3
X_5140_ _5053_/D _5311_/D _6114_/A _5206_/A VGND VGND VPWR VPWR _5142_/B sky130_fd_sc_hd__a31o_2
XFILLER_69_458 VGND VGND VPWR VPWR sky130_fd_sc_hd__fill_2
X_5071_ _5068_/A _6501_/S _5070_/B _5067_/X VGND VGND VPWR VPWR _5075_/A sky130_fd_sc_hd__a31oi_2
XFILLER_84_417 VGND VGND VPWR VPWR sky130_fd_sc_hd__decap_3
X_4022_ _4022_/A _4022_/B VGND VGND VPWR VPWR _4026_/B sky130_fd_sc_hd__or2_2
XFILLER_96_288 VGND VGND VPWR VPWR sky130_fd_sc_hd__decap_3
XFILLER_37_333 VGND VGND VPWR VPWR sky130_fd_sc_hd__decap_3
XFILLER_84_439 VGND VGND VPWR VPWR sky130_fd_sc_hd__fill_1
XFILLER_64_141 VGND VGND VPWR VPWR sky130_fd_sc_hd__decap_3
XFILLER_37_377 VGND VGND VPWR VPWR sky130_fd_sc_hd__decap_3
XFILLER_92_472 VGND VGND VPWR VPWR sky130_fd_sc_hd__decap_3
XFILLER_92_483 VGND VGND VPWR VPWR sky130_fd_sc_hd__fill_2
XFILLER_92_494 VGND VGND VPWR VPWR sky130_fd_sc_hd__decap_3
X_5973_ _4009_/A _4009_/B _4026_/A VGND VGND VPWR VPWR _5989_/A sky130_fd_sc_hd__o21ai_2
XFILLER_40_509 VGND VGND VPWR VPWR sky130_fd_sc_hd__decap_3
X_4924_ _4924_/A _4924_/B VGND VGND VPWR VPWR _4934_/A sky130_fd_sc_hd__xnor2_2
XFILLER_33_561 VGND VGND VPWR VPWR sky130_fd_sc_hd__decap_3
XTAP_TAPCELL_ROW_63_876 VGND VPWR sky130_fd_sc_hd__tapvpwrvgnd_1
XTAP_TAPCELL_ROW_35_589 VGND VPWR sky130_fd_sc_hd__tapvpwrvgnd_1
XFILLER_20_200 VGND VGND VPWR VPWR sky130_fd_sc_hd__decap_3
X_4855_ _4855_/A _4855_/B _4855_/C VGND VGND VPWR VPWR _4876_/A sky130_fd_sc_hd__or3_4
X_4786_ _4979_/A _4978_/C _4978_/D _4793_/A VGND VGND VPWR VPWR _4787_/B sky130_fd_sc_hd__a22o_2
X_3806_ _3806_/A _3806_/B VGND VGND VPWR VPWR _3807_/B sky130_fd_sc_hd__nor2_2
XFILLER_20_288 VGND VGND VPWR VPWR sky130_fd_sc_hd__decap_3
X_6525_ _6228_/A _6552_/A2 _6552_/A3 _6126_/A _6395_/S _6311_/A VGND VGND VPWR VPWR
+ _6526_/B sky130_fd_sc_hd__mux4_2
X_3737_ _6144_/A _6144_/B VGND VGND VPWR VPWR _6145_/A sky130_fd_sc_hd__and2_2
XFILLER_69_18 VGND VGND VPWR VPWR sky130_fd_sc_hd__decap_3
X_6456_ _6395_/X _6397_/X _6456_/S VGND VGND VPWR VPWR _6457_/B sky130_fd_sc_hd__mux2_1
X_3668_ _3669_/B _3669_/C _3661_/Y VGND VGND VPWR VPWR _3724_/A sky130_fd_sc_hd__a21boi_4
X_6387_ _6274_/Y _6348_/Y _6385_/X _6386_/X _6370_/Y VGND VGND VPWR VPWR _6388_/C
+ sky130_fd_sc_hd__o41a_2
X_5407_ _5407_/A _5407_/B _5407_/C VGND VGND VPWR VPWR _5489_/A sky130_fd_sc_hd__and3_2
X_3599_ _3599_/A _3599_/B _3599_/C VGND VGND VPWR VPWR _3600_/B sky130_fd_sc_hd__or3_2
X_5338_ _5338_/A _5338_/B VGND VGND VPWR VPWR _5355_/A sky130_fd_sc_hd__nand2_2
XFILLER_87_222 VGND VGND VPWR VPWR sky130_fd_sc_hd__fill_2
XFILLER_47_108 VGND VGND VPWR VPWR sky130_fd_sc_hd__decap_3
XFILLER_87_266 VGND VGND VPWR VPWR sky130_fd_sc_hd__decap_3
X_5269_ _5269_/A _5269_/B VGND VGND VPWR VPWR _5272_/B sky130_fd_sc_hd__nor2_4
XFILLER_83_461 VGND VGND VPWR VPWR sky130_fd_sc_hd__decap_3
XFILLER_16_517 VGND VGND VPWR VPWR sky130_fd_sc_hd__decap_3
XFILLER_18_88 VGND VGND VPWR VPWR sky130_fd_sc_hd__fill_2
XFILLER_43_325 VGND VGND VPWR VPWR sky130_fd_sc_hd__decap_3
XFILLER_43_358 VGND VGND VPWR VPWR sky130_fd_sc_hd__fill_2
XFILLER_70_133 VGND VGND VPWR VPWR sky130_fd_sc_hd__decap_3
XFILLER_70_144 VGND VGND VPWR VPWR sky130_fd_sc_hd__decap_3
XFILLER_24_550 VGND VGND VPWR VPWR sky130_fd_sc_hd__decap_3
XFILLER_34_32 VGND VGND VPWR VPWR sky130_fd_sc_hd__decap_3
XFILLER_43_369 VGND VGND VPWR VPWR sky130_fd_sc_hd__decap_3
XFILLER_70_177 VGND VGND VPWR VPWR sky130_fd_sc_hd__decap_3
XFILLER_7_204 VGND VGND VPWR VPWR sky130_fd_sc_hd__decap_3
XFILLER_3_476 VGND VGND VPWR VPWR sky130_fd_sc_hd__fill_1
XFILLER_78_200 VGND VGND VPWR VPWR sky130_fd_sc_hd__decap_3
XFILLER_3_498 VGND VGND VPWR VPWR sky130_fd_sc_hd__decap_3
XFILLER_59_84 VGND VGND VPWR VPWR sky130_fd_sc_hd__decap_3
XFILLER_78_233 VGND VGND VPWR VPWR sky130_fd_sc_hd__decap_3
XFILLER_22_9 VGND VGND VPWR VPWR sky130_fd_sc_hd__fill_1
XFILLER_78_288 VGND VGND VPWR VPWR sky130_fd_sc_hd__decap_3
XFILLER_93_225 VGND VGND VPWR VPWR sky130_fd_sc_hd__decap_3
XTAP_TAPCELL_ROW_6_281 VGND VPWR sky130_fd_sc_hd__tapvpwrvgnd_1
XFILLER_19_366 VGND VGND VPWR VPWR sky130_fd_sc_hd__decap_3
XFILLER_46_130 VGND VGND VPWR VPWR sky130_fd_sc_hd__fill_2
XFILLER_46_141 VGND VGND VPWR VPWR sky130_fd_sc_hd__decap_3
XFILLER_75_61 VGND VGND VPWR VPWR sky130_fd_sc_hd__fill_1
XFILLER_93_269 VGND VGND VPWR VPWR sky130_fd_sc_hd__decap_3
XFILLER_19_377 VGND VGND VPWR VPWR sky130_fd_sc_hd__fill_1
XFILLER_74_461 VGND VGND VPWR VPWR sky130_fd_sc_hd__decap_3
XFILLER_34_347 VGND VGND VPWR VPWR sky130_fd_sc_hd__decap_3
XFILLER_61_133 VGND VGND VPWR VPWR sky130_fd_sc_hd__decap_3
XFILLER_22_509 VGND VGND VPWR VPWR sky130_fd_sc_hd__decap_3
XFILLER_30_520 VGND VGND VPWR VPWR sky130_fd_sc_hd__decap_3
XFILLER_42_391 VGND VGND VPWR VPWR sky130_fd_sc_hd__decap_3
XFILLER_91_71 VGND VGND VPWR VPWR sky130_fd_sc_hd__decap_3
XTAP_TAPCELL_ROW_60_846 VGND VPWR sky130_fd_sc_hd__tapvpwrvgnd_1
XTAP_TAPCELL_ROW_32_548 VGND VPWR sky130_fd_sc_hd__tapvpwrvgnd_1
X_4640_ _4642_/B _4642_/C _4642_/A VGND VGND VPWR VPWR _4643_/C sky130_fd_sc_hd__a21oi_2
X_6310_ _4176_/A _4290_/A _6187_/B _6879_/B2 _6319_/S _3868_/B VGND VGND VPWR VPWR
+ _6310_/X sky130_fd_sc_hd__mux4_2
X_4571_ _4989_/A _4785_/B VGND VGND VPWR VPWR _4578_/A sky130_fd_sc_hd__nand2_2
X_3522_ _6263_/B _4551_/A _6929_/A _3869_/D VGND VGND VPWR VPWR _3525_/A sky130_fd_sc_hd__and4_2
X_6241_ _6672_/B _6212_/X _6240_/X _6144_/B _3489_/Y VGND VGND VPWR VPWR _6242_/B
+ sky130_fd_sc_hd__o32a_2
X_6172_ _6172_/A _6172_/B VGND VGND VPWR VPWR _6871_/A sky130_fd_sc_hd__and2_2
Xload_slew641 _5778_/A VGND VGND VPWR VPWR _5695_/A sky130_fd_sc_hd__buf_4
Xload_slew630 _3680_/A VGND VGND VPWR VPWR _3941_/C sky130_fd_sc_hd__buf_4
X_5123_ _5123_/A _5123_/B VGND VGND VPWR VPWR _5238_/B sky130_fd_sc_hd__xnor2_2
XFILLER_69_255 VGND VGND VPWR VPWR sky130_fd_sc_hd__decap_3
XFILLER_84_203 VGND VGND VPWR VPWR sky130_fd_sc_hd__decap_3
Xload_slew652 _3657_/C VGND VGND VPWR VPWR _6089_/B sky130_fd_sc_hd__clkbuf_4
XFILLER_69_299 VGND VGND VPWR VPWR sky130_fd_sc_hd__decap_3
X_5054_ _5054_/A _5313_/B VGND VGND VPWR VPWR _5056_/A sky130_fd_sc_hd__nand2_2
XTAP_TAPCELL_ROW_68_935 VGND VPWR sky130_fd_sc_hd__tapvpwrvgnd_1
X_4005_ _3991_/B _6008_/A _4006_/C VGND VGND VPWR VPWR _4007_/A sky130_fd_sc_hd__a21oi_2
XFILLER_1_80 VGND VGND VPWR VPWR sky130_fd_sc_hd__fill_1
XFILLER_52_100 VGND VGND VPWR VPWR sky130_fd_sc_hd__decap_3
XFILLER_65_461 VGND VGND VPWR VPWR sky130_fd_sc_hd__decap_3
XFILLER_37_185 VGND VGND VPWR VPWR sky130_fd_sc_hd__decap_3
XFILLER_52_144 VGND VGND VPWR VPWR sky130_fd_sc_hd__decap_3
XFILLER_80_453 VGND VGND VPWR VPWR sky130_fd_sc_hd__decap_3
XFILLER_80_486 VGND VGND VPWR VPWR sky130_fd_sc_hd__decap_3
X_5956_ _6848_/S _5956_/B _6569_/B _6286_/B VGND VGND VPWR VPWR _5959_/B sky130_fd_sc_hd__or4_2
XFILLER_33_391 VGND VGND VPWR VPWR sky130_fd_sc_hd__fill_1
X_5887_ _5882_/A _5880_/X _4903_/A _4904_/Y VGND VGND VPWR VPWR _5888_/D sky130_fd_sc_hd__o211a_2
X_4907_ _4848_/Y _4852_/B _4904_/A _4905_/Y VGND VGND VPWR VPWR _4907_/X sky130_fd_sc_hd__a211o_2
XFILLER_21_564 VGND VGND VPWR VPWR sky130_fd_sc_hd__decap_3
X_4838_ _4883_/B _4838_/B VGND VGND VPWR VPWR _4852_/A sky130_fd_sc_hd__nor2_2
Xrebuffer846 _6841_/B VGND VGND VPWR VPWR _6856_/B sky130_fd_sc_hd__buf_2
X_4769_ _4766_/Y _4808_/A _4769_/C VGND VGND VPWR VPWR _4808_/B sky130_fd_sc_hd__nand3b_2
X_6508_ _6122_/B _6717_/B _6891_/B1 _5585_/Y VGND VGND VPWR VPWR _6508_/X sky130_fd_sc_hd__o22a_2
XFILLER_20_45 VGND VGND VPWR VPWR sky130_fd_sc_hd__decap_3
X_6439_ _6439_/A _6439_/B VGND VGND VPWR VPWR _6439_/Y sky130_fd_sc_hd__nand2_2
XFILLER_0_413 VGND VGND VPWR VPWR sky130_fd_sc_hd__decap_3
XFILLER_0_424 VGND VGND VPWR VPWR sky130_fd_sc_hd__decap_3
XFILLER_88_520 VGND VGND VPWR VPWR sky130_fd_sc_hd__decap_3
XFILLER_96_27 VGND VGND VPWR VPWR sky130_fd_sc_hd__fill_1
XFILLER_75_203 VGND VGND VPWR VPWR sky130_fd_sc_hd__decap_3
XFILLER_29_54 VGND VGND VPWR VPWR sky130_fd_sc_hd__fill_2
XFILLER_75_225 VGND VGND VPWR VPWR sky130_fd_sc_hd__decap_3
XFILLER_28_141 VGND VGND VPWR VPWR sky130_fd_sc_hd__fill_2
XFILLER_29_98 VGND VGND VPWR VPWR sky130_fd_sc_hd__decap_3
XTAP_TAPCELL_ROW_89_1148 VGND VPWR sky130_fd_sc_hd__tapvpwrvgnd_1
XTAP_TAPCELL_ROW_3_251 VGND VPWR sky130_fd_sc_hd__tapvpwrvgnd_1
XFILLER_56_472 VGND VGND VPWR VPWR sky130_fd_sc_hd__decap_3
XFILLER_56_483 VGND VGND VPWR VPWR sky130_fd_sc_hd__decap_3
XFILLER_16_347 VGND VGND VPWR VPWR sky130_fd_sc_hd__decap_3
XFILLER_28_185 VGND VGND VPWR VPWR sky130_fd_sc_hd__decap_3
XFILLER_45_64 VGND VGND VPWR VPWR sky130_fd_sc_hd__decap_3
XFILLER_43_144 VGND VGND VPWR VPWR sky130_fd_sc_hd__decap_3
XFILLER_12_542 VGND VGND VPWR VPWR sky130_fd_sc_hd__decap_3
XFILLER_12_597 VGND VGND VPWR VPWR sky130_fd_sc_hd__fill_1
XFILLER_8_568 VGND VGND VPWR VPWR sky130_fd_sc_hd__decap_3
XANTENNA_7 _6178_/A VGND VGND VPWR VPWR sky130_fd_sc_hd__diode_2
XFILLER_3_240 VGND VGND VPWR VPWR sky130_fd_sc_hd__decap_3
XFILLER_98_306 VGND VGND VPWR VPWR sky130_fd_sc_hd__fill_2
XFILLER_3_295 VGND VGND VPWR VPWR sky130_fd_sc_hd__fill_1
XFILLER_66_203 VGND VGND VPWR VPWR sky130_fd_sc_hd__decap_3
XFILLER_66_236 VGND VGND VPWR VPWR sky130_fd_sc_hd__decap_3
XFILLER_79_597 VGND VGND VPWR VPWR sky130_fd_sc_hd__fill_1
XFILLER_94_545 VGND VGND VPWR VPWR sky130_fd_sc_hd__decap_3
XFILLER_94_523 VGND VGND VPWR VPWR sky130_fd_sc_hd__decap_3
XFILLER_54_409 VGND VGND VPWR VPWR sky130_fd_sc_hd__decap_3
XFILLER_34_100 VGND VGND VPWR VPWR sky130_fd_sc_hd__decap_3
XFILLER_81_217 VGND VGND VPWR VPWR sky130_fd_sc_hd__decap_3
XFILLER_81_228 VGND VGND VPWR VPWR sky130_fd_sc_hd__decap_3
XTAP_TAPCELL_ROW_37_607 VGND VPWR sky130_fd_sc_hd__tapvpwrvgnd_1
XFILLER_94_589 VGND VGND VPWR VPWR sky130_fd_sc_hd__fill_1
XFILLER_19_196 VGND VGND VPWR VPWR sky130_fd_sc_hd__decap_3
XFILLER_34_155 VGND VGND VPWR VPWR sky130_fd_sc_hd__decap_3
X_6790_ _6790_/A _6790_/B VGND VGND VPWR VPWR _6984_/B sky130_fd_sc_hd__nand2_2
X_5810_ _5810_/A _5810_/B VGND VGND VPWR VPWR _5810_/Y sky130_fd_sc_hd__nand2_2
XFILLER_34_177 VGND VGND VPWR VPWR sky130_fd_sc_hd__decap_3
X_5741_ _5675_/B _5675_/A _5674_/B VGND VGND VPWR VPWR _5743_/B sky130_fd_sc_hd__a21oi_2
XTAP_TAPCELL_ROW_73_982 VGND VPWR sky130_fd_sc_hd__tapvpwrvgnd_1
XTAP_TAPCELL_ROW_17_397 VGND VPWR sky130_fd_sc_hd__tapvpwrvgnd_1
XFILLER_15_391 VGND VGND VPWR VPWR sky130_fd_sc_hd__fill_1
XFILLER_30_361 VGND VGND VPWR VPWR sky130_fd_sc_hd__decap_3
X_5672_ _5672_/A _5672_/B _5672_/C VGND VGND VPWR VPWR _5674_/B sky130_fd_sc_hd__and3_4
X_4623_ _4623_/A _4623_/B _4623_/C VGND VGND VPWR VPWR _4625_/B sky130_fd_sc_hd__nand3_2
X_4554_ _4554_/A _4554_/B _4554_/C VGND VGND VPWR VPWR _4554_/Y sky130_fd_sc_hd__nand3_2
XTAP_TAPCELL_ROW_77_1030 VGND VPWR sky130_fd_sc_hd__tapvpwrvgnd_1
XFILLER_7_590 VGND VGND VPWR VPWR sky130_fd_sc_hd__fill_2
X_3505_ _6731_/A VGND VGND VPWR VPWR _6730_/A sky130_fd_sc_hd__inv_2
X_6224_ _6224_/A _6569_/A VGND VGND VPWR VPWR _6225_/B sky130_fd_sc_hd__and2_2
X_4485_ _4485_/A _4485_/B _4485_/C VGND VGND VPWR VPWR _4623_/A sky130_fd_sc_hd__or3_4
XFILLER_85_501 VGND VGND VPWR VPWR sky130_fd_sc_hd__decap_3
X_6155_ _6378_/B _6155_/B _6155_/C _6155_/D VGND VGND VPWR VPWR _6155_/X sky130_fd_sc_hd__or4_2
XFILLER_57_214 VGND VGND VPWR VPWR sky130_fd_sc_hd__decap_3
XFILLER_57_225 VGND VGND VPWR VPWR sky130_fd_sc_hd__decap_3
Xload_slew460 _6220_/B VGND VGND VPWR VPWR _5791_/B sky130_fd_sc_hd__clkbuf_4
X_6086_ _6087_/A _6809_/A VGND VGND VPWR VPWR _6808_/A sky130_fd_sc_hd__and2_2
X_5106_ _5108_/B VGND VGND VPWR VPWR _5242_/A sky130_fd_sc_hd__inv_2
XFILLER_85_567 VGND VGND VPWR VPWR sky130_fd_sc_hd__fill_1
X_5037_ _4947_/A _4947_/C _4947_/B VGND VGND VPWR VPWR _5038_/C sky130_fd_sc_hd__o21ai_2
XFILLER_72_206 VGND VGND VPWR VPWR sky130_fd_sc_hd__decap_3
XTAP_TAPCELL_ROW_0_221 VGND VPWR sky130_fd_sc_hd__tapvpwrvgnd_1
XTAP_TAPCELL_ROW_0_210 VGND VPWR sky130_fd_sc_hd__tapvpwrvgnd_1
XFILLER_25_100 VGND VGND VPWR VPWR sky130_fd_sc_hd__decap_3
XFILLER_53_442 VGND VGND VPWR VPWR sky130_fd_sc_hd__decap_3
XFILLER_82_18 VGND VGND VPWR VPWR sky130_fd_sc_hd__fill_1
XFILLER_82_29 VGND VGND VPWR VPWR sky130_fd_sc_hd__decap_3
XFILLER_13_317 VGND VGND VPWR VPWR sky130_fd_sc_hd__decap_3
XFILLER_40_114 VGND VGND VPWR VPWR sky130_fd_sc_hd__decap_3
X_6988_ _6988_/A _6988_/B _6987_/Y VGND VGND VPWR VPWR _6989_/D sky130_fd_sc_hd__or3b_4
X_5939_ _5939_/A _5939_/B VGND VGND VPWR VPWR _6951_/C sky130_fd_sc_hd__or2_2
XFILLER_21_361 VGND VGND VPWR VPWR sky130_fd_sc_hd__decap_3
XFILLER_21_383 VGND VGND VPWR VPWR sky130_fd_sc_hd__decap_3
XFILLER_5_505 VGND VGND VPWR VPWR sky130_fd_sc_hd__decap_3
XFILLER_31_55 VGND VGND VPWR VPWR sky130_fd_sc_hd__fill_1
XFILLER_5_538 VGND VGND VPWR VPWR sky130_fd_sc_hd__decap_3
Xrebuffer676 wire116/X VGND VGND VPWR VPWR _4557_/A1 sky130_fd_sc_hd__buf_2
Xrebuffer698 _4855_/A VGND VGND VPWR VPWR _4715_/A1 sky130_fd_sc_hd__buf_2
Xrebuffer687 _5269_/B VGND VGND VPWR VPWR _5280_/A sky130_fd_sc_hd__buf_2
XFILLER_0_243 VGND VGND VPWR VPWR sky130_fd_sc_hd__decap_3
Xoutput99 _6986_/B VGND VGND VPWR VPWR result[6] sky130_fd_sc_hd__dlymetal6s4s_1
Xoutput88 _6993_/A VGND VGND VPWR VPWR result[25] sky130_fd_sc_hd__buf_6
Xoutput77 _6990_/B VGND VGND VPWR VPWR result[15] sky130_fd_sc_hd__clkbuf_2
XFILLER_76_512 VGND VGND VPWR VPWR sky130_fd_sc_hd__decap_3
XFILLER_48_236 VGND VGND VPWR VPWR sky130_fd_sc_hd__decap_3
XFILLER_48_269 VGND VGND VPWR VPWR sky130_fd_sc_hd__decap_3
XFILLER_76_567 VGND VGND VPWR VPWR sky130_fd_sc_hd__decap_3
XFILLER_29_461 VGND VGND VPWR VPWR sky130_fd_sc_hd__decap_3
XFILLER_63_206 VGND VGND VPWR VPWR sky130_fd_sc_hd__decap_3
XFILLER_63_228 VGND VGND VPWR VPWR sky130_fd_sc_hd__decap_3
XFILLER_76_589 VGND VGND VPWR VPWR sky130_fd_sc_hd__decap_3
XFILLER_56_280 VGND VGND VPWR VPWR sky130_fd_sc_hd__decap_3
XFILLER_56_85 VGND VGND VPWR VPWR sky130_fd_sc_hd__decap_3
XFILLER_16_155 VGND VGND VPWR VPWR sky130_fd_sc_hd__decap_3
XFILLER_44_475 VGND VGND VPWR VPWR sky130_fd_sc_hd__fill_1
XFILLER_71_261 VGND VGND VPWR VPWR sky130_fd_sc_hd__decap_3
XFILLER_31_136 VGND VGND VPWR VPWR sky130_fd_sc_hd__fill_2
XTAP_TAPCELL_ROW_70_952 VGND VPWR sky130_fd_sc_hd__tapvpwrvgnd_1
XTAP_TAPCELL_ROW_42_654 VGND VPWR sky130_fd_sc_hd__tapvpwrvgnd_1
XFILLER_8_321 VGND VGND VPWR VPWR sky130_fd_sc_hd__fill_2
XTAP_TAPCELL_ROW_14_367 VGND VPWR sky130_fd_sc_hd__tapvpwrvgnd_1
XFILLER_8_365 VGND VGND VPWR VPWR sky130_fd_sc_hd__fill_1
X_4270_ _4262_/A _4262_/B _4269_/B _4372_/B _4372_/A VGND VGND VPWR VPWR _4272_/B
+ sky130_fd_sc_hd__a32o_2
XFILLER_100_108 VGND VGND VPWR VPWR sky130_fd_sc_hd__decap_3
XFILLER_39_225 VGND VGND VPWR VPWR sky130_fd_sc_hd__decap_3
XFILLER_39_269 VGND VGND VPWR VPWR sky130_fd_sc_hd__decap_3
XFILLER_54_206 VGND VGND VPWR VPWR sky130_fd_sc_hd__fill_1
X_6911_ _6961_/A1 _6783_/X _6910_/X _6960_/A VGND VGND VPWR VPWR _6911_/Y sky130_fd_sc_hd__a22oi_2
X_6842_ _6842_/A _6842_/B _6842_/C VGND VGND VPWR VPWR _6842_/Y sky130_fd_sc_hd__nand3_2
XFILLER_90_592 VGND VGND VPWR VPWR sky130_fd_sc_hd__decap_3
XFILLER_22_136 VGND VGND VPWR VPWR sky130_fd_sc_hd__decap_3
XFILLER_22_147 VGND VGND VPWR VPWR sky130_fd_sc_hd__decap_3
X_6773_ _6777_/A _6754_/X _6755_/Y _6772_/Y VGND VGND VPWR VPWR _6984_/A sky130_fd_sc_hd__o31ai_2
X_3985_ _3984_/A _3984_/B _3984_/C VGND VGND VPWR VPWR _3986_/B sky130_fd_sc_hd__a21oi_2
XFILLER_10_309 VGND VGND VPWR VPWR sky130_fd_sc_hd__decap_3
XFILLER_50_489 VGND VGND VPWR VPWR sky130_fd_sc_hd__decap_3
X_5724_ _5698_/A _5698_/C _6124_/A VGND VGND VPWR VPWR _5726_/B sky130_fd_sc_hd__o21ai_2
X_5655_ _5655_/A _5655_/B VGND VGND VPWR VPWR _5714_/A sky130_fd_sc_hd__xor2_2
X_4606_ _4509_/A _4509_/C _4509_/B VGND VGND VPWR VPWR _4612_/B sky130_fd_sc_hd__o21ai_2
X_5586_ _5779_/A _5701_/A _5695_/C _5725_/C VGND VGND VPWR VPWR _5588_/C sky130_fd_sc_hd__nand4_2
X_4537_ _3495_/Y _6832_/S _4420_/X _4421_/Y VGND VGND VPWR VPWR _4544_/B sky130_fd_sc_hd__o22a_2
X_4468_ _4888_/A _4468_/B VGND VGND VPWR VPWR _4469_/B sky130_fd_sc_hd__nand2_2
XFILLER_89_158 VGND VGND VPWR VPWR sky130_fd_sc_hd__decap_3
X_6207_ _6207_/A _6796_/A VGND VGND VPWR VPWR _6795_/B sky130_fd_sc_hd__nand2_2
X_6138_ _6138_/A _6138_/B VGND VGND VPWR VPWR _6138_/Y sky130_fd_sc_hd__nand2_2
X_4399_ _4659_/A _4518_/A _4517_/C _4517_/D VGND VGND VPWR VPWR _4399_/X sky130_fd_sc_hd__and4_2
XFILLER_85_320 VGND VGND VPWR VPWR sky130_fd_sc_hd__decap_3
Xload_slew290 _6678_/A VGND VGND VPWR VPWR _6698_/A sky130_fd_sc_hd__clkbuf_4
XFILLER_97_180 VGND VGND VPWR VPWR sky130_fd_sc_hd__fill_1
XFILLER_85_375 VGND VGND VPWR VPWR sky130_fd_sc_hd__decap_3
XFILLER_93_17 VGND VGND VPWR VPWR sky130_fd_sc_hd__fill_2
X_6069_ _6200_/A _6977_/A VGND VGND VPWR VPWR _6069_/X sky130_fd_sc_hd__and2_2
XTAP_TAPCELL_ROW_86_1118 VGND VPWR sky130_fd_sc_hd__tapvpwrvgnd_1
XFILLER_26_475 VGND VGND VPWR VPWR sky130_fd_sc_hd__fill_1
XFILLER_53_261 VGND VGND VPWR VPWR sky130_fd_sc_hd__decap_3
XFILLER_41_434 VGND VGND VPWR VPWR sky130_fd_sc_hd__fill_2
XFILLER_53_294 VGND VGND VPWR VPWR sky130_fd_sc_hd__decap_3
XFILLER_41_478 VGND VGND VPWR VPWR sky130_fd_sc_hd__decap_3
XFILLER_42_76 VGND VGND VPWR VPWR sky130_fd_sc_hd__fill_1
XTAP_TAPCELL_ROW_11_337 VGND VPWR sky130_fd_sc_hd__tapvpwrvgnd_1
XFILLER_21_191 VGND VGND VPWR VPWR sky130_fd_sc_hd__fill_2
XTAP_TAPCELL_ROW_97_1236 VGND VPWR sky130_fd_sc_hd__tapvpwrvgnd_1
XFILLER_5_324 VGND VGND VPWR VPWR sky130_fd_sc_hd__decap_3
XFILLER_5_379 VGND VGND VPWR VPWR sky130_fd_sc_hd__decap_3
XFILLER_1_541 VGND VGND VPWR VPWR sky130_fd_sc_hd__decap_3
XFILLER_68_309 VGND VGND VPWR VPWR sky130_fd_sc_hd__fill_1
XFILLER_1_596 VGND VGND VPWR VPWR sky130_fd_sc_hd__fill_2
XFILLER_49_512 VGND VGND VPWR VPWR sky130_fd_sc_hd__decap_3
XFILLER_67_73 VGND VGND VPWR VPWR sky130_fd_sc_hd__decap_3
XFILLER_88_180 VGND VGND VPWR VPWR sky130_fd_sc_hd__decap_3
XFILLER_64_504 VGND VGND VPWR VPWR sky130_fd_sc_hd__decap_3
XFILLER_67_95 VGND VGND VPWR VPWR sky130_fd_sc_hd__decap_3
XTAP_TAPCELL_ROW_47_713 VGND VPWR sky130_fd_sc_hd__tapvpwrvgnd_1
XFILLER_76_397 VGND VGND VPWR VPWR sky130_fd_sc_hd__fill_2
XTAP_TAPCELL_ROW_19_415 VGND VPWR sky130_fd_sc_hd__tapvpwrvgnd_1
XFILLER_91_367 VGND VGND VPWR VPWR sky130_fd_sc_hd__decap_3
XFILLER_17_497 VGND VGND VPWR VPWR sky130_fd_sc_hd__decap_3
XFILLER_44_283 VGND VGND VPWR VPWR sky130_fd_sc_hd__decap_3
XFILLER_72_592 VGND VGND VPWR VPWR sky130_fd_sc_hd__decap_3
XTAP_TAPCELL_ROW_55_790 VGND VPWR sky130_fd_sc_hd__tapvpwrvgnd_1
X_3770_ _3770_/A _6263_/B _4420_/C _4538_/D VGND VGND VPWR VPWR _3773_/A sky130_fd_sc_hd__and4_2
XFILLER_12_191 VGND VGND VPWR VPWR sky130_fd_sc_hd__decap_3
X_5440_ _5464_/B _5439_/C _5511_/B VGND VGND VPWR VPWR _5441_/C sky130_fd_sc_hd__a21oi_2
XFILLER_8_195 VGND VGND VPWR VPWR sky130_fd_sc_hd__fill_1
X_5371_ _5370_/B _5370_/C _5370_/A VGND VGND VPWR VPWR _5373_/B sky130_fd_sc_hd__a21boi_2
X_4322_ _4323_/A _4323_/B VGND VGND VPWR VPWR _4322_/X sky130_fd_sc_hd__or2_2
X_4253_ _4253_/A _4253_/B _4253_/C _4253_/D VGND VGND VPWR VPWR _4254_/A sky130_fd_sc_hd__nand4_2
XFILLER_99_467 VGND VGND VPWR VPWR sky130_fd_sc_hd__decap_3
XFILLER_86_106 VGND VGND VPWR VPWR sky130_fd_sc_hd__fill_1
XFILLER_67_320 VGND VGND VPWR VPWR sky130_fd_sc_hd__decap_3
X_4184_ _4184_/A _4299_/A VGND VGND VPWR VPWR _4186_/B sky130_fd_sc_hd__nor2_2
XFILLER_27_217 VGND VGND VPWR VPWR sky130_fd_sc_hd__fill_2
XFILLER_27_228 VGND VGND VPWR VPWR sky130_fd_sc_hd__decap_3
XFILLER_55_548 VGND VGND VPWR VPWR sky130_fd_sc_hd__decap_3
XFILLER_94_183 VGND VGND VPWR VPWR sky130_fd_sc_hd__decap_3
XFILLER_70_518 VGND VGND VPWR VPWR sky130_fd_sc_hd__decap_3
XFILLER_23_412 VGND VGND VPWR VPWR sky130_fd_sc_hd__decap_3
XFILLER_50_242 VGND VGND VPWR VPWR sky130_fd_sc_hd__decap_3
X_6825_ _6825_/A _6825_/B VGND VGND VPWR VPWR _6825_/Y sky130_fd_sc_hd__nor2_2
XFILLER_50_253 VGND VGND VPWR VPWR sky130_fd_sc_hd__decap_3
X_6756_ _6255_/A _6255_/C _6250_/B _6758_/C VGND VGND VPWR VPWR _6757_/D sky130_fd_sc_hd__a211o_2
X_3968_ _4023_/B _4023_/A VGND VGND VPWR VPWR _3984_/B sky130_fd_sc_hd__nand2b_2
XFILLER_50_286 VGND VGND VPWR VPWR sky130_fd_sc_hd__decap_3
XFILLER_50_297 VGND VGND VPWR VPWR sky130_fd_sc_hd__decap_3
X_5707_ _5707_/A _5791_/B _5748_/A _5707_/D VGND VGND VPWR VPWR _5748_/B sky130_fd_sc_hd__nand4_2
XFILLER_12_24 VGND VGND VPWR VPWR sky130_fd_sc_hd__decap_3
XFILLER_12_35 VGND VGND VPWR VPWR sky130_fd_sc_hd__decap_3
X_6687_ _6687_/A _6687_/B VGND VGND VPWR VPWR _6687_/Y sky130_fd_sc_hd__xnor2_2
X_3899_ _4031_/A _4031_/B VGND VGND VPWR VPWR _3916_/B sky130_fd_sc_hd__nand2b_2
X_5638_ _5638_/A _5716_/B _5638_/C VGND VGND VPWR VPWR _5678_/A sky130_fd_sc_hd__nand3_2
XFILLER_2_305 VGND VGND VPWR VPWR sky130_fd_sc_hd__decap_3
X_5569_ _5518_/Y _5522_/X _5564_/Y _5566_/Y VGND VGND VPWR VPWR _5569_/X sky130_fd_sc_hd__a211o_2
XFILLER_2_316 VGND VGND VPWR VPWR sky130_fd_sc_hd__decap_3
Xfanout620 _6079_/B VGND VGND VPWR VPWR _3770_/A sky130_fd_sc_hd__clkbuf_2
Xfanout631 _4585_/A VGND VGND VPWR VPWR _4295_/A1 sky130_fd_sc_hd__clkdlybuf4s25_1
Xfanout642 _6126_/A VGND VGND VPWR VPWR _6439_/A sky130_fd_sc_hd__clkbuf_2
XTAP_TAPCELL_ROW_92_1188 VGND VPWR sky130_fd_sc_hd__tapvpwrvgnd_1
XFILLER_58_342 VGND VGND VPWR VPWR sky130_fd_sc_hd__fill_2
XFILLER_77_139 VGND VGND VPWR VPWR sky130_fd_sc_hd__decap_3
Xfanout653 input11/X VGND VGND VPWR VPWR _6019_/D sky130_fd_sc_hd__clkdlybuf4s25_1
XFILLER_100_461 VGND VGND VPWR VPWR sky130_fd_sc_hd__decap_3
XFILLER_100_483 VGND VGND VPWR VPWR sky130_fd_sc_hd__decap_3
XFILLER_46_526 VGND VGND VPWR VPWR sky130_fd_sc_hd__decap_3
XFILLER_58_386 VGND VGND VPWR VPWR sky130_fd_sc_hd__decap_3
XFILLER_73_312 VGND VGND VPWR VPWR sky130_fd_sc_hd__decap_3
XFILLER_41_242 VGND VGND VPWR VPWR sky130_fd_sc_hd__decap_3
XFILLER_53_42 VGND VGND VPWR VPWR sky130_fd_sc_hd__decap_3
XFILLER_54_592 VGND VGND VPWR VPWR sky130_fd_sc_hd__decap_3
XFILLER_53_97 VGND VGND VPWR VPWR sky130_fd_sc_hd__decap_3
XTAP_TAPCELL_ROW_52_760 VGND VPWR sky130_fd_sc_hd__tapvpwrvgnd_1
XTAP_TAPCELL_ROW_24_473 VGND VPWR sky130_fd_sc_hd__tapvpwrvgnd_1
XFILLER_96_404 VGND VGND VPWR VPWR sky130_fd_sc_hd__fill_2
XFILLER_68_106 VGND VGND VPWR VPWR sky130_fd_sc_hd__fill_2
XFILLER_78_61 VGND VGND VPWR VPWR sky130_fd_sc_hd__decap_3
XFILLER_49_320 VGND VGND VPWR VPWR sky130_fd_sc_hd__decap_3
XFILLER_68_139 VGND VGND VPWR VPWR sky130_fd_sc_hd__fill_1
XFILLER_96_448 VGND VGND VPWR VPWR sky130_fd_sc_hd__decap_3
XFILLER_49_364 VGND VGND VPWR VPWR sky130_fd_sc_hd__decap_3
XFILLER_76_150 VGND VGND VPWR VPWR sky130_fd_sc_hd__decap_3
XFILLER_37_548 VGND VGND VPWR VPWR sky130_fd_sc_hd__decap_3
XFILLER_64_312 VGND VGND VPWR VPWR sky130_fd_sc_hd__decap_3
XFILLER_76_194 VGND VGND VPWR VPWR sky130_fd_sc_hd__fill_2
XFILLER_52_507 VGND VGND VPWR VPWR sky130_fd_sc_hd__decap_3
XFILLER_64_345 VGND VGND VPWR VPWR sky130_fd_sc_hd__decap_3
XFILLER_94_82 VGND VGND VPWR VPWR sky130_fd_sc_hd__fill_2
XFILLER_17_250 VGND VGND VPWR VPWR sky130_fd_sc_hd__decap_3
XFILLER_64_389 VGND VGND VPWR VPWR sky130_fd_sc_hd__decap_3
X_4940_ _4940_/A _4940_/B _4940_/C VGND VGND VPWR VPWR _5030_/A sky130_fd_sc_hd__and3_2
X_4871_ _4871_/A VGND VGND VPWR VPWR _4871_/Y sky130_fd_sc_hd__inv_2
XFILLER_60_573 VGND VGND VPWR VPWR sky130_fd_sc_hd__decap_3
X_6610_ _6294_/Y _6875_/A _6609_/X _6586_/A VGND VGND VPWR VPWR _6611_/A sky130_fd_sc_hd__a22o_2
X_3822_ _3932_/B _3822_/B VGND VGND VPWR VPWR _3824_/C sky130_fd_sc_hd__nand2_2
XFILLER_60_595 VGND VGND VPWR VPWR sky130_fd_sc_hd__decap_3
X_6541_ _5786_/X _5804_/X _6777_/A VGND VGND VPWR VPWR _6541_/Y sky130_fd_sc_hd__a21oi_2
X_3753_ _3720_/A _4526_/B _3721_/A _3720_/D VGND VGND VPWR VPWR _3754_/C sky130_fd_sc_hd__a22o_2
XFILLER_9_471 VGND VGND VPWR VPWR sky130_fd_sc_hd__fill_1
X_6472_ _6472_/A _6472_/B _6471_/X VGND VGND VPWR VPWR _6472_/X sky130_fd_sc_hd__or3b_2
X_3684_ _3690_/A _3690_/B VGND VGND VPWR VPWR _3706_/A sky130_fd_sc_hd__nand2b_2
X_5423_ _5423_/A _5423_/B VGND VGND VPWR VPWR _5425_/B sky130_fd_sc_hd__xor2_2
X_5354_ _5428_/B _5353_/C _5473_/A VGND VGND VPWR VPWR _5355_/C sky130_fd_sc_hd__a21o_2
X_4305_ _4305_/A _4305_/B VGND VGND VPWR VPWR _4307_/B sky130_fd_sc_hd__xnor2_2
XFILLER_99_253 VGND VGND VPWR VPWR sky130_fd_sc_hd__decap_3
XFILLER_99_231 VGND VGND VPWR VPWR sky130_fd_sc_hd__decap_3
XFILLER_87_426 VGND VGND VPWR VPWR sky130_fd_sc_hd__decap_3
X_5285_ _5287_/B _5287_/C _5287_/A VGND VGND VPWR VPWR _5288_/A sky130_fd_sc_hd__o21ai_2
X_4236_ _4126_/A _4126_/C _4126_/B VGND VGND VPWR VPWR _4237_/C sky130_fd_sc_hd__o21ai_2
XFILLER_99_297 VGND VGND VPWR VPWR sky130_fd_sc_hd__decap_3
X_4167_ _4167_/A _4167_/B _4167_/C VGND VGND VPWR VPWR _4279_/A sky130_fd_sc_hd__or3_4
XFILLER_55_312 VGND VGND VPWR VPWR sky130_fd_sc_hd__decap_3
XFILLER_67_172 VGND VGND VPWR VPWR sky130_fd_sc_hd__decap_3
XFILLER_82_120 VGND VGND VPWR VPWR sky130_fd_sc_hd__decap_3
XFILLER_95_470 VGND VGND VPWR VPWR sky130_fd_sc_hd__decap_3
XFILLER_28_559 VGND VGND VPWR VPWR sky130_fd_sc_hd__fill_1
X_4098_ _4593_/A _6264_/A _4211_/D _4592_/A VGND VGND VPWR VPWR _4099_/B sky130_fd_sc_hd__a22o_2
XFILLER_15_209 VGND VGND VPWR VPWR sky130_fd_sc_hd__decap_3
XFILLER_36_570 VGND VGND VPWR VPWR sky130_fd_sc_hd__decap_3
XFILLER_55_378 VGND VGND VPWR VPWR sky130_fd_sc_hd__decap_3
XFILLER_70_326 VGND VGND VPWR VPWR sky130_fd_sc_hd__decap_3
XFILLER_82_164 VGND VGND VPWR VPWR sky130_fd_sc_hd__decap_3
XFILLER_23_220 VGND VGND VPWR VPWR sky130_fd_sc_hd__decap_3
XFILLER_23_231 VGND VGND VPWR VPWR sky130_fd_sc_hd__decap_3
XFILLER_36_592 VGND VGND VPWR VPWR sky130_fd_sc_hd__decap_3
XFILLER_51_540 VGND VGND VPWR VPWR sky130_fd_sc_hd__decap_3
XFILLER_82_197 VGND VGND VPWR VPWR sky130_fd_sc_hd__decap_3
XFILLER_23_264 VGND VGND VPWR VPWR sky130_fd_sc_hd__decap_3
XFILLER_51_573 VGND VGND VPWR VPWR sky130_fd_sc_hd__fill_1
XFILLER_90_29 VGND VGND VPWR VPWR sky130_fd_sc_hd__fill_2
X_6808_ _6808_/A _6808_/B VGND VGND VPWR VPWR _6808_/Y sky130_fd_sc_hd__xnor2_2
XFILLER_11_437 VGND VGND VPWR VPWR sky130_fd_sc_hd__decap_3
XFILLER_7_419 VGND VGND VPWR VPWR sky130_fd_sc_hd__fill_1
X_6739_ _6739_/A _6739_/B VGND VGND VPWR VPWR _6739_/X sky130_fd_sc_hd__xor2_2
XTAP_TAPCELL_ROW_94_1206 VGND VPWR sky130_fd_sc_hd__tapvpwrvgnd_1
XFILLER_2_135 VGND VGND VPWR VPWR sky130_fd_sc_hd__decap_3
XFILLER_78_415 VGND VGND VPWR VPWR sky130_fd_sc_hd__decap_3
XFILLER_78_448 VGND VGND VPWR VPWR sky130_fd_sc_hd__decap_3
Xfanout461 _6474_/S VGND VGND VPWR VPWR _6373_/B sky130_fd_sc_hd__clkdlybuf4s25_1
Xfanout472 _6236_/B VGND VGND VPWR VPWR _6109_/A sky130_fd_sc_hd__clkbuf_4
Xfanout483 _4748_/B VGND VGND VPWR VPWR _5275_/A sky130_fd_sc_hd__dlymetal6s2s_1
XFILLER_46_312 VGND VGND VPWR VPWR sky130_fd_sc_hd__fill_1
XFILLER_48_97 VGND VGND VPWR VPWR sky130_fd_sc_hd__decap_3
XFILLER_58_161 VGND VGND VPWR VPWR sky130_fd_sc_hd__fill_2
XFILLER_58_172 VGND VGND VPWR VPWR sky130_fd_sc_hd__decap_3
XTAP_TAPCELL_ROW_29_521 VGND VPWR sky130_fd_sc_hd__tapvpwrvgnd_1
XFILLER_0_27 VGND VGND VPWR VPWR sky130_fd_sc_hd__fill_1
XFILLER_19_559 VGND VGND VPWR VPWR sky130_fd_sc_hd__fill_1
XFILLER_73_131 VGND VGND VPWR VPWR sky130_fd_sc_hd__decap_3
XFILLER_73_153 VGND VGND VPWR VPWR sky130_fd_sc_hd__decap_3
XFILLER_27_581 VGND VGND VPWR VPWR sky130_fd_sc_hd__fill_1
XFILLER_46_378 VGND VGND VPWR VPWR sky130_fd_sc_hd__decap_3
XFILLER_64_41 VGND VGND VPWR VPWR sky130_fd_sc_hd__decap_3
XFILLER_73_175 VGND VGND VPWR VPWR sky130_fd_sc_hd__decap_3
XFILLER_14_220 VGND VGND VPWR VPWR sky130_fd_sc_hd__decap_3
XFILLER_42_540 VGND VGND VPWR VPWR sky130_fd_sc_hd__decap_3
XFILLER_61_337 VGND VGND VPWR VPWR sky130_fd_sc_hd__decap_3
XFILLER_64_85 VGND VGND VPWR VPWR sky130_fd_sc_hd__decap_3
XFILLER_73_197 VGND VGND VPWR VPWR sky130_fd_sc_hd__decap_3
XFILLER_14_253 VGND VGND VPWR VPWR sky130_fd_sc_hd__decap_3
XFILLER_80_40 VGND VGND VPWR VPWR sky130_fd_sc_hd__decap_3
XFILLER_10_470 VGND VGND VPWR VPWR sky130_fd_sc_hd__decap_3
XFILLER_69_415 VGND VGND VPWR VPWR sky130_fd_sc_hd__decap_3
X_5070_ _5067_/X _5070_/B VGND VGND VPWR VPWR _5156_/B sky130_fd_sc_hd__and2b_2
XFILLER_96_234 VGND VGND VPWR VPWR sky130_fd_sc_hd__decap_3
XFILLER_29_3 VGND VGND VPWR VPWR sky130_fd_sc_hd__fill_2
X_4021_ _4022_/A _4022_/B VGND VGND VPWR VPWR _4026_/A sky130_fd_sc_hd__nand2_2
XFILLER_37_301 VGND VGND VPWR VPWR sky130_fd_sc_hd__decap_3
XFILLER_49_172 VGND VGND VPWR VPWR sky130_fd_sc_hd__decap_3
XFILLER_77_470 VGND VGND VPWR VPWR sky130_fd_sc_hd__fill_1
XFILLER_92_440 VGND VGND VPWR VPWR sky130_fd_sc_hd__decap_3
XFILLER_25_529 VGND VGND VPWR VPWR sky130_fd_sc_hd__decap_3
XFILLER_37_389 VGND VGND VPWR VPWR sky130_fd_sc_hd__decap_3
X_5972_ _5972_/A _5972_/B VGND VGND VPWR VPWR _6042_/A sky130_fd_sc_hd__xnor2_2
XFILLER_33_540 VGND VGND VPWR VPWR sky130_fd_sc_hd__decap_3
XFILLER_64_197 VGND VGND VPWR VPWR sky130_fd_sc_hd__decap_3
X_4923_ _4923_/A _4923_/B VGND VGND VPWR VPWR _4923_/X sky130_fd_sc_hd__and2_2
XFILLER_33_573 VGND VGND VPWR VPWR sky130_fd_sc_hd__decap_3
XTAP_TAPCELL_ROW_63_877 VGND VPWR sky130_fd_sc_hd__tapvpwrvgnd_1
XFILLER_20_223 VGND VGND VPWR VPWR sky130_fd_sc_hd__decap_3
XFILLER_33_595 VGND VGND VPWR VPWR sky130_fd_sc_hd__decap_3
X_4854_ _4854_/A _4855_/B _4855_/C VGND VGND VPWR VPWR _4854_/Y sky130_fd_sc_hd__nor3_2
XFILLER_20_256 VGND VGND VPWR VPWR sky130_fd_sc_hd__decap_3
X_4785_ _5162_/A _4785_/B VGND VGND VPWR VPWR _4797_/A sky130_fd_sc_hd__nand2_2
X_3805_ _3806_/A _3806_/B VGND VGND VPWR VPWR _3807_/A sky130_fd_sc_hd__and2_2
X_6524_ _6522_/Y _6523_/X _6608_/S VGND VGND VPWR VPWR _6524_/X sky130_fd_sc_hd__mux2_1
X_3736_ _3667_/A _3736_/B VGND VGND VPWR VPWR _3744_/A sky130_fd_sc_hd__nand2b_2
XFILLER_9_290 VGND VGND VPWR VPWR sky130_fd_sc_hd__decap_3
X_6455_ _6453_/X _6567_/B _6589_/B VGND VGND VPWR VPWR _6455_/X sky130_fd_sc_hd__mux2_1
X_3667_ _3667_/A VGND VGND VPWR VPWR _3669_/C sky130_fd_sc_hd__inv_2
X_6386_ _6386_/A _6386_/B _6386_/C _6133_/Y VGND VGND VPWR VPWR _6386_/X sky130_fd_sc_hd__or4b_2
X_5406_ _5404_/A _5404_/C _5404_/B VGND VGND VPWR VPWR _5407_/C sky130_fd_sc_hd__o21ai_2
X_3598_ _3599_/A _3599_/B _3599_/C VGND VGND VPWR VPWR _3824_/A sky130_fd_sc_hd__o21ai_2
XFILLER_87_201 VGND VGND VPWR VPWR sky130_fd_sc_hd__decap_3
X_5337_ _5337_/A _5337_/B _5337_/C VGND VGND VPWR VPWR _5393_/B sky130_fd_sc_hd__and3_4
XFILLER_87_245 VGND VGND VPWR VPWR sky130_fd_sc_hd__fill_1
X_5268_ _5267_/Y _5269_/A _5268_/C _6501_/S VGND VGND VPWR VPWR _5269_/B sky130_fd_sc_hd__and4bb_2
XFILLER_85_18 VGND VGND VPWR VPWR sky130_fd_sc_hd__decap_3
X_4219_ _4220_/B _4220_/C _4220_/A VGND VGND VPWR VPWR _4228_/B sky130_fd_sc_hd__a21oi_2
XFILLER_28_312 VGND VGND VPWR VPWR sky130_fd_sc_hd__decap_3
X_5199_ _5142_/A _5142_/C _5142_/B VGND VGND VPWR VPWR _5200_/C sky130_fd_sc_hd__a21o_2
XFILLER_28_334 VGND VGND VPWR VPWR sky130_fd_sc_hd__decap_3
XFILLER_55_142 VGND VGND VPWR VPWR sky130_fd_sc_hd__decap_3
XFILLER_83_440 VGND VGND VPWR VPWR sky130_fd_sc_hd__decap_3
XFILLER_18_78 VGND VGND VPWR VPWR sky130_fd_sc_hd__decap_3
XFILLER_43_304 VGND VGND VPWR VPWR sky130_fd_sc_hd__decap_3
XFILLER_55_175 VGND VGND VPWR VPWR sky130_fd_sc_hd__decap_3
XFILLER_43_337 VGND VGND VPWR VPWR sky130_fd_sc_hd__decap_3
XFILLER_43_348 VGND VGND VPWR VPWR sky130_fd_sc_hd__decap_3
XFILLER_70_156 VGND VGND VPWR VPWR sky130_fd_sc_hd__decap_3
XFILLER_24_595 VGND VGND VPWR VPWR sky130_fd_sc_hd__decap_3
XFILLER_34_88 VGND VGND VPWR VPWR sky130_fd_sc_hd__decap_3
XFILLER_70_189 VGND VGND VPWR VPWR sky130_fd_sc_hd__decap_3
XFILLER_50_54 VGND VGND VPWR VPWR sky130_fd_sc_hd__decap_3
XFILLER_7_249 VGND VGND VPWR VPWR sky130_fd_sc_hd__decap_3
XFILLER_59_52 VGND VGND VPWR VPWR sky130_fd_sc_hd__decap_3
XFILLER_59_74 VGND VGND VPWR VPWR sky130_fd_sc_hd__fill_1
XFILLER_78_245 VGND VGND VPWR VPWR sky130_fd_sc_hd__decap_3
XFILLER_66_407 VGND VGND VPWR VPWR sky130_fd_sc_hd__decap_3
XFILLER_78_267 VGND VGND VPWR VPWR sky130_fd_sc_hd__decap_3
XFILLER_59_492 VGND VGND VPWR VPWR sky130_fd_sc_hd__fill_2
Xfanout280 wire282/A VGND VGND VPWR VPWR _6121_/B sky130_fd_sc_hd__clkbuf_4
Xfanout291 input58/X VGND VGND VPWR VPWR fanout291/X sky130_fd_sc_hd__buf_6
XTAP_TAPCELL_ROW_6_282 VGND VPWR sky130_fd_sc_hd__tapvpwrvgnd_1
XFILLER_19_334 VGND VGND VPWR VPWR sky130_fd_sc_hd__fill_2
XFILLER_93_248 VGND VGND VPWR VPWR sky130_fd_sc_hd__decap_3
XFILLER_46_164 VGND VGND VPWR VPWR sky130_fd_sc_hd__decap_3
XFILLER_74_473 VGND VGND VPWR VPWR sky130_fd_sc_hd__decap_3
XFILLER_75_84 VGND VGND VPWR VPWR sky130_fd_sc_hd__decap_3
XFILLER_34_337 VGND VGND VPWR VPWR sky130_fd_sc_hd__fill_1
XFILLER_34_359 VGND VGND VPWR VPWR sky130_fd_sc_hd__decap_3
XFILLER_46_197 VGND VGND VPWR VPWR sky130_fd_sc_hd__decap_3
XFILLER_61_167 VGND VGND VPWR VPWR sky130_fd_sc_hd__fill_1
XTAP_TAPCELL_ROW_60_847 VGND VPWR sky130_fd_sc_hd__tapvpwrvgnd_1
XFILLER_30_565 VGND VGND VPWR VPWR sky130_fd_sc_hd__decap_3
XTAP_TAPCELL_ROW_32_549 VGND VPWR sky130_fd_sc_hd__tapvpwrvgnd_1
XFILLER_30_587 VGND VGND VPWR VPWR sky130_fd_sc_hd__fill_1
X_4570_ _5162_/A _6248_/B _4978_/C _4978_/D VGND VGND VPWR VPWR _4570_/X sky130_fd_sc_hd__and4_2
X_3521_ _3521_/A _3521_/B VGND VGND VPWR VPWR _3527_/A sky130_fd_sc_hd__xnor2_2
X_6240_ _6212_/A _6212_/B _6383_/B _6635_/B _6238_/Y VGND VGND VPWR VPWR _6240_/X
+ sky130_fd_sc_hd__o221a_2
X_6171_ _6842_/B _6842_/C _6860_/A _6842_/A VGND VGND VPWR VPWR _6172_/B sky130_fd_sc_hd__a211o_2
XFILLER_69_234 VGND VGND VPWR VPWR sky130_fd_sc_hd__decap_3
X_5122_ _5120_/X _5122_/B VGND VGND VPWR VPWR _5238_/A sky130_fd_sc_hd__nand2b_2
XFILLER_29_109 VGND VGND VPWR VPWR sky130_fd_sc_hd__decap_3
XFILLER_57_407 VGND VGND VPWR VPWR sky130_fd_sc_hd__decap_3
XFILLER_69_267 VGND VGND VPWR VPWR sky130_fd_sc_hd__decap_3
Xload_slew664 _5680_/A VGND VGND VPWR VPWR _5778_/B sky130_fd_sc_hd__buf_4
XFILLER_84_226 VGND VGND VPWR VPWR sky130_fd_sc_hd__decap_3
X_5053_ _5311_/D _5137_/A _5311_/C _5053_/D VGND VGND VPWR VPWR _5056_/B sky130_fd_sc_hd__and4_2
XTAP_TAPCELL_ROW_68_936 VGND VPWR sky130_fd_sc_hd__tapvpwrvgnd_1
XFILLER_84_248 VGND VGND VPWR VPWR sky130_fd_sc_hd__decap_3
XFILLER_84_259 VGND VGND VPWR VPWR sky130_fd_sc_hd__decap_3
X_4004_ _3954_/Y _3992_/A _4016_/A VGND VGND VPWR VPWR _4006_/C sky130_fd_sc_hd__a21oi_2
XFILLER_25_315 VGND VGND VPWR VPWR sky130_fd_sc_hd__decap_3
XFILLER_65_473 VGND VGND VPWR VPWR sky130_fd_sc_hd__decap_3
XFILLER_80_410 VGND VGND VPWR VPWR sky130_fd_sc_hd__decap_3
XFILLER_25_337 VGND VGND VPWR VPWR sky130_fd_sc_hd__decap_3
XFILLER_80_421 VGND VGND VPWR VPWR sky130_fd_sc_hd__fill_1
XFILLER_52_156 VGND VGND VPWR VPWR sky130_fd_sc_hd__decap_3
X_5955_ _6527_/A2 _3868_/A _6456_/S _3867_/A VGND VGND VPWR VPWR _5959_/A sky130_fd_sc_hd__a22o_2
XFILLER_40_318 VGND VGND VPWR VPWR sky130_fd_sc_hd__decap_3
X_5886_ _5885_/A _5885_/C _5885_/B VGND VGND VPWR VPWR _5888_/C sky130_fd_sc_hd__a21oi_2
X_4906_ _4848_/Y _4852_/B _4904_/A _4905_/Y VGND VGND VPWR VPWR _4906_/Y sky130_fd_sc_hd__a211oi_2
X_4837_ _4836_/A _4836_/B _4836_/C VGND VGND VPWR VPWR _4838_/B sky130_fd_sc_hd__a21oi_2
X_4768_ _4767_/A _4767_/C _4767_/D _4767_/B VGND VGND VPWR VPWR _4769_/C sky130_fd_sc_hd__a22o_2
X_6507_ _6485_/Y _6486_/X _6487_/Y _6129_/X VGND VGND VPWR VPWR _6512_/B sky130_fd_sc_hd__a22o_2
X_4699_ _4669_/A _4669_/C _4669_/B VGND VGND VPWR VPWR _4700_/C sky130_fd_sc_hd__o21ai_2
X_3719_ _4165_/A _4767_/C _4767_/D _3757_/A VGND VGND VPWR VPWR _3720_/D sky130_fd_sc_hd__a22o_2
XFILLER_20_57 VGND VGND VPWR VPWR sky130_fd_sc_hd__fill_2
X_6438_ _6586_/A _6438_/B VGND VGND VPWR VPWR _6438_/Y sky130_fd_sc_hd__nand2_2
X_6369_ _6369_/A _6393_/B VGND VGND VPWR VPWR _6369_/Y sky130_fd_sc_hd__nor2_2
XFILLER_0_447 VGND VGND VPWR VPWR sky130_fd_sc_hd__fill_1
XFILLER_0_458 VGND VGND VPWR VPWR sky130_fd_sc_hd__decap_3
XFILLER_29_22 VGND VGND VPWR VPWR sky130_fd_sc_hd__fill_1
XFILLER_48_418 VGND VGND VPWR VPWR sky130_fd_sc_hd__fill_2
XFILLER_88_554 VGND VGND VPWR VPWR sky130_fd_sc_hd__decap_3
XFILLER_29_77 VGND VGND VPWR VPWR sky130_fd_sc_hd__decap_3
XFILLER_56_440 VGND VGND VPWR VPWR sky130_fd_sc_hd__decap_3
XTAP_TAPCELL_ROW_89_1149 VGND VPWR sky130_fd_sc_hd__tapvpwrvgnd_1
XTAP_TAPCELL_ROW_3_252 VGND VPWR sky130_fd_sc_hd__tapvpwrvgnd_1
XFILLER_28_164 VGND VGND VPWR VPWR sky130_fd_sc_hd__decap_3
XFILLER_90_218 VGND VGND VPWR VPWR sky130_fd_sc_hd__decap_3
XFILLER_16_326 VGND VGND VPWR VPWR sky130_fd_sc_hd__decap_3
XFILLER_28_197 VGND VGND VPWR VPWR sky130_fd_sc_hd__fill_1
XFILLER_71_421 VGND VGND VPWR VPWR sky130_fd_sc_hd__decap_3
XFILLER_83_270 VGND VGND VPWR VPWR sky130_fd_sc_hd__decap_3
XFILLER_83_281 VGND VGND VPWR VPWR sky130_fd_sc_hd__decap_3
XFILLER_16_359 VGND VGND VPWR VPWR sky130_fd_sc_hd__decap_3
XFILLER_45_76 VGND VGND VPWR VPWR sky130_fd_sc_hd__decap_3
XFILLER_12_510 VGND VGND VPWR VPWR sky130_fd_sc_hd__fill_1
XFILLER_31_318 VGND VGND VPWR VPWR sky130_fd_sc_hd__fill_2
XFILLER_61_20 VGND VGND VPWR VPWR sky130_fd_sc_hd__fill_2
XFILLER_12_576 VGND VGND VPWR VPWR sky130_fd_sc_hd__fill_2
XFILLER_61_64 VGND VGND VPWR VPWR sky130_fd_sc_hd__decap_3
XFILLER_61_75 VGND VGND VPWR VPWR sky130_fd_sc_hd__decap_3
XFILLER_8_547 VGND VGND VPWR VPWR sky130_fd_sc_hd__fill_1
XFILLER_79_521 VGND VGND VPWR VPWR sky130_fd_sc_hd__decap_3
XFILLER_94_502 VGND VGND VPWR VPWR sky130_fd_sc_hd__decap_3
XFILLER_86_83 VGND VGND VPWR VPWR sky130_fd_sc_hd__fill_1
XFILLER_13_6 VGND VGND VPWR VPWR sky130_fd_sc_hd__fill_1
XFILLER_19_120 VGND VGND VPWR VPWR sky130_fd_sc_hd__decap_3
XFILLER_66_248 VGND VGND VPWR VPWR sky130_fd_sc_hd__decap_3
XFILLER_86_94 VGND VGND VPWR VPWR sky130_fd_sc_hd__decap_3
XFILLER_94_568 VGND VGND VPWR VPWR sky130_fd_sc_hd__fill_1
XFILLER_19_164 VGND VGND VPWR VPWR sky130_fd_sc_hd__decap_3
XTAP_TAPCELL_ROW_37_608 VGND VPWR sky130_fd_sc_hd__tapvpwrvgnd_1
XFILLER_62_421 VGND VGND VPWR VPWR sky130_fd_sc_hd__decap_3
XFILLER_74_281 VGND VGND VPWR VPWR sky130_fd_sc_hd__decap_3
XFILLER_22_307 VGND VGND VPWR VPWR sky130_fd_sc_hd__fill_1
XFILLER_15_370 VGND VGND VPWR VPWR sky130_fd_sc_hd__decap_3
X_5740_ _5740_/A _5740_/B _5740_/C VGND VGND VPWR VPWR _5743_/A sky130_fd_sc_hd__and3_4
XTAP_TAPCELL_ROW_73_983 VGND VPWR sky130_fd_sc_hd__tapvpwrvgnd_1
XTAP_TAPCELL_ROW_45_685 VGND VPWR sky130_fd_sc_hd__tapvpwrvgnd_1
XTAP_TAPCELL_ROW_17_398 VGND VPWR sky130_fd_sc_hd__tapvpwrvgnd_1
X_5671_ _5670_/B _5670_/C _5670_/A VGND VGND VPWR VPWR _5672_/C sky130_fd_sc_hd__o21bai_2
X_4622_ _4485_/B _4485_/C _4485_/A VGND VGND VPWR VPWR _4623_/C sky130_fd_sc_hd__o21ai_2
X_4553_ _4554_/A _4554_/B _4554_/C VGND VGND VPWR VPWR _4553_/X sky130_fd_sc_hd__and3_2
X_4484_ _4355_/A _4482_/C _4482_/D _4482_/B VGND VGND VPWR VPWR _4485_/C sky130_fd_sc_hd__a22oi_2
X_3504_ _3867_/A VGND VGND VPWR VPWR _6286_/B sky130_fd_sc_hd__inv_2
X_6223_ _6381_/D _6223_/B VGND VGND VPWR VPWR _6467_/A sky130_fd_sc_hd__and2_2
X_6154_ _6709_/A _6727_/A VGND VGND VPWR VPWR _6155_/D sky130_fd_sc_hd__or2_2
Xload_slew450 _4589_/B VGND VGND VPWR VPWR _4989_/B sky130_fd_sc_hd__buf_4
X_6085_ _6266_/A _6085_/B VGND VGND VPWR VPWR _6809_/A sky130_fd_sc_hd__or2_2
X_5105_ _5241_/A _5241_/B VGND VGND VPWR VPWR _5108_/B sky130_fd_sc_hd__or2_4
XFILLER_57_237 VGND VGND VPWR VPWR sky130_fd_sc_hd__decap_3
XFILLER_57_259 VGND VGND VPWR VPWR sky130_fd_sc_hd__decap_3
X_5036_ _5035_/B _5035_/C _5035_/A VGND VGND VPWR VPWR _5038_/B sky130_fd_sc_hd__o21bai_2
XFILLER_72_218 VGND VGND VPWR VPWR sky130_fd_sc_hd__decap_3
XTAP_TAPCELL_ROW_0_211 VGND VPWR sky130_fd_sc_hd__tapvpwrvgnd_1
XPHY_EDGE_ROW_69_Left_170 VGND VGND VPWR VPWR sky130_fd_sc_hd__decap_3
XFILLER_53_421 VGND VGND VPWR VPWR sky130_fd_sc_hd__decap_3
XFILLER_65_281 VGND VGND VPWR VPWR sky130_fd_sc_hd__decap_3
XTAP_TAPCELL_ROW_0_222 VGND VPWR sky130_fd_sc_hd__tapvpwrvgnd_1
XFILLER_93_590 VGND VGND VPWR VPWR sky130_fd_sc_hd__decap_3
XFILLER_25_134 VGND VGND VPWR VPWR sky130_fd_sc_hd__decap_3
X_6987_ _6987_/A _6987_/B _6987_/C _6987_/D VGND VGND VPWR VPWR _6987_/Y sky130_fd_sc_hd__nor4_4
XFILLER_15_57 VGND VGND VPWR VPWR sky130_fd_sc_hd__decap_3
XFILLER_40_126 VGND VGND VPWR VPWR sky130_fd_sc_hd__decap_3
X_5938_ _4567_/A _4567_/B _5939_/B VGND VGND VPWR VPWR _5938_/X sky130_fd_sc_hd__o21ba_2
XFILLER_15_79 VGND VGND VPWR VPWR sky130_fd_sc_hd__decap_3
XFILLER_21_340 VGND VGND VPWR VPWR sky130_fd_sc_hd__fill_2
X_5869_ _5862_/Y _5866_/X _5869_/B1 _5869_/C1 VGND VGND VPWR VPWR _5871_/D sky130_fd_sc_hd__a211oi_2
Xrebuffer699 _4855_/A VGND VGND VPWR VPWR _4854_/A sky130_fd_sc_hd__buf_2
Xrebuffer688 _5468_/X VGND VGND VPWR VPWR _5869_/B1 sky130_fd_sc_hd__buf_2
Xrebuffer677 _5877_/X VGND VGND VPWR VPWR _6873_/A2 sky130_fd_sc_hd__buf_2
XTAP_TAPCELL_ROW_8_300 VGND VPWR sky130_fd_sc_hd__tapvpwrvgnd_1
Xoutput89 output89/A VGND VGND VPWR VPWR result[26] sky130_fd_sc_hd__buf_6
Xoutput78 _6989_/C VGND VGND VPWR VPWR result[16] sky130_fd_sc_hd__dlymetal6s2s_1
XFILLER_0_266 VGND VGND VPWR VPWR sky130_fd_sc_hd__decap_3
XFILLER_76_524 VGND VGND VPWR VPWR sky130_fd_sc_hd__fill_2
XFILLER_88_362 VGND VGND VPWR VPWR sky130_fd_sc_hd__fill_2
XFILLER_0_299 VGND VGND VPWR VPWR sky130_fd_sc_hd__decap_3
XFILLER_48_248 VGND VGND VPWR VPWR sky130_fd_sc_hd__decap_3
XFILLER_63_218 VGND VGND VPWR VPWR sky130_fd_sc_hd__decap_3
XFILLER_76_579 VGND VGND VPWR VPWR sky130_fd_sc_hd__fill_1
XFILLER_91_505 VGND VGND VPWR VPWR sky130_fd_sc_hd__decap_3
XFILLER_16_112 VGND VGND VPWR VPWR sky130_fd_sc_hd__decap_3
XFILLER_44_421 VGND VGND VPWR VPWR sky130_fd_sc_hd__decap_3
XFILLER_91_538 VGND VGND VPWR VPWR sky130_fd_sc_hd__decap_3
XFILLER_71_240 VGND VGND VPWR VPWR sky130_fd_sc_hd__decap_3
XFILLER_16_167 VGND VGND VPWR VPWR sky130_fd_sc_hd__decap_3
XFILLER_44_487 VGND VGND VPWR VPWR sky130_fd_sc_hd__fill_1
XFILLER_71_273 VGND VGND VPWR VPWR sky130_fd_sc_hd__decap_3
XFILLER_71_284 VGND VGND VPWR VPWR sky130_fd_sc_hd__decap_3
XFILLER_72_52 VGND VGND VPWR VPWR sky130_fd_sc_hd__decap_3
XTAP_TAPCELL_ROW_70_953 VGND VPWR sky130_fd_sc_hd__tapvpwrvgnd_1
XTAP_TAPCELL_ROW_42_655 VGND VPWR sky130_fd_sc_hd__tapvpwrvgnd_1
XTAP_TAPCELL_ROW_14_368 VGND VPWR sky130_fd_sc_hd__tapvpwrvgnd_1
XFILLER_8_399 VGND VGND VPWR VPWR sky130_fd_sc_hd__decap_3
XFILLER_4_561 VGND VGND VPWR VPWR sky130_fd_sc_hd__decap_3
XFILLER_79_340 VGND VGND VPWR VPWR sky130_fd_sc_hd__decap_3
XFILLER_79_373 VGND VGND VPWR VPWR sky130_fd_sc_hd__decap_3
XFILLER_11_3 VGND VGND VPWR VPWR sky130_fd_sc_hd__decap_3
XFILLER_39_237 VGND VGND VPWR VPWR sky130_fd_sc_hd__decap_3
XFILLER_67_535 VGND VGND VPWR VPWR sky130_fd_sc_hd__decap_3
XFILLER_67_546 VGND VGND VPWR VPWR sky130_fd_sc_hd__decap_3
XFILLER_94_321 VGND VGND VPWR VPWR sky130_fd_sc_hd__decap_3
XFILLER_82_516 VGND VGND VPWR VPWR sky130_fd_sc_hd__decap_3
XFILLER_94_387 VGND VGND VPWR VPWR sky130_fd_sc_hd__decap_3
XFILLER_94_365 VGND VGND VPWR VPWR sky130_fd_sc_hd__decap_3
XFILLER_35_421 VGND VGND VPWR VPWR sky130_fd_sc_hd__fill_1
XFILLER_47_270 VGND VGND VPWR VPWR sky130_fd_sc_hd__decap_3
XFILLER_47_281 VGND VGND VPWR VPWR sky130_fd_sc_hd__decap_3
XFILLER_75_590 VGND VGND VPWR VPWR sky130_fd_sc_hd__decap_3
X_6910_ _6847_/X _6909_/X _6976_/S VGND VGND VPWR VPWR _6910_/X sky130_fd_sc_hd__mux2_1
XFILLER_35_465 VGND VGND VPWR VPWR sky130_fd_sc_hd__fill_1
XFILLER_62_251 VGND VGND VPWR VPWR sky130_fd_sc_hd__fill_1
X_6841_ _6841_/A _6841_/B _6841_/C VGND VGND VPWR VPWR _6854_/B sky130_fd_sc_hd__nor3_2
XFILLER_22_115 VGND VGND VPWR VPWR sky130_fd_sc_hd__decap_3
XFILLER_50_402 VGND VGND VPWR VPWR sky130_fd_sc_hd__fill_1
XFILLER_62_262 VGND VGND VPWR VPWR sky130_fd_sc_hd__decap_3
XFILLER_62_284 VGND VGND VPWR VPWR sky130_fd_sc_hd__decap_3
X_6772_ _6819_/A2 _6758_/Y _6759_/X _6771_/X _6757_/X VGND VGND VPWR VPWR _6772_/Y
+ sky130_fd_sc_hd__a311oi_2
X_3984_ _3984_/A _3984_/B _3984_/C VGND VGND VPWR VPWR _3986_/A sky130_fd_sc_hd__and3_2
XTAP_TAPCELL_ROW_83_1090 VGND VPWR sky130_fd_sc_hd__tapvpwrvgnd_1
XFILLER_22_159 VGND VGND VPWR VPWR sky130_fd_sc_hd__decap_3
X_5723_ _5703_/A _5703_/C _5703_/B VGND VGND VPWR VPWR _5732_/B sky130_fd_sc_hd__o21ai_2
X_5654_ _5654_/A _5654_/B VGND VGND VPWR VPWR _5685_/A sky130_fd_sc_hd__xnor2_2
X_4605_ _4605_/A _4605_/B VGND VGND VPWR VPWR _4615_/A sky130_fd_sc_hd__xnor2_2
XFILLER_7_91 VGND VGND VPWR VPWR sky130_fd_sc_hd__fill_1
X_5585_ _6219_/A _5585_/B VGND VGND VPWR VPWR _5585_/Y sky130_fd_sc_hd__nand2_2
XFILLER_89_104 VGND VGND VPWR VPWR sky130_fd_sc_hd__decap_3
X_4536_ _4536_/A _4536_/B VGND VGND VPWR VPWR _4549_/A sky130_fd_sc_hd__nor2_2
X_4467_ _4888_/A _4468_/B VGND VGND VPWR VPWR _4469_/A sky130_fd_sc_hd__or2_2
X_6206_ _6196_/A _5956_/B _6205_/Y _6073_/A VGND VGND VPWR VPWR _6206_/X sky130_fd_sc_hd__o22a_2
X_4398_ _4398_/A VGND VGND VPWR VPWR _4398_/Y sky130_fd_sc_hd__inv_2
XFILLER_85_310 VGND VGND VPWR VPWR sky130_fd_sc_hd__fill_1
X_6137_ _6381_/A _6137_/B VGND VGND VPWR VPWR _6138_/B sky130_fd_sc_hd__or2_2
XFILLER_85_332 VGND VGND VPWR VPWR sky130_fd_sc_hd__decap_3
XFILLER_85_343 VGND VGND VPWR VPWR sky130_fd_sc_hd__decap_3
XFILLER_58_579 VGND VGND VPWR VPWR sky130_fd_sc_hd__fill_1
XFILLER_73_505 VGND VGND VPWR VPWR sky130_fd_sc_hd__fill_2
X_6068_ _6286_/A _6068_/B VGND VGND VPWR VPWR _6977_/A sky130_fd_sc_hd__or2_2
XTAP_TAPCELL_ROW_86_1119 VGND VPWR sky130_fd_sc_hd__tapvpwrvgnd_1
XFILLER_26_421 VGND VGND VPWR VPWR sky130_fd_sc_hd__decap_3
XFILLER_73_549 VGND VGND VPWR VPWR sky130_fd_sc_hd__decap_3
XFILLER_85_387 VGND VGND VPWR VPWR sky130_fd_sc_hd__decap_3
X_5019_ _5019_/A _5019_/B _5420_/A VGND VGND VPWR VPWR _5240_/A sky130_fd_sc_hd__or3_2
XFILLER_26_454 VGND VGND VPWR VPWR sky130_fd_sc_hd__decap_3
XFILLER_26_56 VGND VGND VPWR VPWR sky130_fd_sc_hd__decap_3
XFILLER_41_413 VGND VGND VPWR VPWR sky130_fd_sc_hd__decap_3
XFILLER_53_273 VGND VGND VPWR VPWR sky130_fd_sc_hd__decap_3
XFILLER_13_159 VGND VGND VPWR VPWR sky130_fd_sc_hd__decap_3
XFILLER_9_119 VGND VGND VPWR VPWR sky130_fd_sc_hd__decap_3
XFILLER_5_303 VGND VGND VPWR VPWR sky130_fd_sc_hd__fill_1
XTAP_TAPCELL_ROW_97_1237 VGND VPWR sky130_fd_sc_hd__tapvpwrvgnd_1
XFILLER_3_27 VGND VGND VPWR VPWR sky130_fd_sc_hd__decap_3
XFILLER_1_564 VGND VGND VPWR VPWR sky130_fd_sc_hd__decap_3
XFILLER_67_41 VGND VGND VPWR VPWR sky130_fd_sc_hd__decap_3
XFILLER_76_321 VGND VGND VPWR VPWR sky130_fd_sc_hd__decap_3
XFILLER_76_343 VGND VGND VPWR VPWR sky130_fd_sc_hd__fill_2
XFILLER_88_192 VGND VGND VPWR VPWR sky130_fd_sc_hd__decap_3
XFILLER_64_516 VGND VGND VPWR VPWR sky130_fd_sc_hd__decap_3
XFILLER_67_85 VGND VGND VPWR VPWR sky130_fd_sc_hd__decap_3
XFILLER_76_354 VGND VGND VPWR VPWR sky130_fd_sc_hd__decap_3
XFILLER_76_365 VGND VGND VPWR VPWR sky130_fd_sc_hd__decap_3
XTAP_TAPCELL_ROW_47_714 VGND VPWR sky130_fd_sc_hd__tapvpwrvgnd_1
XFILLER_29_270 VGND VGND VPWR VPWR sky130_fd_sc_hd__decap_3
XFILLER_29_281 VGND VGND VPWR VPWR sky130_fd_sc_hd__fill_2
XFILLER_91_324 VGND VGND VPWR VPWR sky130_fd_sc_hd__decap_3
XTAP_TAPCELL_ROW_19_416 VGND VPWR sky130_fd_sc_hd__tapvpwrvgnd_1
XFILLER_17_443 VGND VGND VPWR VPWR sky130_fd_sc_hd__decap_3
XFILLER_91_346 VGND VGND VPWR VPWR sky130_fd_sc_hd__decap_3
XFILLER_91_379 VGND VGND VPWR VPWR sky130_fd_sc_hd__decap_3
XFILLER_17_476 VGND VGND VPWR VPWR sky130_fd_sc_hd__decap_3
XTAP_TAPCELL_ROW_55_791 VGND VPWR sky130_fd_sc_hd__tapvpwrvgnd_1
XFILLER_80_6 VGND VGND VPWR VPWR sky130_fd_sc_hd__fill_2
XFILLER_8_141 VGND VGND VPWR VPWR sky130_fd_sc_hd__fill_2
XFILLER_8_163 VGND VGND VPWR VPWR sky130_fd_sc_hd__decap_3
XFILLER_59_3 VGND VGND VPWR VPWR sky130_fd_sc_hd__decap_3
X_5370_ _5370_/A _5370_/B _5370_/C VGND VGND VPWR VPWR _5409_/A sky130_fd_sc_hd__and3_2
XFILLER_99_402 VGND VGND VPWR VPWR sky130_fd_sc_hd__decap_3
X_4321_ _4321_/A _4321_/B VGND VGND VPWR VPWR _4323_/B sky130_fd_sc_hd__nor2_2
X_4252_ _4225_/A _4225_/B _4348_/A VGND VGND VPWR VPWR _4253_/D sky130_fd_sc_hd__o21ai_2
XFILLER_99_479 VGND VGND VPWR VPWR sky130_fd_sc_hd__fill_2
XFILLER_86_118 VGND VGND VPWR VPWR sky130_fd_sc_hd__decap_3
XFILLER_67_332 VGND VGND VPWR VPWR sky130_fd_sc_hd__decap_3
X_4183_ _4184_/A _4182_/Y _6263_/B _4539_/B VGND VGND VPWR VPWR _4299_/A sky130_fd_sc_hd__and4bb_2
XFILLER_27_207 VGND VGND VPWR VPWR sky130_fd_sc_hd__fill_1
XFILLER_55_505 VGND VGND VPWR VPWR sky130_fd_sc_hd__decap_3
XFILLER_82_302 VGND VGND VPWR VPWR sky130_fd_sc_hd__decap_3
XFILLER_94_195 VGND VGND VPWR VPWR sky130_fd_sc_hd__fill_1
XFILLER_82_368 VGND VGND VPWR VPWR sky130_fd_sc_hd__decap_3
XFILLER_23_424 VGND VGND VPWR VPWR sky130_fd_sc_hd__fill_1
XFILLER_23_435 VGND VGND VPWR VPWR sky130_fd_sc_hd__decap_3
XFILLER_23_457 VGND VGND VPWR VPWR sky130_fd_sc_hd__decap_3
XFILLER_35_284 VGND VGND VPWR VPWR sky130_fd_sc_hd__decap_3
XFILLER_63_593 VGND VGND VPWR VPWR sky130_fd_sc_hd__decap_3
X_6824_ _6087_/A _6824_/A2 _6261_/C _6203_/X VGND VGND VPWR VPWR _6825_/B sky130_fd_sc_hd__a31o_2
XFILLER_50_265 VGND VGND VPWR VPWR sky130_fd_sc_hd__decap_3
X_6755_ _6754_/B _6754_/C _6754_/A VGND VGND VPWR VPWR _6755_/Y sky130_fd_sc_hd__a21oi_2
X_3967_ _3895_/A _3894_/B _3894_/A VGND VGND VPWR VPWR _4023_/B sky130_fd_sc_hd__o21ba_2
X_5706_ _5705_/A _5705_/B _5705_/C VGND VGND VPWR VPWR _5707_/D sky130_fd_sc_hd__a21o_2
X_6686_ _5688_/Y _5815_/X _6686_/A3 _5817_/B VGND VGND VPWR VPWR _6687_/B sky130_fd_sc_hd__a31o_2
X_3898_ _5993_/B _5992_/A _3789_/B _3788_/A VGND VGND VPWR VPWR _4031_/B sky130_fd_sc_hd__a31o_2
X_5637_ _5636_/A _6401_/S _5716_/A _5636_/D VGND VGND VPWR VPWR _5638_/C sky130_fd_sc_hd__a22o_2
X_5568_ _5518_/Y _5522_/X _5564_/Y _5566_/Y VGND VGND VPWR VPWR _5568_/Y sky130_fd_sc_hd__a211oi_2
XFILLER_88_29 VGND VGND VPWR VPWR sky130_fd_sc_hd__fill_1
X_4519_ _4662_/B _4517_/C _4517_/D _4659_/A VGND VGND VPWR VPWR _4520_/B sky130_fd_sc_hd__a22o_2
X_5499_ _6109_/A _5536_/B _5527_/B _5496_/X VGND VGND VPWR VPWR _5501_/A sky130_fd_sc_hd__a31o_2
XTAP_TAPCELL_ROW_92_1178 VGND VPWR sky130_fd_sc_hd__tapvpwrvgnd_1
Xfanout610 _6187_/B VGND VGND VPWR VPWR _4432_/A sky130_fd_sc_hd__clkdlybuf4s25_1
XFILLER_58_321 VGND VGND VPWR VPWR sky130_fd_sc_hd__fill_1
Xfanout654 input10/X VGND VGND VPWR VPWR _4538_/A sky130_fd_sc_hd__clkdlybuf4s25_1
Xfanout665 _6373_/A VGND VGND VPWR VPWR _5777_/A sky130_fd_sc_hd__buf_6
XFILLER_46_505 VGND VGND VPWR VPWR sky130_fd_sc_hd__decap_3
XFILLER_58_354 VGND VGND VPWR VPWR sky130_fd_sc_hd__fill_1
XFILLER_85_151 VGND VGND VPWR VPWR sky130_fd_sc_hd__decap_3
XFILLER_100_473 VGND VGND VPWR VPWR sky130_fd_sc_hd__decap_3
XFILLER_100_495 VGND VGND VPWR VPWR sky130_fd_sc_hd__decap_3
XFILLER_37_44 VGND VGND VPWR VPWR sky130_fd_sc_hd__decap_3
XFILLER_37_66 VGND VGND VPWR VPWR sky130_fd_sc_hd__decap_3
XFILLER_73_324 VGND VGND VPWR VPWR sky130_fd_sc_hd__decap_3
XFILLER_14_402 VGND VGND VPWR VPWR sky130_fd_sc_hd__decap_3
XFILLER_26_273 VGND VGND VPWR VPWR sky130_fd_sc_hd__decap_3
XFILLER_54_571 VGND VGND VPWR VPWR sky130_fd_sc_hd__decap_3
XFILLER_73_379 VGND VGND VPWR VPWR sky130_fd_sc_hd__decap_3
XFILLER_53_21 VGND VGND VPWR VPWR sky130_fd_sc_hd__fill_1
XFILLER_53_54 VGND VGND VPWR VPWR sky130_fd_sc_hd__fill_2
XFILLER_14_457 VGND VGND VPWR VPWR sky130_fd_sc_hd__decap_3
XTAP_TAPCELL_ROW_52_761 VGND VPWR sky130_fd_sc_hd__tapvpwrvgnd_1
XFILLER_41_287 VGND VGND VPWR VPWR sky130_fd_sc_hd__fill_1
XFILLER_41_298 VGND VGND VPWR VPWR sky130_fd_sc_hd__decap_3
XTAP_TAPCELL_ROW_24_474 VGND VPWR sky130_fd_sc_hd__tapvpwrvgnd_1
XFILLER_5_111 VGND VGND VPWR VPWR sky130_fd_sc_hd__fill_1
XFILLER_5_166 VGND VGND VPWR VPWR sky130_fd_sc_hd__fill_2
XFILLER_1_350 VGND VGND VPWR VPWR sky130_fd_sc_hd__decap_3
XFILLER_78_73 VGND VGND VPWR VPWR sky130_fd_sc_hd__decap_3
XFILLER_96_427 VGND VGND VPWR VPWR sky130_fd_sc_hd__decap_3
XFILLER_49_332 VGND VGND VPWR VPWR sky130_fd_sc_hd__decap_3
XFILLER_37_505 VGND VGND VPWR VPWR sky130_fd_sc_hd__decap_3
XFILLER_49_343 VGND VGND VPWR VPWR sky130_fd_sc_hd__decap_3
XFILLER_49_376 VGND VGND VPWR VPWR sky130_fd_sc_hd__decap_3
XFILLER_64_302 VGND VGND VPWR VPWR sky130_fd_sc_hd__decap_3
XFILLER_64_324 VGND VGND VPWR VPWR sky130_fd_sc_hd__decap_3
XFILLER_76_162 VGND VGND VPWR VPWR sky130_fd_sc_hd__decap_3
XFILLER_64_357 VGND VGND VPWR VPWR sky130_fd_sc_hd__decap_3
XFILLER_91_187 VGND VGND VPWR VPWR sky130_fd_sc_hd__decap_3
XFILLER_17_284 VGND VGND VPWR VPWR sky130_fd_sc_hd__fill_2
XFILLER_32_210 VGND VGND VPWR VPWR sky130_fd_sc_hd__fill_2
XFILLER_72_390 VGND VGND VPWR VPWR sky130_fd_sc_hd__decap_3
X_4870_ _4870_/A _4870_/B _4870_/C VGND VGND VPWR VPWR _4871_/A sky130_fd_sc_hd__and3_2
XFILLER_32_243 VGND VGND VPWR VPWR sky130_fd_sc_hd__decap_3
X_3821_ _3821_/A _3821_/B _3821_/C VGND VGND VPWR VPWR _3822_/B sky130_fd_sc_hd__or3_2
XFILLER_20_438 VGND VGND VPWR VPWR sky130_fd_sc_hd__decap_3
XFILLER_60_585 VGND VGND VPWR VPWR sky130_fd_sc_hd__decap_3
X_6540_ _6540_/A _6540_/B _6540_/C _6540_/D VGND VGND VPWR VPWR _6985_/D sky130_fd_sc_hd__or4_4
XTAP_TAPCELL_ROW_80_1060 VGND VPWR sky130_fd_sc_hd__tapvpwrvgnd_1
X_3752_ _4280_/B _4659_/B _3751_/B _3748_/X VGND VGND VPWR VPWR _3754_/B sky130_fd_sc_hd__a31o_2
XFILLER_9_461 VGND VGND VPWR VPWR sky130_fd_sc_hd__fill_2
X_6471_ _6381_/D _6127_/X _6470_/Y VGND VGND VPWR VPWR _6471_/X sky130_fd_sc_hd__a21o_2
X_3683_ _3683_/A _3683_/B VGND VGND VPWR VPWR _3690_/B sky130_fd_sc_hd__xnor2_2
X_5422_ _5296_/B _5296_/C _5296_/A VGND VGND VPWR VPWR _5425_/A sky130_fd_sc_hd__a21bo_4
X_5353_ _5473_/A _5428_/B _5353_/C VGND VGND VPWR VPWR _5355_/B sky130_fd_sc_hd__nand3_2
X_4304_ _4304_/A _4304_/B _4305_/B VGND VGND VPWR VPWR _4304_/X sky130_fd_sc_hd__or3_2
XFILLER_59_107 VGND VGND VPWR VPWR sky130_fd_sc_hd__decap_3
XFILLER_87_405 VGND VGND VPWR VPWR sky130_fd_sc_hd__decap_3
X_5284_ _5395_/A _5284_/B _5360_/B VGND VGND VPWR VPWR _5287_/C sky130_fd_sc_hd__and3_2
XFILLER_99_265 VGND VGND VPWR VPWR sky130_fd_sc_hd__decap_3
XFILLER_4_81 VGND VGND VPWR VPWR sky130_fd_sc_hd__decap_3
XFILLER_87_438 VGND VGND VPWR VPWR sky130_fd_sc_hd__decap_3
XFILLER_87_449 VGND VGND VPWR VPWR sky130_fd_sc_hd__fill_1
X_4235_ _4617_/A _4476_/B _4234_/B _4231_/X VGND VGND VPWR VPWR _4237_/B sky130_fd_sc_hd__a31o_2
X_4166_ _4280_/B _4406_/C _4406_/D _4282_/A VGND VGND VPWR VPWR _4167_/C sky130_fd_sc_hd__a22oi_2
XFILLER_67_184 VGND VGND VPWR VPWR sky130_fd_sc_hd__decap_3
XFILLER_55_335 VGND VGND VPWR VPWR sky130_fd_sc_hd__fill_1
XFILLER_55_346 VGND VGND VPWR VPWR sky130_fd_sc_hd__decap_3
X_4097_ _4476_/A _4097_/B VGND VGND VPWR VPWR _4210_/A sky130_fd_sc_hd__nand2_2
XFILLER_43_519 VGND VGND VPWR VPWR sky130_fd_sc_hd__decap_3
XFILLER_70_305 VGND VGND VPWR VPWR sky130_fd_sc_hd__decap_3
XFILLER_82_176 VGND VGND VPWR VPWR sky130_fd_sc_hd__decap_3
XFILLER_23_243 VGND VGND VPWR VPWR sky130_fd_sc_hd__decap_3
X_6807_ _6807_/A _6807_/B VGND VGND VPWR VPWR _6807_/Y sky130_fd_sc_hd__nand2_2
XFILLER_23_276 VGND VGND VPWR VPWR sky130_fd_sc_hd__decap_3
XFILLER_23_287 VGND VGND VPWR VPWR sky130_fd_sc_hd__decap_3
X_4999_ _4834_/D _4834_/B _4834_/C _4834_/A VGND VGND VPWR VPWR _4999_/X sky130_fd_sc_hd__o22a_2
XFILLER_11_449 VGND VGND VPWR VPWR sky130_fd_sc_hd__decap_3
XFILLER_23_57 VGND VGND VPWR VPWR sky130_fd_sc_hd__decap_3
X_6738_ _6739_/A _6739_/B VGND VGND VPWR VPWR _6754_/C sky130_fd_sc_hd__or2_2
XTAP_TAPCELL_ROW_21_433 VGND VPWR sky130_fd_sc_hd__tapvpwrvgnd_1
X_6669_ _5688_/Y _5815_/X _6686_/A3 _6777_/A VGND VGND VPWR VPWR _6669_/X sky130_fd_sc_hd__a31o_2
XTAP_TAPCELL_ROW_94_1207 VGND VPWR sky130_fd_sc_hd__tapvpwrvgnd_1
XFILLER_78_427 VGND VGND VPWR VPWR sky130_fd_sc_hd__fill_1
Xfanout440 _6016_/A VGND VGND VPWR VPWR _6106_/B sky130_fd_sc_hd__buf_6
XFILLER_93_408 VGND VGND VPWR VPWR sky130_fd_sc_hd__decap_3
Xfanout451 _6492_/S0 VGND VGND VPWR VPWR _4900_/B sky130_fd_sc_hd__clkdlybuf4s25_1
Xfanout473 fanout475/X VGND VGND VPWR VPWR _6673_/A3 sky130_fd_sc_hd__clkdlybuf4s25_1
XFILLER_19_516 VGND VGND VPWR VPWR sky130_fd_sc_hd__decap_3
XTAP_TAPCELL_ROW_57_820 VGND VPWR sky130_fd_sc_hd__tapvpwrvgnd_1
XFILLER_100_281 VGND VGND VPWR VPWR sky130_fd_sc_hd__decap_3
XFILLER_34_508 VGND VGND VPWR VPWR sky130_fd_sc_hd__decap_3
XFILLER_58_195 VGND VGND VPWR VPWR sky130_fd_sc_hd__fill_1
XTAP_TAPCELL_ROW_29_522 VGND VPWR sky130_fd_sc_hd__tapvpwrvgnd_1
XFILLER_61_316 VGND VGND VPWR VPWR sky130_fd_sc_hd__decap_3
XFILLER_73_165 VGND VGND VPWR VPWR sky130_fd_sc_hd__decap_3
XPHY_EDGE_ROW_14_Left_115 VGND VGND VPWR VPWR sky130_fd_sc_hd__decap_3
XFILLER_73_187 VGND VGND VPWR VPWR sky130_fd_sc_hd__decap_3
XFILLER_14_265 VGND VGND VPWR VPWR sky130_fd_sc_hd__fill_2
XFILLER_9_26 VGND VGND VPWR VPWR sky130_fd_sc_hd__decap_3
XFILLER_14_276 VGND VGND VPWR VPWR sky130_fd_sc_hd__decap_3
XFILLER_80_63 VGND VGND VPWR VPWR sky130_fd_sc_hd__decap_3
XFILLER_80_85 VGND VGND VPWR VPWR sky130_fd_sc_hd__decap_3
XFILLER_6_486 VGND VGND VPWR VPWR sky130_fd_sc_hd__decap_3
XPHY_EDGE_ROW_23_Left_124 VGND VGND VPWR VPWR sky130_fd_sc_hd__decap_3
XFILLER_96_246 VGND VGND VPWR VPWR sky130_fd_sc_hd__decap_3
X_4020_ _4020_/A _4020_/B VGND VGND VPWR VPWR _4022_/B sky130_fd_sc_hd__xnor2_2
XFILLER_37_313 VGND VGND VPWR VPWR sky130_fd_sc_hd__fill_2
XPHY_EDGE_ROW_32_Left_133 VGND VGND VPWR VPWR sky130_fd_sc_hd__decap_3
XFILLER_25_508 VGND VGND VPWR VPWR sky130_fd_sc_hd__fill_2
XFILLER_64_176 VGND VGND VPWR VPWR sky130_fd_sc_hd__decap_3
X_5971_ _5971_/A _5971_/B VGND VGND VPWR VPWR _5972_/B sky130_fd_sc_hd__xnor2_2
X_4922_ _4922_/A _4922_/B VGND VGND VPWR VPWR _4940_/A sky130_fd_sc_hd__nor2_2
XTAP_TAPCELL_ROW_63_878 VGND VPWR sky130_fd_sc_hd__tapvpwrvgnd_1
X_4853_ _4852_/B _4852_/C _4852_/A VGND VGND VPWR VPWR _4855_/C sky130_fd_sc_hd__a21oi_2
XFILLER_60_393 VGND VGND VPWR VPWR sky130_fd_sc_hd__decap_3
X_4784_ _4979_/A _4793_/A _4978_/C _4978_/D VGND VGND VPWR VPWR _4784_/X sky130_fd_sc_hd__and4_2
X_3804_ _3804_/A _3804_/B VGND VGND VPWR VPWR _3806_/B sky130_fd_sc_hd__xnor2_2
X_6523_ _6396_/X _6406_/X _6569_/A VGND VGND VPWR VPWR _6523_/X sky130_fd_sc_hd__mux2_1
X_3735_ _4524_/B _6014_/A _3669_/B _3666_/D VGND VGND VPWR VPWR _3736_/B sky130_fd_sc_hd__a22o_2
X_6454_ _6394_/X _6405_/X _6760_/S VGND VGND VPWR VPWR _6567_/B sky130_fd_sc_hd__mux2_1
XPHY_EDGE_ROW_41_Left_142 VGND VGND VPWR VPWR sky130_fd_sc_hd__decap_3
X_5405_ _5526_/A _5536_/B VGND VGND VPWR VPWR _5407_/B sky130_fd_sc_hd__and2_2
X_3666_ _4524_/B _6014_/A _3669_/B _3666_/D VGND VGND VPWR VPWR _3667_/A sky130_fd_sc_hd__and4_2
X_6385_ _6874_/A _6385_/B _6385_/C _6385_/D VGND VGND VPWR VPWR _6385_/X sky130_fd_sc_hd__or4_2
X_3597_ _3597_/A _3597_/B VGND VGND VPWR VPWR _3599_/C sky130_fd_sc_hd__xnor2_2
X_5336_ _5338_/B _5319_/C _5524_/A VGND VGND VPWR VPWR _5337_/C sky130_fd_sc_hd__a21o_2
XFILLER_87_213 VGND VGND VPWR VPWR sky130_fd_sc_hd__decap_3
XFILLER_87_235 VGND VGND VPWR VPWR sky130_fd_sc_hd__decap_3
X_5267_ _5267_/A1 _5151_/C _5266_/D _5277_/C VGND VGND VPWR VPWR _5267_/Y sky130_fd_sc_hd__a22oi_2
XFILLER_75_419 VGND VGND VPWR VPWR sky130_fd_sc_hd__decap_3
X_4218_ _4331_/A _4331_/B VGND VGND VPWR VPWR _4220_/C sky130_fd_sc_hd__nand2_2
XFILLER_18_35 VGND VGND VPWR VPWR sky130_fd_sc_hd__decap_3
X_5198_ _5196_/B _5418_/B _5194_/X VGND VGND VPWR VPWR _5200_/B sky130_fd_sc_hd__a21o_2
XPHY_EDGE_ROW_50_Left_151 VGND VGND VPWR VPWR sky130_fd_sc_hd__decap_3
XFILLER_83_452 VGND VGND VPWR VPWR sky130_fd_sc_hd__decap_3
X_4149_ _4518_/A _4264_/B _4150_/A _4149_/D VGND VGND VPWR VPWR _4262_/A sky130_fd_sc_hd__nand4_2
XFILLER_95_290 VGND VGND VPWR VPWR sky130_fd_sc_hd__decap_3
XFILLER_83_485 VGND VGND VPWR VPWR sky130_fd_sc_hd__decap_3
XFILLER_24_530 VGND VGND VPWR VPWR sky130_fd_sc_hd__fill_2
XFILLER_70_124 VGND VGND VPWR VPWR sky130_fd_sc_hd__decap_3
XFILLER_70_168 VGND VGND VPWR VPWR sky130_fd_sc_hd__decap_3
XFILLER_24_574 VGND VGND VPWR VPWR sky130_fd_sc_hd__decap_3
XFILLER_24_585 VGND VGND VPWR VPWR sky130_fd_sc_hd__decap_3
XFILLER_51_360 VGND VGND VPWR VPWR sky130_fd_sc_hd__decap_3
XFILLER_51_393 VGND VGND VPWR VPWR sky130_fd_sc_hd__decap_3
Xwire104 _6992_/Y VGND VGND VPWR VPWR wire104/X sky130_fd_sc_hd__clkbuf_2
XFILLER_11_279 VGND VGND VPWR VPWR sky130_fd_sc_hd__fill_1
XFILLER_50_88 VGND VGND VPWR VPWR sky130_fd_sc_hd__fill_1
XFILLER_3_445 VGND VGND VPWR VPWR sky130_fd_sc_hd__decap_3
XFILLER_59_31 VGND VGND VPWR VPWR sky130_fd_sc_hd__fill_2
XFILLER_78_224 VGND VGND VPWR VPWR sky130_fd_sc_hd__decap_3
XFILLER_66_419 VGND VGND VPWR VPWR sky130_fd_sc_hd__fill_1
XFILLER_78_279 VGND VGND VPWR VPWR sky130_fd_sc_hd__decap_3
XFILLER_93_216 VGND VGND VPWR VPWR sky130_fd_sc_hd__decap_3
Xfanout270 _3870_/A2 VGND VGND VPWR VPWR _6929_/A sky130_fd_sc_hd__clkdlybuf4s25_1
Xfanout281 input58/X VGND VGND VPWR VPWR wire282/A sky130_fd_sc_hd__dlymetal6s2s_1
Xfanout292 _6789_/A1 VGND VGND VPWR VPWR _5491_/B sky130_fd_sc_hd__clkdlybuf4s25_1
XTAP_TAPCELL_ROW_6_283 VGND VPWR sky130_fd_sc_hd__tapvpwrvgnd_1
XFILLER_19_324 VGND VGND VPWR VPWR sky130_fd_sc_hd__fill_2
XFILLER_19_357 VGND VGND VPWR VPWR sky130_fd_sc_hd__decap_3
XFILLER_74_430 VGND VGND VPWR VPWR sky130_fd_sc_hd__fill_1
XFILLER_46_176 VGND VGND VPWR VPWR sky130_fd_sc_hd__decap_3
XFILLER_74_452 VGND VGND VPWR VPWR sky130_fd_sc_hd__decap_3
XFILLER_74_485 VGND VGND VPWR VPWR sky130_fd_sc_hd__decap_3
XFILLER_61_113 VGND VGND VPWR VPWR sky130_fd_sc_hd__decap_3
XFILLER_61_124 VGND VGND VPWR VPWR sky130_fd_sc_hd__decap_3
XFILLER_30_511 VGND VGND VPWR VPWR sky130_fd_sc_hd__decap_3
XFILLER_42_382 VGND VGND VPWR VPWR sky130_fd_sc_hd__decap_3
XFILLER_91_62 VGND VGND VPWR VPWR sky130_fd_sc_hd__decap_3
XTAP_TAPCELL_ROW_60_848 VGND VPWR sky130_fd_sc_hd__tapvpwrvgnd_1
XFILLER_30_533 VGND VGND VPWR VPWR sky130_fd_sc_hd__decap_3
X_3520_ _3880_/B _3520_/B VGND VGND VPWR VPWR _3531_/A sky130_fd_sc_hd__nor2_2
XFILLER_6_283 VGND VGND VPWR VPWR sky130_fd_sc_hd__decap_3
XFILLER_41_3 VGND VGND VPWR VPWR sky130_fd_sc_hd__fill_1
XFILLER_69_202 VGND VGND VPWR VPWR sky130_fd_sc_hd__decap_3
X_6170_ _6170_/A _6170_/B VGND VGND VPWR VPWR _6860_/A sky130_fd_sc_hd__nand2_2
Xload_slew632 _4295_/A1 VGND VGND VPWR VPWR _6085_/B sky130_fd_sc_hd__buf_4
Xload_slew621 _3770_/A VGND VGND VPWR VPWR _4181_/B sky130_fd_sc_hd__buf_6
X_5121_ _5120_/A _5120_/C _5120_/B VGND VGND VPWR VPWR _5122_/B sky130_fd_sc_hd__a21o_4
XFILLER_69_246 VGND VGND VPWR VPWR sky130_fd_sc_hd__decap_3
Xload_slew643 _6439_/A VGND VGND VPWR VPWR _5543_/A sky130_fd_sc_hd__buf_4
XFILLER_69_279 VGND VGND VPWR VPWR sky130_fd_sc_hd__fill_1
X_5052_ _5052_/A _5052_/B _5052_/C VGND VGND VPWR VPWR _5059_/A sky130_fd_sc_hd__nand3_2
XTAP_TAPCELL_ROW_68_926 VGND VPWR sky130_fd_sc_hd__tapvpwrvgnd_1
XFILLER_37_110 VGND VGND VPWR VPWR sky130_fd_sc_hd__fill_2
XFILLER_77_290 VGND VGND VPWR VPWR sky130_fd_sc_hd__decap_3
XFILLER_84_238 VGND VGND VPWR VPWR sky130_fd_sc_hd__fill_2
X_4003_ _6004_/B _4003_/B _4003_/C _5993_/A VGND VGND VPWR VPWR _4016_/A sky130_fd_sc_hd__and4_2
XFILLER_1_71 VGND VGND VPWR VPWR sky130_fd_sc_hd__decap_3
XFILLER_37_154 VGND VGND VPWR VPWR sky130_fd_sc_hd__fill_1
XFILLER_65_452 VGND VGND VPWR VPWR sky130_fd_sc_hd__decap_3
XFILLER_25_349 VGND VGND VPWR VPWR sky130_fd_sc_hd__decap_3
XFILLER_65_485 VGND VGND VPWR VPWR sky130_fd_sc_hd__decap_3
XFILLER_80_433 VGND VGND VPWR VPWR sky130_fd_sc_hd__fill_1
XFILLER_92_271 VGND VGND VPWR VPWR sky130_fd_sc_hd__decap_3
XFILLER_92_293 VGND VGND VPWR VPWR sky130_fd_sc_hd__decap_3
XFILLER_80_477 VGND VGND VPWR VPWR sky130_fd_sc_hd__decap_3
X_5954_ _6397_/S _6731_/A VGND VGND VPWR VPWR _5962_/A sky130_fd_sc_hd__nand2_2
X_5885_ _5885_/A _5885_/B _5885_/C VGND VGND VPWR VPWR _5888_/B sky130_fd_sc_hd__and3_2
X_4905_ _4903_/A _4903_/B _4903_/C VGND VGND VPWR VPWR _4905_/Y sky130_fd_sc_hd__a21oi_2
XFILLER_33_393 VGND VGND VPWR VPWR sky130_fd_sc_hd__decap_3
X_4836_ _4836_/A _4836_/B _4836_/C VGND VGND VPWR VPWR _4883_/B sky130_fd_sc_hd__and3_2
X_6506_ _6506_/A _6506_/B VGND VGND VPWR VPWR _6512_/A sky130_fd_sc_hd__nor2_2
X_4767_ _4767_/A _4767_/B _4767_/C _4767_/D VGND VGND VPWR VPWR _4808_/A sky130_fd_sc_hd__nand4_2
XFILLER_4_209 VGND VGND VPWR VPWR sky130_fd_sc_hd__decap_3
X_4698_ _4697_/B _4697_/C _4697_/A VGND VGND VPWR VPWR _4700_/B sky130_fd_sc_hd__o21bai_2
X_3718_ _4165_/A _3757_/A _4767_/C _4767_/D VGND VGND VPWR VPWR _3721_/A sky130_fd_sc_hd__nand4_2
X_6437_ _6428_/X _6431_/X _6436_/X _6434_/X _6414_/S _6589_/A VGND VGND VPWR VPWR
+ _6438_/B sky130_fd_sc_hd__mux4_2
X_3649_ _3644_/A _3644_/C _3644_/B VGND VGND VPWR VPWR _3650_/C sky130_fd_sc_hd__a21o_2
X_6368_ _6625_/B _6368_/B VGND VGND VPWR VPWR _6638_/A sky130_fd_sc_hd__nand2_2
XFILLER_88_511 VGND VGND VPWR VPWR sky130_fd_sc_hd__decap_3
XFILLER_88_533 VGND VGND VPWR VPWR sky130_fd_sc_hd__decap_3
X_5319_ _5524_/A _5338_/B _5319_/C VGND VGND VPWR VPWR _5337_/A sky130_fd_sc_hd__nand3_2
X_6299_ _6297_/Y _6298_/X _6831_/S VGND VGND VPWR VPWR _6299_/X sky130_fd_sc_hd__mux2_1
XFILLER_29_45 VGND VGND VPWR VPWR sky130_fd_sc_hd__decap_3
XFILLER_29_89 VGND VGND VPWR VPWR sky130_fd_sc_hd__decap_3
XFILLER_68_290 VGND VGND VPWR VPWR sky130_fd_sc_hd__decap_3
XFILLER_75_249 VGND VGND VPWR VPWR sky130_fd_sc_hd__decap_3
XTAP_TAPCELL_ROW_3_253 VGND VPWR sky130_fd_sc_hd__tapvpwrvgnd_1
XFILLER_16_338 VGND VGND VPWR VPWR sky130_fd_sc_hd__decap_3
XFILLER_28_176 VGND VGND VPWR VPWR sky130_fd_sc_hd__decap_3
XFILLER_43_102 VGND VGND VPWR VPWR sky130_fd_sc_hd__fill_1
XFILLER_43_113 VGND VGND VPWR VPWR sky130_fd_sc_hd__decap_3
XFILLER_45_55 VGND VGND VPWR VPWR sky130_fd_sc_hd__fill_1
XFILLER_56_496 VGND VGND VPWR VPWR sky130_fd_sc_hd__decap_3
XFILLER_71_433 VGND VGND VPWR VPWR sky130_fd_sc_hd__fill_2
XFILLER_83_293 VGND VGND VPWR VPWR sky130_fd_sc_hd__decap_3
XFILLER_43_135 VGND VGND VPWR VPWR sky130_fd_sc_hd__decap_3
XFILLER_71_466 VGND VGND VPWR VPWR sky130_fd_sc_hd__fill_2
XFILLER_24_371 VGND VGND VPWR VPWR sky130_fd_sc_hd__decap_3
XFILLER_12_555 VGND VGND VPWR VPWR sky130_fd_sc_hd__decap_3
XFILLER_61_54 VGND VGND VPWR VPWR sky130_fd_sc_hd__fill_2
XFILLER_8_526 VGND VGND VPWR VPWR sky130_fd_sc_hd__decap_3
XFILLER_61_87 VGND VGND VPWR VPWR sky130_fd_sc_hd__decap_3
XFILLER_8_559 VGND VGND VPWR VPWR sky130_fd_sc_hd__decap_3
XFILLER_6_27 VGND VGND VPWR VPWR sky130_fd_sc_hd__fill_1
XFILLER_79_500 VGND VGND VPWR VPWR sky130_fd_sc_hd__decap_3
XFILLER_66_227 VGND VGND VPWR VPWR sky130_fd_sc_hd__decap_3
XFILLER_94_536 VGND VGND VPWR VPWR sky130_fd_sc_hd__decap_3
XFILLER_94_514 VGND VGND VPWR VPWR sky130_fd_sc_hd__decap_3
XFILLER_59_290 VGND VGND VPWR VPWR sky130_fd_sc_hd__fill_2
XFILLER_47_452 VGND VGND VPWR VPWR sky130_fd_sc_hd__decap_3
XFILLER_62_400 VGND VGND VPWR VPWR sky130_fd_sc_hd__decap_3
XFILLER_81_208 VGND VGND VPWR VPWR sky130_fd_sc_hd__decap_3
XTAP_TAPCELL_ROW_37_609 VGND VPWR sky130_fd_sc_hd__tapvpwrvgnd_1
XFILLER_19_187 VGND VGND VPWR VPWR sky130_fd_sc_hd__decap_3
XFILLER_74_293 VGND VGND VPWR VPWR sky130_fd_sc_hd__decap_3
XFILLER_34_168 VGND VGND VPWR VPWR sky130_fd_sc_hd__decap_3
XFILLER_62_477 VGND VGND VPWR VPWR sky130_fd_sc_hd__fill_1
XTAP_TAPCELL_ROW_73_984 VGND VPWR sky130_fd_sc_hd__tapvpwrvgnd_1
XTAP_TAPCELL_ROW_45_686 VGND VPWR sky130_fd_sc_hd__tapvpwrvgnd_1
X_5670_ _5670_/A _5670_/B _5670_/C VGND VGND VPWR VPWR _5705_/A sky130_fd_sc_hd__or3_2
XTAP_TAPCELL_ROW_17_399 VGND VPWR sky130_fd_sc_hd__tapvpwrvgnd_1
X_4621_ _4592_/A _4592_/B _4595_/B _4593_/X VGND VGND VPWR VPWR _4623_/B sky130_fd_sc_hd__a31o_2
XFILLER_30_374 VGND VGND VPWR VPWR sky130_fd_sc_hd__decap_3
X_4552_ _4552_/A _4552_/B VGND VGND VPWR VPWR _4554_/C sky130_fd_sc_hd__xnor2_2
XTAP_TAPCELL_ROW_77_1021 VGND VPWR sky130_fd_sc_hd__tapvpwrvgnd_1
XFILLER_7_570 VGND VGND VPWR VPWR sky130_fd_sc_hd__decap_3
X_4483_ _4483_/A _4617_/B VGND VGND VPWR VPWR _4485_/A sky130_fd_sc_hd__nand2_2
X_3503_ _4782_/B VGND VGND VPWR VPWR _6760_/S sky130_fd_sc_hd__inv_2
XFILLER_89_308 VGND VGND VPWR VPWR sky130_fd_sc_hd__decap_3
X_6222_ _6441_/A _6441_/B _6221_/X VGND VGND VPWR VPWR _6223_/B sky130_fd_sc_hd__a21o_2
X_6153_ _6153_/A _6153_/B VGND VGND VPWR VPWR _6727_/A sky130_fd_sc_hd__nand2_2
XFILLER_57_205 VGND VGND VPWR VPWR sky130_fd_sc_hd__decap_3
X_6084_ _6266_/A _6085_/B VGND VGND VPWR VPWR _6087_/A sky130_fd_sc_hd__nand2_2
X_5104_ _5104_/A _5104_/B VGND VGND VPWR VPWR _5241_/B sky130_fd_sc_hd__xnor2_2
XFILLER_85_558 VGND VGND VPWR VPWR sky130_fd_sc_hd__fill_2
X_5035_ _5035_/A _5035_/B _5035_/C VGND VGND VPWR VPWR _5120_/A sky130_fd_sc_hd__or3_4
XFILLER_97_396 VGND VGND VPWR VPWR sky130_fd_sc_hd__decap_3
XFILLER_38_452 VGND VGND VPWR VPWR sky130_fd_sc_hd__decap_3
XTAP_TAPCELL_ROW_0_212 VGND VPWR sky130_fd_sc_hd__tapvpwrvgnd_1
XFILLER_25_113 VGND VGND VPWR VPWR sky130_fd_sc_hd__decap_3
XFILLER_53_400 VGND VGND VPWR VPWR sky130_fd_sc_hd__decap_3
XFILLER_53_433 VGND VGND VPWR VPWR sky130_fd_sc_hd__fill_1
XFILLER_65_260 VGND VGND VPWR VPWR sky130_fd_sc_hd__decap_3
XFILLER_53_455 VGND VGND VPWR VPWR sky130_fd_sc_hd__decap_3
X_6986_ _6986_/A _6986_/B _6986_/C _6986_/D VGND VGND VPWR VPWR _6987_/D sky130_fd_sc_hd__or4_4
XFILLER_40_105 VGND VGND VPWR VPWR sky130_fd_sc_hd__decap_3
X_5937_ _4446_/X _4449_/Y _4321_/B _4325_/X VGND VGND VPWR VPWR _5939_/B sky130_fd_sc_hd__a211oi_2
X_5868_ _5869_/B1 _5869_/C1 _5862_/Y _5866_/X VGND VGND VPWR VPWR _6754_/B sky130_fd_sc_hd__o211ai_2
XFILLER_21_374 VGND VGND VPWR VPWR sky130_fd_sc_hd__decap_3
X_5799_ _5799_/A _6375_/A VGND VGND VPWR VPWR _6465_/A sky130_fd_sc_hd__nor2_2
X_4819_ _4815_/X _4817_/Y _4773_/B _4775_/B VGND VGND VPWR VPWR _4819_/Y sky130_fd_sc_hd__o211ai_2
XFILLER_31_46 VGND VGND VPWR VPWR sky130_fd_sc_hd__decap_3
XFILLER_5_518 VGND VGND VPWR VPWR sky130_fd_sc_hd__fill_2
Xrebuffer689 wire672/X VGND VGND VPWR VPWR fanout666/A sky130_fd_sc_hd__buf_4
Xrebuffer678 _5525_/A VGND VGND VPWR VPWR _5504_/A sky130_fd_sc_hd__buf_2
XTAP_TAPCELL_ROW_8_301 VGND VPWR sky130_fd_sc_hd__tapvpwrvgnd_1
XFILLER_0_212 VGND VGND VPWR VPWR sky130_fd_sc_hd__fill_2
XFILLER_0_234 VGND VGND VPWR VPWR sky130_fd_sc_hd__decap_3
XFILLER_88_330 VGND VGND VPWR VPWR sky130_fd_sc_hd__decap_3
Xoutput79 _6984_/A VGND VGND VPWR VPWR result[17] sky130_fd_sc_hd__dlymetal6s4s_1
XFILLER_0_278 VGND VGND VPWR VPWR sky130_fd_sc_hd__fill_2
XFILLER_88_374 VGND VGND VPWR VPWR sky130_fd_sc_hd__decap_3
XFILLER_48_227 VGND VGND VPWR VPWR sky130_fd_sc_hd__decap_3
XFILLER_76_558 VGND VGND VPWR VPWR sky130_fd_sc_hd__decap_3
XFILLER_29_452 VGND VGND VPWR VPWR sky130_fd_sc_hd__decap_3
XFILLER_56_65 VGND VGND VPWR VPWR sky130_fd_sc_hd__decap_3
XFILLER_29_496 VGND VGND VPWR VPWR sky130_fd_sc_hd__decap_3
XFILLER_56_271 VGND VGND VPWR VPWR sky130_fd_sc_hd__decap_3
XFILLER_56_293 VGND VGND VPWR VPWR sky130_fd_sc_hd__decap_3
XPHY_EDGE_ROW_19_Right_19 VGND VGND VPWR VPWR sky130_fd_sc_hd__decap_3
XFILLER_71_252 VGND VGND VPWR VPWR sky130_fd_sc_hd__decap_3
XFILLER_71_296 VGND VGND VPWR VPWR sky130_fd_sc_hd__decap_3
XFILLER_72_64 VGND VGND VPWR VPWR sky130_fd_sc_hd__fill_1
XTAP_TAPCELL_ROW_70_954 VGND VPWR sky130_fd_sc_hd__tapvpwrvgnd_1
XFILLER_12_363 VGND VGND VPWR VPWR sky130_fd_sc_hd__fill_1
XTAP_TAPCELL_ROW_42_656 VGND VPWR sky130_fd_sc_hd__tapvpwrvgnd_1
XTAP_TAPCELL_ROW_14_369 VGND VPWR sky130_fd_sc_hd__tapvpwrvgnd_1
XFILLER_12_374 VGND VGND VPWR VPWR sky130_fd_sc_hd__decap_3
XFILLER_8_389 VGND VGND VPWR VPWR sky130_fd_sc_hd__fill_2
XPHY_EDGE_ROW_28_Right_28 VGND VGND VPWR VPWR sky130_fd_sc_hd__decap_3
XFILLER_39_216 VGND VGND VPWR VPWR sky130_fd_sc_hd__decap_3
XFILLER_67_514 VGND VGND VPWR VPWR sky130_fd_sc_hd__decap_3
XFILLER_79_385 VGND VGND VPWR VPWR sky130_fd_sc_hd__decap_3
XFILLER_94_300 VGND VGND VPWR VPWR sky130_fd_sc_hd__decap_3
XFILLER_67_558 VGND VGND VPWR VPWR sky130_fd_sc_hd__fill_2
XFILLER_79_396 VGND VGND VPWR VPWR sky130_fd_sc_hd__decap_3
XPHY_EDGE_ROW_6_Left_107 VGND VGND VPWR VPWR sky130_fd_sc_hd__decap_3
XFILLER_82_539 VGND VGND VPWR VPWR sky130_fd_sc_hd__fill_2
XPHY_EDGE_ROW_37_Right_37 VGND VGND VPWR VPWR sky130_fd_sc_hd__decap_3
XFILLER_94_399 VGND VGND VPWR VPWR sky130_fd_sc_hd__decap_3
XFILLER_35_444 VGND VGND VPWR VPWR sky130_fd_sc_hd__decap_3
XFILLER_62_230 VGND VGND VPWR VPWR sky130_fd_sc_hd__decap_3
XFILLER_90_550 VGND VGND VPWR VPWR sky130_fd_sc_hd__decap_3
X_6840_ _6839_/C _6839_/B _6839_/A VGND VGND VPWR VPWR _6841_/B sky130_fd_sc_hd__a21oi_4
X_6771_ _6586_/A _6424_/X _6770_/Y _6769_/X VGND VGND VPWR VPWR _6771_/X sky130_fd_sc_hd__a31o_2
XFILLER_50_447 VGND VGND VPWR VPWR sky130_fd_sc_hd__fill_1
XFILLER_62_296 VGND VGND VPWR VPWR sky130_fd_sc_hd__decap_3
X_5722_ _5713_/B _5713_/C _5750_/A _5709_/X VGND VGND VPWR VPWR _5740_/B sky130_fd_sc_hd__a2bb2o_2
X_3983_ _3983_/A _3983_/B VGND VGND VPWR VPWR _3984_/C sky130_fd_sc_hd__or2_2
XTAP_TAPCELL_ROW_83_1091 VGND VPWR sky130_fd_sc_hd__tapvpwrvgnd_1
XFILLER_30_160 VGND VGND VPWR VPWR sky130_fd_sc_hd__decap_3
X_5653_ _5647_/Y _5648_/X _5539_/Y _5541_/Y VGND VGND VPWR VPWR _5653_/X sky130_fd_sc_hd__o211a_2
X_5584_ _5779_/A _5725_/C VGND VGND VPWR VPWR _6122_/A sky130_fd_sc_hd__and2_2
X_4604_ _4848_/A _4604_/B VGND VGND VPWR VPWR _4604_/Y sky130_fd_sc_hd__nor2_2
XPHY_EDGE_ROW_46_Right_46 VGND VGND VPWR VPWR sky130_fd_sc_hd__decap_3
X_4535_ _4428_/A _4428_/C _4428_/B VGND VGND VPWR VPWR _4536_/B sky130_fd_sc_hd__a21oi_2
X_4466_ _4466_/A _4466_/B VGND VGND VPWR VPWR _4468_/B sky130_fd_sc_hd__xnor2_2
XFILLER_89_149 VGND VGND VPWR VPWR sky130_fd_sc_hd__decap_3
X_6205_ _6205_/A _6957_/A VGND VGND VPWR VPWR _6205_/Y sky130_fd_sc_hd__nand2_2
X_4397_ _4397_/A _4397_/B _4397_/C VGND VGND VPWR VPWR _4398_/A sky130_fd_sc_hd__and3_4
X_6136_ _6584_/A _6583_/B _6114_/A VGND VGND VPWR VPWR _6137_/B sky130_fd_sc_hd__a21oi_2
XFILLER_58_536 VGND VGND VPWR VPWR sky130_fd_sc_hd__fill_2
XFILLER_73_517 VGND VGND VPWR VPWR sky130_fd_sc_hd__decap_3
XFILLER_85_366 VGND VGND VPWR VPWR sky130_fd_sc_hd__decap_3
X_6067_ _6286_/A _6068_/B VGND VGND VPWR VPWR _6200_/A sky130_fd_sc_hd__nand2_2
XPHY_EDGE_ROW_55_Right_55 VGND VGND VPWR VPWR sky130_fd_sc_hd__decap_3
XFILLER_38_282 VGND VGND VPWR VPWR sky130_fd_sc_hd__decap_3
XFILLER_66_580 VGND VGND VPWR VPWR sky130_fd_sc_hd__fill_2
XFILLER_85_399 VGND VGND VPWR VPWR sky130_fd_sc_hd__decap_3
X_5018_ _5321_/B _5018_/B VGND VGND VPWR VPWR _5420_/A sky130_fd_sc_hd__nand2_2
XFILLER_38_293 VGND VGND VPWR VPWR sky130_fd_sc_hd__decap_3
XFILLER_81_550 VGND VGND VPWR VPWR sky130_fd_sc_hd__decap_3
XFILLER_26_488 VGND VGND VPWR VPWR sky130_fd_sc_hd__fill_1
XFILLER_41_425 VGND VGND VPWR VPWR sky130_fd_sc_hd__decap_3
XFILLER_41_447 VGND VGND VPWR VPWR sky130_fd_sc_hd__fill_1
XFILLER_41_458 VGND VGND VPWR VPWR sky130_fd_sc_hd__decap_3
XFILLER_81_594 VGND VGND VPWR VPWR sky130_fd_sc_hd__decap_3
X_6969_ _6969_/A _6969_/B VGND VGND VPWR VPWR _6969_/Y sky130_fd_sc_hd__nand2_2
XFILLER_9_109 VGND VGND VPWR VPWR sky130_fd_sc_hd__decap_3
XTAP_TAPCELL_ROW_11_328 VGND VPWR sky130_fd_sc_hd__tapvpwrvgnd_1
XPHY_EDGE_ROW_64_Right_64 VGND VGND VPWR VPWR sky130_fd_sc_hd__decap_3
XFILLER_21_182 VGND VGND VPWR VPWR sky130_fd_sc_hd__decap_3
XTAP_TAPCELL_ROW_97_1238 VGND VPWR sky130_fd_sc_hd__tapvpwrvgnd_1
XFILLER_1_532 VGND VGND VPWR VPWR sky130_fd_sc_hd__decap_3
XFILLER_76_300 VGND VGND VPWR VPWR sky130_fd_sc_hd__decap_3
XFILLER_67_53 VGND VGND VPWR VPWR sky130_fd_sc_hd__decap_3
XFILLER_67_64 VGND VGND VPWR VPWR sky130_fd_sc_hd__decap_3
XFILLER_88_171 VGND VGND VPWR VPWR sky130_fd_sc_hd__decap_3
XPHY_EDGE_ROW_73_Right_73 VGND VGND VPWR VPWR sky130_fd_sc_hd__decap_3
XFILLER_36_208 VGND VGND VPWR VPWR sky130_fd_sc_hd__decap_3
XFILLER_76_377 VGND VGND VPWR VPWR sky130_fd_sc_hd__fill_2
XFILLER_91_303 VGND VGND VPWR VPWR sky130_fd_sc_hd__decap_3
XFILLER_57_580 VGND VGND VPWR VPWR sky130_fd_sc_hd__decap_3
XFILLER_64_528 VGND VGND VPWR VPWR sky130_fd_sc_hd__decap_3
XFILLER_76_388 VGND VGND VPWR VPWR sky130_fd_sc_hd__decap_3
XTAP_TAPCELL_ROW_47_715 VGND VPWR sky130_fd_sc_hd__tapvpwrvgnd_1
XTAP_TAPCELL_ROW_19_417 VGND VPWR sky130_fd_sc_hd__tapvpwrvgnd_1
XFILLER_17_433 VGND VGND VPWR VPWR sky130_fd_sc_hd__fill_2
XFILLER_72_550 VGND VGND VPWR VPWR sky130_fd_sc_hd__decap_3
XFILLER_83_30 VGND VGND VPWR VPWR sky130_fd_sc_hd__decap_3
XFILLER_91_358 VGND VGND VPWR VPWR sky130_fd_sc_hd__decap_3
XFILLER_17_488 VGND VGND VPWR VPWR sky130_fd_sc_hd__decap_3
XFILLER_44_263 VGND VGND VPWR VPWR sky130_fd_sc_hd__fill_1
XFILLER_83_63 VGND VGND VPWR VPWR sky130_fd_sc_hd__decap_3
XFILLER_32_447 VGND VGND VPWR VPWR sky130_fd_sc_hd__decap_3
XTAP_TAPCELL_ROW_55_792 VGND VPWR sky130_fd_sc_hd__tapvpwrvgnd_1
XPHY_EDGE_ROW_88_Left_189 VGND VGND VPWR VPWR sky130_fd_sc_hd__decap_3
XPHY_EDGE_ROW_82_Right_82 VGND VGND VPWR VPWR sky130_fd_sc_hd__decap_3
XFILLER_40_480 VGND VGND VPWR VPWR sky130_fd_sc_hd__fill_1
XFILLER_73_6 VGND VGND VPWR VPWR sky130_fd_sc_hd__decap_3
XFILLER_8_175 VGND VGND VPWR VPWR sky130_fd_sc_hd__fill_1
XFILLER_8_197 VGND VGND VPWR VPWR sky130_fd_sc_hd__fill_1
X_4320_ _3779_/A _3780_/Y _4321_/A _4319_/X VGND VGND VPWR VPWR _4321_/B sky130_fd_sc_hd__a211oi_2
X_4251_ _4246_/Y _4251_/A2 _4227_/Y _4229_/A VGND VGND VPWR VPWR _4253_/C sky130_fd_sc_hd__a211o_2
XPHY_EDGE_ROW_97_Left_198 VGND VGND VPWR VPWR sky130_fd_sc_hd__decap_3
XFILLER_99_458 VGND VGND VPWR VPWR sky130_fd_sc_hd__decap_3
XFILLER_99_447 VGND VGND VPWR VPWR sky130_fd_sc_hd__fill_1
XFILLER_79_160 VGND VGND VPWR VPWR sky130_fd_sc_hd__decap_3
XPHY_EDGE_ROW_91_Right_91 VGND VGND VPWR VPWR sky130_fd_sc_hd__decap_3
XFILLER_67_311 VGND VGND VPWR VPWR sky130_fd_sc_hd__decap_3
X_4182_ _6083_/B _4420_/C _3869_/D _4181_/B VGND VGND VPWR VPWR _4182_/Y sky130_fd_sc_hd__a22oi_2
XFILLER_55_517 VGND VGND VPWR VPWR sky130_fd_sc_hd__decap_3
XFILLER_67_344 VGND VGND VPWR VPWR sky130_fd_sc_hd__fill_1
XFILLER_67_366 VGND VGND VPWR VPWR sky130_fd_sc_hd__fill_2
XFILLER_94_141 VGND VGND VPWR VPWR sky130_fd_sc_hd__fill_1
XFILLER_55_539 VGND VGND VPWR VPWR sky130_fd_sc_hd__decap_3
XFILLER_94_174 VGND VGND VPWR VPWR sky130_fd_sc_hd__decap_3
XFILLER_70_509 VGND VGND VPWR VPWR sky130_fd_sc_hd__decap_3
XFILLER_82_347 VGND VGND VPWR VPWR sky130_fd_sc_hd__fill_1
XFILLER_23_403 VGND VGND VPWR VPWR sky130_fd_sc_hd__fill_1
XFILLER_50_200 VGND VGND VPWR VPWR sky130_fd_sc_hd__decap_3
XFILLER_63_561 VGND VGND VPWR VPWR sky130_fd_sc_hd__decap_3
XFILLER_90_380 VGND VGND VPWR VPWR sky130_fd_sc_hd__decap_3
X_6823_ _6087_/A wire109/X _6261_/C VGND VGND VPWR VPWR _6825_/A sky130_fd_sc_hd__a21oi_2
XFILLER_23_469 VGND VGND VPWR VPWR sky130_fd_sc_hd__decap_3
X_6754_ _6754_/A _6754_/B _6754_/C VGND VGND VPWR VPWR _6754_/X sky130_fd_sc_hd__and3_2
X_3966_ _3966_/A _3966_/B VGND VGND VPWR VPWR _4023_/A sky130_fd_sc_hd__xor2_2
XFILLER_50_277 VGND VGND VPWR VPWR sky130_fd_sc_hd__decap_3
X_6685_ _6668_/Y _6669_/X _6684_/X VGND VGND VPWR VPWR _6988_/B sky130_fd_sc_hd__o21bai_2
X_5705_ _5705_/A _5705_/B _5705_/C VGND VGND VPWR VPWR _5748_/A sky130_fd_sc_hd__nand3_2
X_5636_ _5636_/A _6401_/S _5716_/A _5636_/D VGND VGND VPWR VPWR _5716_/B sky130_fd_sc_hd__nand4_2
X_3897_ _3897_/A _3897_/B VGND VGND VPWR VPWR _4031_/A sky130_fd_sc_hd__xnor2_2
XFILLER_12_48 VGND VGND VPWR VPWR sky130_fd_sc_hd__fill_2
X_5567_ _5409_/X _5411_/Y _5571_/A1 _5565_/X VGND VGND VPWR VPWR _5567_/X sky130_fd_sc_hd__a211o_2
X_5498_ _5498_/A _5498_/B VGND VGND VPWR VPWR _5527_/B sky130_fd_sc_hd__xnor2_2
X_4518_ _4518_/A _4518_/B VGND VGND VPWR VPWR _4605_/A sky130_fd_sc_hd__nand2_2
X_4449_ _4451_/A _4451_/B VGND VGND VPWR VPWR _4449_/Y sky130_fd_sc_hd__nand2_2
XFILLER_58_300 VGND VGND VPWR VPWR sky130_fd_sc_hd__decap_3
XFILLER_77_108 VGND VGND VPWR VPWR sky130_fd_sc_hd__decap_3
XFILLER_77_119 VGND VGND VPWR VPWR sky130_fd_sc_hd__decap_3
Xfanout600 input2/X VGND VGND VPWR VPWR fanout600/X sky130_fd_sc_hd__clkbuf_2
Xfanout611 input18/X VGND VGND VPWR VPWR _6187_/B sky130_fd_sc_hd__clkdlybuf4s25_1
Xfanout622 fanout623/X VGND VGND VPWR VPWR _6079_/B sky130_fd_sc_hd__buf_4
Xfanout633 _3757_/A VGND VGND VPWR VPWR _4585_/A sky130_fd_sc_hd__clkbuf_2
XTAP_TAPCELL_ROW_92_1179 VGND VPWR sky130_fd_sc_hd__tapvpwrvgnd_1
XFILLER_58_333 VGND VGND VPWR VPWR sky130_fd_sc_hd__decap_3
Xfanout644 input12/X VGND VGND VPWR VPWR _6126_/A sky130_fd_sc_hd__buf_4
Xfanout666 fanout666/A VGND VGND VPWR VPWR _6373_/A sky130_fd_sc_hd__clkbuf_4
XFILLER_98_480 VGND VGND VPWR VPWR sky130_fd_sc_hd__fill_1
XFILLER_100_452 VGND VGND VPWR VPWR sky130_fd_sc_hd__decap_3
X_6119_ _6120_/A _6120_/B VGND VGND VPWR VPWR _6119_/Y sky130_fd_sc_hd__nor2_2
XFILLER_39_580 VGND VGND VPWR VPWR sky130_fd_sc_hd__fill_1
XFILLER_46_517 VGND VGND VPWR VPWR sky130_fd_sc_hd__decap_3
XFILLER_85_163 VGND VGND VPWR VPWR sky130_fd_sc_hd__decap_3
XFILLER_37_89 VGND VGND VPWR VPWR sky130_fd_sc_hd__decap_3
XFILLER_41_233 VGND VGND VPWR VPWR sky130_fd_sc_hd__decap_3
XFILLER_53_33 VGND VGND VPWR VPWR sky130_fd_sc_hd__decap_3
XFILLER_81_380 VGND VGND VPWR VPWR sky130_fd_sc_hd__decap_3
XFILLER_53_66 VGND VGND VPWR VPWR sky130_fd_sc_hd__decap_3
XFILLER_53_88 VGND VGND VPWR VPWR sky130_fd_sc_hd__decap_3
XTAP_TAPCELL_ROW_52_762 VGND VPWR sky130_fd_sc_hd__tapvpwrvgnd_1
XFILLER_22_480 VGND VGND VPWR VPWR sky130_fd_sc_hd__fill_1
XFILLER_41_277 VGND VGND VPWR VPWR sky130_fd_sc_hd__decap_3
XTAP_TAPCELL_ROW_24_464 VGND VPWR sky130_fd_sc_hd__tapvpwrvgnd_1
XFILLER_5_156 VGND VGND VPWR VPWR sky130_fd_sc_hd__decap_3
XFILLER_1_340 VGND VGND VPWR VPWR sky130_fd_sc_hd__decap_3
XFILLER_78_85 VGND VGND VPWR VPWR sky130_fd_sc_hd__fill_1
XFILLER_1_384 VGND VGND VPWR VPWR sky130_fd_sc_hd__fill_2
XFILLER_49_311 VGND VGND VPWR VPWR sky130_fd_sc_hd__decap_3
XFILLER_89_480 VGND VGND VPWR VPWR sky130_fd_sc_hd__decap_3
XFILLER_76_130 VGND VGND VPWR VPWR sky130_fd_sc_hd__decap_3
XFILLER_76_141 VGND VGND VPWR VPWR sky130_fd_sc_hd__decap_3
XFILLER_37_539 VGND VGND VPWR VPWR sky130_fd_sc_hd__decap_3
XFILLER_91_111 VGND VGND VPWR VPWR sky130_fd_sc_hd__fill_1
XFILLER_64_336 VGND VGND VPWR VPWR sky130_fd_sc_hd__decap_3
XFILLER_94_95 VGND VGND VPWR VPWR sky130_fd_sc_hd__decap_3
XFILLER_60_520 VGND VGND VPWR VPWR sky130_fd_sc_hd__decap_3
XFILLER_20_406 VGND VGND VPWR VPWR sky130_fd_sc_hd__decap_3
XFILLER_60_564 VGND VGND VPWR VPWR sky130_fd_sc_hd__decap_3
X_3820_ _3821_/A _3821_/B _3821_/C VGND VGND VPWR VPWR _3932_/B sky130_fd_sc_hd__o21ai_2
XFILLER_32_277 VGND VGND VPWR VPWR sky130_fd_sc_hd__decap_3
X_3751_ _3748_/X _3751_/B VGND VGND VPWR VPWR _4151_/B sky130_fd_sc_hd__and2b_2
XTAP_TAPCELL_ROW_80_1061 VGND VPWR sky130_fd_sc_hd__tapvpwrvgnd_1
XFILLER_71_3 VGND VGND VPWR VPWR sky130_fd_sc_hd__decap_3
X_6470_ _6381_/D _6127_/X _6542_/A2 VGND VGND VPWR VPWR _6470_/Y sky130_fd_sc_hd__o21ai_2
X_3682_ _3682_/A _3682_/B VGND VGND VPWR VPWR _3683_/B sky130_fd_sc_hd__nor2_2
X_5421_ _5445_/A _5421_/B VGND VGND VPWR VPWR _5437_/A sky130_fd_sc_hd__and2_2
X_5352_ _5428_/A _5351_/C _5351_/A VGND VGND VPWR VPWR _5353_/C sky130_fd_sc_hd__a21o_2
X_4303_ _4302_/B _4302_/C _4302_/A VGND VGND VPWR VPWR _4305_/B sky130_fd_sc_hd__a21boi_2
XFILLER_87_417 VGND VGND VPWR VPWR sky130_fd_sc_hd__decap_3
X_5283_ _5283_/A _5283_/B VGND VGND VPWR VPWR _5360_/B sky130_fd_sc_hd__xnor2_2
XFILLER_99_277 VGND VGND VPWR VPWR sky130_fd_sc_hd__decap_3
X_4234_ _4231_/X _4234_/B VGND VGND VPWR VPWR _4340_/B sky130_fd_sc_hd__and2b_2
XFILLER_67_130 VGND VGND VPWR VPWR sky130_fd_sc_hd__decap_3
X_4165_ _4165_/A _4526_/B VGND VGND VPWR VPWR _4167_/B sky130_fd_sc_hd__nand2_2
XFILLER_28_528 VGND VGND VPWR VPWR sky130_fd_sc_hd__decap_3
XFILLER_55_303 VGND VGND VPWR VPWR sky130_fd_sc_hd__decap_3
XFILLER_95_461 VGND VGND VPWR VPWR sky130_fd_sc_hd__decap_3
X_4096_ _4593_/A _4592_/A _6264_/A _4211_/D VGND VGND VPWR VPWR _4096_/X sky130_fd_sc_hd__and4_2
XFILLER_36_561 VGND VGND VPWR VPWR sky130_fd_sc_hd__decap_3
XFILLER_70_317 VGND VGND VPWR VPWR sky130_fd_sc_hd__decap_3
XFILLER_23_200 VGND VGND VPWR VPWR sky130_fd_sc_hd__decap_3
XFILLER_51_531 VGND VGND VPWR VPWR sky130_fd_sc_hd__decap_3
XFILLER_63_391 VGND VGND VPWR VPWR sky130_fd_sc_hd__fill_1
XFILLER_82_188 VGND VGND VPWR VPWR sky130_fd_sc_hd__decap_3
XFILLER_23_255 VGND VGND VPWR VPWR sky130_fd_sc_hd__decap_3
X_6806_ _6806_/A _6806_/B VGND VGND VPWR VPWR _6806_/X sky130_fd_sc_hd__xor2_2
XFILLER_11_428 VGND VGND VPWR VPWR sky130_fd_sc_hd__decap_3
XFILLER_23_299 VGND VGND VPWR VPWR sky130_fd_sc_hd__decap_3
XFILLER_51_586 VGND VGND VPWR VPWR sky130_fd_sc_hd__decap_3
X_4998_ _4998_/A _4998_/B _4998_/C _4998_/D VGND VGND VPWR VPWR _4998_/Y sky130_fd_sc_hd__nand4_2
XFILLER_23_47 VGND VGND VPWR VPWR sky130_fd_sc_hd__decap_3
XFILLER_23_69 VGND VGND VPWR VPWR sky130_fd_sc_hd__decap_3
X_6737_ _6923_/A _6724_/Y _6736_/X VGND VGND VPWR VPWR _6990_/B sky130_fd_sc_hd__a21o_2
X_3949_ _6039_/B _3950_/C _3950_/A VGND VGND VPWR VPWR _3951_/A sky130_fd_sc_hd__o21a_2
XTAP_TAPCELL_ROW_21_434 VGND VPWR sky130_fd_sc_hd__tapvpwrvgnd_1
X_6668_ _5688_/Y _5815_/X _6686_/A3 VGND VGND VPWR VPWR _6668_/Y sky130_fd_sc_hd__a21oi_2
X_6599_ _6215_/Y _6234_/X _6381_/A VGND VGND VPWR VPWR _6599_/Y sky130_fd_sc_hd__a21oi_2
X_5619_ _5777_/A _6109_/B _3497_/Y _5019_/A VGND VGND VPWR VPWR _5620_/B sky130_fd_sc_hd__o2bb2a_2
XTAP_TAPCELL_ROW_94_1208 VGND VPWR sky130_fd_sc_hd__tapvpwrvgnd_1
XFILLER_2_104 VGND VGND VPWR VPWR sky130_fd_sc_hd__decap_3
XFILLER_78_406 VGND VGND VPWR VPWR sky130_fd_sc_hd__decap_3
XFILLER_48_22 VGND VGND VPWR VPWR sky130_fd_sc_hd__fill_2
XFILLER_78_439 VGND VGND VPWR VPWR sky130_fd_sc_hd__decap_3
Xfanout430 input36/X VGND VGND VPWR VPWR _6019_/C sky130_fd_sc_hd__clkbuf_2
Xfanout441 _4662_/C VGND VGND VPWR VPWR _4517_/C sky130_fd_sc_hd__clkbuf_2
XFILLER_58_141 VGND VGND VPWR VPWR sky130_fd_sc_hd__decap_3
Xfanout452 _6958_/S0 VGND VGND VPWR VPWR _3765_/B sky130_fd_sc_hd__clkdlybuf4s25_1
Xfanout463 input33/X VGND VGND VPWR VPWR _6474_/S sky130_fd_sc_hd__dlymetal6s2s_1
XFILLER_100_271 VGND VGND VPWR VPWR sky130_fd_sc_hd__decap_3
XFILLER_19_528 VGND VGND VPWR VPWR sky130_fd_sc_hd__decap_3
XFILLER_48_88 VGND VGND VPWR VPWR sky130_fd_sc_hd__decap_3
XFILLER_73_100 VGND VGND VPWR VPWR sky130_fd_sc_hd__decap_3
XFILLER_86_461 VGND VGND VPWR VPWR sky130_fd_sc_hd__decap_3
Xfanout485 fanout489/X VGND VGND VPWR VPWR _5361_/B sky130_fd_sc_hd__buf_6
XFILLER_0_18 VGND VGND VPWR VPWR sky130_fd_sc_hd__decap_3
XFILLER_0_29 VGND VGND VPWR VPWR sky130_fd_sc_hd__decap_3
XFILLER_73_122 VGND VGND VPWR VPWR sky130_fd_sc_hd__decap_3
XTAP_TAPCELL_ROW_29_523 VGND VPWR sky130_fd_sc_hd__tapvpwrvgnd_1
XFILLER_27_561 VGND VGND VPWR VPWR sky130_fd_sc_hd__decap_3
XFILLER_64_32 VGND VGND VPWR VPWR sky130_fd_sc_hd__decap_3
XFILLER_14_200 VGND VGND VPWR VPWR sky130_fd_sc_hd__decap_3
XFILLER_14_211 VGND VGND VPWR VPWR sky130_fd_sc_hd__decap_3
XFILLER_42_531 VGND VGND VPWR VPWR sky130_fd_sc_hd__fill_1
XFILLER_61_328 VGND VGND VPWR VPWR sky130_fd_sc_hd__decap_3
XFILLER_64_76 VGND VGND VPWR VPWR sky130_fd_sc_hd__decap_3
XFILLER_14_244 VGND VGND VPWR VPWR sky130_fd_sc_hd__decap_3
XFILLER_14_288 VGND VGND VPWR VPWR sky130_fd_sc_hd__decap_3
XFILLER_80_75 VGND VGND VPWR VPWR sky130_fd_sc_hd__decap_3
XFILLER_10_450 VGND VGND VPWR VPWR sky130_fd_sc_hd__fill_1
XFILLER_10_461 VGND VGND VPWR VPWR sky130_fd_sc_hd__fill_1
XFILLER_6_421 VGND VGND VPWR VPWR sky130_fd_sc_hd__decap_3
XFILLER_6_454 VGND VGND VPWR VPWR sky130_fd_sc_hd__fill_1
XFILLER_89_40 VGND VGND VPWR VPWR sky130_fd_sc_hd__decap_3
XFILLER_6_498 VGND VGND VPWR VPWR sky130_fd_sc_hd__decap_3
XFILLER_89_73 VGND VGND VPWR VPWR sky130_fd_sc_hd__decap_3
XFILLER_69_406 VGND VGND VPWR VPWR sky130_fd_sc_hd__decap_3
XFILLER_89_95 VGND VGND VPWR VPWR sky130_fd_sc_hd__decap_3
XFILLER_36_6 VGND VGND VPWR VPWR sky130_fd_sc_hd__fill_1
XFILLER_69_439 VGND VGND VPWR VPWR sky130_fd_sc_hd__fill_1
XFILLER_49_130 VGND VGND VPWR VPWR sky130_fd_sc_hd__fill_1
XFILLER_96_269 VGND VGND VPWR VPWR sky130_fd_sc_hd__fill_1
XFILLER_49_163 VGND VGND VPWR VPWR sky130_fd_sc_hd__decap_3
XFILLER_49_196 VGND VGND VPWR VPWR sky130_fd_sc_hd__decap_3
XFILLER_64_144 VGND VGND VPWR VPWR sky130_fd_sc_hd__decap_3
XFILLER_92_475 VGND VGND VPWR VPWR sky130_fd_sc_hd__fill_1
X_5970_ _5970_/A _5970_/B VGND VGND VPWR VPWR _5971_/B sky130_fd_sc_hd__xnor2_2
XFILLER_18_572 VGND VGND VPWR VPWR sky130_fd_sc_hd__decap_3
XFILLER_33_531 VGND VGND VPWR VPWR sky130_fd_sc_hd__decap_3
XFILLER_45_380 VGND VGND VPWR VPWR sky130_fd_sc_hd__decap_3
XFILLER_92_497 VGND VGND VPWR VPWR sky130_fd_sc_hd__fill_2
X_4921_ _4685_/A _4646_/D _4631_/A _4629_/Y VGND VGND VPWR VPWR _4922_/B sky130_fd_sc_hd__o2bb2a_2
XFILLER_33_564 VGND VGND VPWR VPWR sky130_fd_sc_hd__decap_3
X_4852_ _4852_/A _4852_/B _4852_/C VGND VGND VPWR VPWR _4855_/B sky130_fd_sc_hd__and3_4
XTAP_TAPCELL_ROW_63_879 VGND VPWR sky130_fd_sc_hd__tapvpwrvgnd_1
XFILLER_20_203 VGND VGND VPWR VPWR sky130_fd_sc_hd__fill_2
X_3803_ _3803_/A _3803_/B VGND VGND VPWR VPWR _3804_/B sky130_fd_sc_hd__nor2_2
X_4783_ _4783_/A _4783_/B VGND VGND VPWR VPWR _4790_/A sky130_fd_sc_hd__xnor2_2
X_6522_ _6678_/B VGND VGND VPWR VPWR _6522_/Y sky130_fd_sc_hd__inv_2
X_3734_ _3709_/X _3724_/Y _3747_/A _3723_/A VGND VGND VPWR VPWR _3734_/Y sky130_fd_sc_hd__o211ai_2
X_6453_ _6402_/X _6404_/Y _6453_/S VGND VGND VPWR VPWR _6453_/X sky130_fd_sc_hd__mux2_1
X_3665_ _3664_/A _3665_/A2 _3933_/D _3664_/B VGND VGND VPWR VPWR _3666_/D sky130_fd_sc_hd__a22o_2
XFILLER_9_281 VGND VGND VPWR VPWR sky130_fd_sc_hd__decap_3
X_5404_ _5404_/A _5404_/B _5404_/C VGND VGND VPWR VPWR _5407_/A sky130_fd_sc_hd__or3_2
X_6384_ _6384_/A _6384_/B _6384_/C _6384_/D VGND VGND VPWR VPWR _6385_/D sky130_fd_sc_hd__or4_2
X_3596_ _6150_/A _3597_/B VGND VGND VPWR VPWR _3821_/B sky130_fd_sc_hd__and2_2
X_5335_ _5390_/B _5334_/B _5334_/A VGND VGND VPWR VPWR _5337_/B sky130_fd_sc_hd__o21bai_2
XFILLER_87_225 VGND VGND VPWR VPWR sky130_fd_sc_hd__fill_2
X_5266_ _5275_/B _5277_/C _5398_/C _5266_/D VGND VGND VPWR VPWR _5269_/A sky130_fd_sc_hd__and4_4
XFILLER_87_269 VGND VGND VPWR VPWR sky130_fd_sc_hd__fill_2
X_4217_ _4217_/A _4217_/B VGND VGND VPWR VPWR _4331_/B sky130_fd_sc_hd__xnor2_2
X_5197_ _5197_/A _5197_/B VGND VGND VPWR VPWR _5418_/B sky130_fd_sc_hd__xnor2_2
XFILLER_18_47 VGND VGND VPWR VPWR sky130_fd_sc_hd__decap_3
XFILLER_55_111 VGND VGND VPWR VPWR sky130_fd_sc_hd__fill_1
X_4148_ _5976_/B _4387_/C _4387_/D _4659_/A VGND VGND VPWR VPWR _4149_/D sky130_fd_sc_hd__a22o_2
XFILLER_18_69 VGND VGND VPWR VPWR sky130_fd_sc_hd__decap_3
XFILLER_83_464 VGND VGND VPWR VPWR sky130_fd_sc_hd__decap_3
X_4079_ _4079_/A _4080_/A _4079_/C _4079_/D VGND VGND VPWR VPWR _4080_/B sky130_fd_sc_hd__nand4_2
XFILLER_43_328 VGND VGND VPWR VPWR sky130_fd_sc_hd__decap_3
XFILLER_24_553 VGND VGND VPWR VPWR sky130_fd_sc_hd__decap_3
XFILLER_34_35 VGND VGND VPWR VPWR sky130_fd_sc_hd__decap_3
XFILLER_36_391 VGND VGND VPWR VPWR sky130_fd_sc_hd__decap_3
XFILLER_70_136 VGND VGND VPWR VPWR sky130_fd_sc_hd__decap_3
XFILLER_70_147 VGND VGND VPWR VPWR sky130_fd_sc_hd__decap_3
XFILLER_51_383 VGND VGND VPWR VPWR sky130_fd_sc_hd__decap_3
XTAP_TAPCELL_ROW_34_570 VGND VPWR sky130_fd_sc_hd__tapvpwrvgnd_1
XFILLER_11_225 VGND VGND VPWR VPWR sky130_fd_sc_hd__decap_3
XFILLER_7_207 VGND VGND VPWR VPWR sky130_fd_sc_hd__decap_3
Xwire116 _4378_/Y VGND VGND VPWR VPWR wire116/X sky130_fd_sc_hd__clkbuf_2
XFILLER_1_3 VGND VGND VPWR VPWR sky130_fd_sc_hd__decap_3
XFILLER_78_203 VGND VGND VPWR VPWR sky130_fd_sc_hd__decap_3
XFILLER_78_236 VGND VGND VPWR VPWR sky130_fd_sc_hd__decap_3
XFILLER_59_87 VGND VGND VPWR VPWR sky130_fd_sc_hd__decap_3
XFILLER_46_100 VGND VGND VPWR VPWR sky130_fd_sc_hd__decap_3
XFILLER_59_461 VGND VGND VPWR VPWR sky130_fd_sc_hd__decap_3
XFILLER_59_483 VGND VGND VPWR VPWR sky130_fd_sc_hd__decap_3
XFILLER_93_228 VGND VGND VPWR VPWR sky130_fd_sc_hd__decap_3
Xfanout260 _5490_/C VGND VGND VPWR VPWR _5398_/C sky130_fd_sc_hd__buf_6
Xfanout271 _3870_/A2 VGND VGND VPWR VPWR _4420_/C sky130_fd_sc_hd__dlymetal6s2s_1
XTAP_TAPCELL_ROW_6_284 VGND VPWR sky130_fd_sc_hd__tapvpwrvgnd_1
XFILLER_86_280 VGND VGND VPWR VPWR sky130_fd_sc_hd__decap_3
XFILLER_74_464 VGND VGND VPWR VPWR sky130_fd_sc_hd__decap_3
XFILLER_27_380 VGND VGND VPWR VPWR sky130_fd_sc_hd__decap_3
XFILLER_61_169 VGND VGND VPWR VPWR sky130_fd_sc_hd__decap_3
XFILLER_42_350 VGND VGND VPWR VPWR sky130_fd_sc_hd__decap_3
XFILLER_91_52 VGND VGND VPWR VPWR sky130_fd_sc_hd__decap_3
XFILLER_91_74 VGND VGND VPWR VPWR sky130_fd_sc_hd__decap_3
XFILLER_30_523 VGND VGND VPWR VPWR sky130_fd_sc_hd__decap_3
XFILLER_42_394 VGND VGND VPWR VPWR sky130_fd_sc_hd__fill_2
XFILLER_91_96 VGND VGND VPWR VPWR sky130_fd_sc_hd__fill_2
XTAP_TAPCELL_ROW_60_849 VGND VPWR sky130_fd_sc_hd__tapvpwrvgnd_1
XFILLER_30_589 VGND VGND VPWR VPWR sky130_fd_sc_hd__fill_1
Xwire661 wire661/A VGND VGND VPWR VPWR _5321_/B sky130_fd_sc_hd__buf_6
XFILLER_10_291 VGND VGND VPWR VPWR sky130_fd_sc_hd__fill_2
XFILLER_6_251 VGND VGND VPWR VPWR sky130_fd_sc_hd__fill_1
Xwire672 input1/X VGND VGND VPWR VPWR wire672/X sky130_fd_sc_hd__buf_6
XFILLER_69_225 VGND VGND VPWR VPWR sky130_fd_sc_hd__decap_3
X_5120_ _5120_/A _5120_/B _5120_/C VGND VGND VPWR VPWR _5120_/X sky130_fd_sc_hd__and3_2
XFILLER_69_258 VGND VGND VPWR VPWR sky130_fd_sc_hd__decap_3
Xload_slew655 _4538_/A VGND VGND VPWR VPWR _6248_/B sky130_fd_sc_hd__clkbuf_4
X_5051_ _5051_/A1 _4967_/C _4967_/A VGND VGND VPWR VPWR _5052_/C sky130_fd_sc_hd__o21ai_2
XFILLER_84_206 VGND VGND VPWR VPWR sky130_fd_sc_hd__decap_3
X_4002_ _6003_/A _4002_/B VGND VGND VPWR VPWR _4009_/A sky130_fd_sc_hd__or2_2
XTAP_TAPCELL_ROW_68_927 VGND VPWR sky130_fd_sc_hd__tapvpwrvgnd_1
XFILLER_65_431 VGND VGND VPWR VPWR sky130_fd_sc_hd__decap_3
XFILLER_65_464 VGND VGND VPWR VPWR sky130_fd_sc_hd__decap_3
XFILLER_80_401 VGND VGND VPWR VPWR sky130_fd_sc_hd__decap_3
XFILLER_92_250 VGND VGND VPWR VPWR sky130_fd_sc_hd__fill_2
XFILLER_37_188 VGND VGND VPWR VPWR sky130_fd_sc_hd__decap_3
XFILLER_52_103 VGND VGND VPWR VPWR sky130_fd_sc_hd__decap_3
XFILLER_65_497 VGND VGND VPWR VPWR sky130_fd_sc_hd__decap_3
XFILLER_52_147 VGND VGND VPWR VPWR sky130_fd_sc_hd__decap_3
XFILLER_80_456 VGND VGND VPWR VPWR sky130_fd_sc_hd__decap_3
X_5953_ _3872_/A _5953_/A2 _3873_/A _3871_/A VGND VGND VPWR VPWR _5963_/A sky130_fd_sc_hd__a31o_2
XFILLER_33_372 VGND VGND VPWR VPWR sky130_fd_sc_hd__decap_3
XFILLER_40_309 VGND VGND VPWR VPWR sky130_fd_sc_hd__decap_3
XFILLER_80_489 VGND VGND VPWR VPWR sky130_fd_sc_hd__decap_3
X_5884_ _4497_/B _4497_/C _4497_/A VGND VGND VPWR VPWR _5885_/C sky130_fd_sc_hd__a21o_2
X_4904_ _4904_/A VGND VGND VPWR VPWR _4904_/Y sky130_fd_sc_hd__inv_2
XFILLER_21_556 VGND VGND VPWR VPWR sky130_fd_sc_hd__decap_3
X_4835_ _4835_/A _4835_/B VGND VGND VPWR VPWR _4836_/C sky130_fd_sc_hd__xnor2_2
X_4766_ _4979_/A _4766_/B VGND VGND VPWR VPWR _4766_/Y sky130_fd_sc_hd__nand2_2
XTAP_TAPCELL_ROW_31_540 VGND VPWR sky130_fd_sc_hd__tapvpwrvgnd_1
X_6505_ _6832_/S _6505_/B VGND VGND VPWR VPWR _6505_/X sky130_fd_sc_hd__and2_2
X_3717_ _3717_/A _3717_/B _3717_/C VGND VGND VPWR VPWR _3723_/A sky130_fd_sc_hd__nand3_2
X_4697_ _4697_/A _4697_/B _4697_/C VGND VGND VPWR VPWR _4722_/A sky130_fd_sc_hd__or3_4
XFILLER_20_48 VGND VGND VPWR VPWR sky130_fd_sc_hd__decap_3
X_6436_ _6439_/A _5477_/A _6224_/A _5701_/A _5777_/B _6432_/S VGND VGND VPWR VPWR
+ _6436_/X sky130_fd_sc_hd__mux4_2
X_3648_ _3648_/A _4122_/A VGND VGND VPWR VPWR _3650_/B sky130_fd_sc_hd__nand2_2
X_6367_ _6367_/A _6498_/B VGND VGND VPWR VPWR _6393_/B sky130_fd_sc_hd__nor2_2
X_3579_ _3578_/A _3977_/B _5983_/C _3639_/A VGND VGND VPWR VPWR _3580_/B sky130_fd_sc_hd__a22o_2
XFILLER_0_416 VGND VGND VPWR VPWR sky130_fd_sc_hd__decap_3
XFILLER_0_427 VGND VGND VPWR VPWR sky130_fd_sc_hd__decap_3
XFILLER_88_523 VGND VGND VPWR VPWR sky130_fd_sc_hd__decap_3
X_5318_ _5338_/A _5317_/C _5317_/A VGND VGND VPWR VPWR _5319_/C sky130_fd_sc_hd__a21o_2
XFILLER_0_449 VGND VGND VPWR VPWR sky130_fd_sc_hd__decap_3
XFILLER_88_567 VGND VGND VPWR VPWR sky130_fd_sc_hd__decap_3
X_6298_ _3663_/A _6144_/A _6410_/S VGND VGND VPWR VPWR _6298_/X sky130_fd_sc_hd__mux2_1
XFILLER_29_57 VGND VGND VPWR VPWR sky130_fd_sc_hd__fill_2
XFILLER_75_206 VGND VGND VPWR VPWR sky130_fd_sc_hd__decap_3
XFILLER_88_589 VGND VGND VPWR VPWR sky130_fd_sc_hd__decap_3
X_5249_ _5250_/A _5250_/B _5831_/A VGND VGND VPWR VPWR _5249_/Y sky130_fd_sc_hd__nor3b_4
XFILLER_28_111 VGND VGND VPWR VPWR sky130_fd_sc_hd__decap_3
XFILLER_56_475 VGND VGND VPWR VPWR sky130_fd_sc_hd__fill_1
XFILLER_90_209 VGND VGND VPWR VPWR sky130_fd_sc_hd__decap_3
XFILLER_16_317 VGND VGND VPWR VPWR sky130_fd_sc_hd__decap_3
XFILLER_28_188 VGND VGND VPWR VPWR sky130_fd_sc_hd__decap_3
XFILLER_71_412 VGND VGND VPWR VPWR sky130_fd_sc_hd__decap_3
XFILLER_83_261 VGND VGND VPWR VPWR sky130_fd_sc_hd__decap_3
XFILLER_43_147 VGND VGND VPWR VPWR sky130_fd_sc_hd__decap_3
XFILLER_45_67 VGND VGND VPWR VPWR sky130_fd_sc_hd__decap_3
XFILLER_12_501 VGND VGND VPWR VPWR sky130_fd_sc_hd__decap_3
XFILLER_24_350 VGND VGND VPWR VPWR sky130_fd_sc_hd__fill_2
XFILLER_12_589 VGND VGND VPWR VPWR sky130_fd_sc_hd__decap_3
XFILLER_98_309 VGND VGND VPWR VPWR sky130_fd_sc_hd__decap_3
XFILLER_79_556 VGND VGND VPWR VPWR sky130_fd_sc_hd__decap_3
XFILLER_66_206 VGND VGND VPWR VPWR sky130_fd_sc_hd__decap_3
XFILLER_86_52 VGND VGND VPWR VPWR sky130_fd_sc_hd__decap_3
XFILLER_94_526 VGND VGND VPWR VPWR sky130_fd_sc_hd__decap_3
XFILLER_47_420 VGND VGND VPWR VPWR sky130_fd_sc_hd__decap_3
XFILLER_66_239 VGND VGND VPWR VPWR sky130_fd_sc_hd__fill_2
XFILLER_86_85 VGND VGND VPWR VPWR sky130_fd_sc_hd__decap_3
XFILLER_94_548 VGND VGND VPWR VPWR sky130_fd_sc_hd__decap_3
XFILLER_34_103 VGND VGND VPWR VPWR sky130_fd_sc_hd__decap_3
XFILLER_34_136 VGND VGND VPWR VPWR sky130_fd_sc_hd__decap_3
XFILLER_34_158 VGND VGND VPWR VPWR sky130_fd_sc_hd__fill_2
XFILLER_15_361 VGND VGND VPWR VPWR sky130_fd_sc_hd__decap_3
XFILLER_22_309 VGND VGND VPWR VPWR sky130_fd_sc_hd__decap_3
XTAP_TAPCELL_ROW_73_985 VGND VPWR sky130_fd_sc_hd__tapvpwrvgnd_1
XTAP_TAPCELL_ROW_45_687 VGND VPWR sky130_fd_sc_hd__tapvpwrvgnd_1
X_4620_ _4617_/A _4617_/B _4632_/B _4619_/A VGND VGND VPWR VPWR _4625_/A sky130_fd_sc_hd__a31o_2
X_4551_ _4551_/A _4900_/B _4552_/B VGND VGND VPWR VPWR _4551_/X sky130_fd_sc_hd__and3_2
XTAP_TAPCELL_ROW_77_1022 VGND VPWR sky130_fd_sc_hd__tapvpwrvgnd_1
XFILLER_7_582 VGND VGND VPWR VPWR sky130_fd_sc_hd__decap_3
X_4482_ _4482_/A _4482_/B _4482_/C _4482_/D VGND VGND VPWR VPWR _4485_/B sky130_fd_sc_hd__and4_2
X_3502_ _3868_/A VGND VGND VPWR VPWR _5956_/B sky130_fd_sc_hd__inv_2
X_6221_ _6126_/B _6439_/A VGND VGND VPWR VPWR _6221_/X sky130_fd_sc_hd__and2b_2
X_6152_ _6152_/A _6211_/B VGND VGND VPWR VPWR _6153_/B sky130_fd_sc_hd__or2_2
X_5103_ _5240_/A _5103_/B VGND VGND VPWR VPWR _5241_/A sky130_fd_sc_hd__xor2_2
XFILLER_57_217 VGND VGND VPWR VPWR sky130_fd_sc_hd__fill_1
Xload_slew474 _6673_/A3 VGND VGND VPWR VPWR _6236_/B sky130_fd_sc_hd__buf_4
X_6083_ _6083_/A _6083_/B VGND VGND VPWR VPWR _6166_/B sky130_fd_sc_hd__or2_2
XFILLER_57_228 VGND VGND VPWR VPWR sky130_fd_sc_hd__decap_3
X_5034_ _5382_/A _5188_/C _5290_/C _5382_/B VGND VGND VPWR VPWR _5035_/C sky130_fd_sc_hd__a22oi_2
XFILLER_72_209 VGND VGND VPWR VPWR sky130_fd_sc_hd__decap_3
XTAP_TAPCELL_ROW_88_1140 VGND VPWR sky130_fd_sc_hd__tapvpwrvgnd_1
XTAP_TAPCELL_ROW_0_202 VGND VPWR sky130_fd_sc_hd__tapvpwrvgnd_1
XFILLER_25_103 VGND VGND VPWR VPWR sky130_fd_sc_hd__decap_3
XFILLER_38_475 VGND VGND VPWR VPWR sky130_fd_sc_hd__fill_1
XFILLER_53_412 VGND VGND VPWR VPWR sky130_fd_sc_hd__decap_3
XFILLER_65_272 VGND VGND VPWR VPWR sky130_fd_sc_hd__decap_3
XTAP_TAPCELL_ROW_0_213 VGND VPWR sky130_fd_sc_hd__tapvpwrvgnd_1
XFILLER_93_581 VGND VGND VPWR VPWR sky130_fd_sc_hd__decap_3
XFILLER_53_445 VGND VGND VPWR VPWR sky130_fd_sc_hd__decap_3
X_6985_ _6985_/A _6985_/B _6985_/C _6985_/D VGND VGND VPWR VPWR _6986_/C sky130_fd_sc_hd__or4_4
XFILLER_25_169 VGND VGND VPWR VPWR sky130_fd_sc_hd__decap_3
XFILLER_40_117 VGND VGND VPWR VPWR sky130_fd_sc_hd__decap_3
XFILLER_53_478 VGND VGND VPWR VPWR sky130_fd_sc_hd__fill_1
XFILLER_80_253 VGND VGND VPWR VPWR sky130_fd_sc_hd__decap_3
X_5936_ _5917_/X _5930_/X _5930_/B _5934_/X _6935_/A VGND VGND VPWR VPWR _5936_/X
+ sky130_fd_sc_hd__a221o_2
XFILLER_40_139 VGND VGND VPWR VPWR sky130_fd_sc_hd__fill_1
X_5867_ _5869_/B1 _5869_/C1 _5862_/Y _5866_/X VGND VGND VPWR VPWR _5871_/C sky130_fd_sc_hd__o211a_2
XFILLER_21_386 VGND VGND VPWR VPWR sky130_fd_sc_hd__decap_3
X_5798_ _6373_/A _6220_/B VGND VGND VPWR VPWR _6375_/A sky130_fd_sc_hd__nand2_2
X_4818_ _4773_/B _4775_/B _4815_/X _4817_/Y VGND VGND VPWR VPWR _4818_/X sky130_fd_sc_hd__a211o_2
XFILLER_5_508 VGND VGND VPWR VPWR sky130_fd_sc_hd__decap_3
X_4749_ _4749_/A _5680_/B VGND VGND VPWR VPWR _4953_/A sky130_fd_sc_hd__nand2_2
Xrebuffer679 _5746_/B VGND VGND VPWR VPWR _5745_/B sky130_fd_sc_hd__buf_2
X_6419_ _6760_/S _6419_/B VGND VGND VPWR VPWR _6420_/B sky130_fd_sc_hd__nand2_2
XTAP_TAPCELL_ROW_8_302 VGND VPWR sky130_fd_sc_hd__tapvpwrvgnd_1
XFILLER_0_246 VGND VGND VPWR VPWR sky130_fd_sc_hd__decap_3
Xoutput69 _7000_/X VGND VGND VPWR VPWR carry sky130_fd_sc_hd__dlymetal6s4s_1
XFILLER_76_515 VGND VGND VPWR VPWR sky130_fd_sc_hd__decap_3
XFILLER_88_353 VGND VGND VPWR VPWR sky130_fd_sc_hd__decap_3
XFILLER_48_239 VGND VGND VPWR VPWR sky130_fd_sc_hd__decap_3
XFILLER_29_464 VGND VGND VPWR VPWR sky130_fd_sc_hd__decap_3
XFILLER_63_209 VGND VGND VPWR VPWR sky130_fd_sc_hd__decap_3
XFILLER_56_88 VGND VGND VPWR VPWR sky130_fd_sc_hd__decap_3
XFILLER_71_231 VGND VGND VPWR VPWR sky130_fd_sc_hd__decap_3
XFILLER_16_158 VGND VGND VPWR VPWR sky130_fd_sc_hd__decap_3
XFILLER_71_264 VGND VGND VPWR VPWR sky130_fd_sc_hd__decap_3
XFILLER_72_32 VGND VGND VPWR VPWR sky130_fd_sc_hd__decap_3
XTAP_TAPCELL_ROW_70_955 VGND VPWR sky130_fd_sc_hd__tapvpwrvgnd_1
XFILLER_12_342 VGND VGND VPWR VPWR sky130_fd_sc_hd__fill_2
XTAP_TAPCELL_ROW_42_657 VGND VPWR sky130_fd_sc_hd__tapvpwrvgnd_1
XTAP_TAPCELL_ROW_14_359 VGND VPWR sky130_fd_sc_hd__tapvpwrvgnd_1
XFILLER_68_9 VGND VGND VPWR VPWR sky130_fd_sc_hd__decap_3
XFILLER_79_320 VGND VGND VPWR VPWR sky130_fd_sc_hd__decap_3
XFILLER_79_364 VGND VGND VPWR VPWR sky130_fd_sc_hd__decap_3
XFILLER_39_228 VGND VGND VPWR VPWR sky130_fd_sc_hd__decap_3
XFILLER_94_312 VGND VGND VPWR VPWR sky130_fd_sc_hd__decap_3
XFILLER_75_570 VGND VGND VPWR VPWR sky130_fd_sc_hd__decap_3
XFILLER_62_242 VGND VGND VPWR VPWR sky130_fd_sc_hd__decap_3
XFILLER_62_253 VGND VGND VPWR VPWR sky130_fd_sc_hd__decap_3
X_6770_ _6770_/A _6770_/B VGND VGND VPWR VPWR _6770_/Y sky130_fd_sc_hd__nand2_2
X_3982_ _3982_/A _3982_/B VGND VGND VPWR VPWR _3983_/B sky130_fd_sc_hd__nor2_2
XFILLER_22_139 VGND VGND VPWR VPWR sky130_fd_sc_hd__fill_1
XFILLER_90_595 VGND VGND VPWR VPWR sky130_fd_sc_hd__decap_3
X_5721_ _5721_/A _5721_/B VGND VGND VPWR VPWR _5746_/A sky130_fd_sc_hd__xnor2_2
XTAP_TAPCELL_ROW_83_1092 VGND VPWR sky130_fd_sc_hd__tapvpwrvgnd_1
XFILLER_30_172 VGND VGND VPWR VPWR sky130_fd_sc_hd__fill_2
X_5652_ _5652_/A _5652_/B VGND VGND VPWR VPWR _6687_/A sky130_fd_sc_hd__and2_4
XFILLER_30_194 VGND VGND VPWR VPWR sky130_fd_sc_hd__fill_2
X_5583_ _5583_/A _5583_/B VGND VGND VPWR VPWR _5596_/A sky130_fd_sc_hd__xnor2_2
X_4603_ _4603_/A _4603_/B VGND VGND VPWR VPWR _4604_/B sky130_fd_sc_hd__and2_2
XFILLER_7_60 VGND VGND VPWR VPWR sky130_fd_sc_hd__decap_3
X_4534_ _4551_/A _6319_/S VGND VGND VPWR VPWR _4552_/A sky130_fd_sc_hd__nand2_2
X_4465_ _4465_/A _4473_/B _4465_/C VGND VGND VPWR VPWR _4888_/A sky130_fd_sc_hd__or3_2
X_6204_ _6348_/A _6200_/A _6971_/A _6778_/B1 VGND VGND VPWR VPWR _6204_/X sky130_fd_sc_hd__a31o_2
X_4396_ _4285_/A _4285_/C _4285_/B VGND VGND VPWR VPWR _4397_/C sky130_fd_sc_hd__a21o_2
X_6135_ _6381_/B _6134_/X _6117_/A VGND VGND VPWR VPWR _6583_/B sky130_fd_sc_hd__o21ai_2
XFILLER_85_323 VGND VGND VPWR VPWR sky130_fd_sc_hd__decap_3
X_6066_ _6331_/A _6999_/A VGND VGND VPWR VPWR _6348_/A sky130_fd_sc_hd__nand2_2
Xload_slew293 _5491_/B VGND VGND VPWR VPWR _5399_/B sky130_fd_sc_hd__buf_4
X_5017_ _5017_/A _5017_/B VGND VGND VPWR VPWR _5022_/A sky130_fd_sc_hd__xnor2_2
XFILLER_26_401 VGND VGND VPWR VPWR sky130_fd_sc_hd__decap_3
XFILLER_85_378 VGND VGND VPWR VPWR sky130_fd_sc_hd__decap_3
XFILLER_26_36 VGND VGND VPWR VPWR sky130_fd_sc_hd__decap_3
XFILLER_26_47 VGND VGND VPWR VPWR sky130_fd_sc_hd__decap_3
XFILLER_53_231 VGND VGND VPWR VPWR sky130_fd_sc_hd__decap_3
XFILLER_53_264 VGND VGND VPWR VPWR sky130_fd_sc_hd__decap_3
XFILLER_53_297 VGND VGND VPWR VPWR sky130_fd_sc_hd__fill_1
X_6968_ _6982_/A2 _6952_/Y _6967_/X VGND VGND VPWR VPWR _6994_/A sky130_fd_sc_hd__a21o_4
X_6899_ _3486_/Y _6182_/B _6890_/A _6273_/B VGND VGND VPWR VPWR _6899_/X sky130_fd_sc_hd__a211o_2
X_5919_ _4565_/A _4563_/X _4304_/X _4306_/Y VGND VGND VPWR VPWR _5919_/X sky130_fd_sc_hd__o211a_2
XFILLER_21_161 VGND VGND VPWR VPWR sky130_fd_sc_hd__decap_3
XTAP_TAPCELL_ROW_11_329 VGND VPWR sky130_fd_sc_hd__tapvpwrvgnd_1
XTAP_TAPCELL_ROW_97_1239 VGND VPWR sky130_fd_sc_hd__tapvpwrvgnd_1
XFILLER_5_327 VGND VGND VPWR VPWR sky130_fd_sc_hd__decap_3
XFILLER_1_544 VGND VGND VPWR VPWR sky130_fd_sc_hd__fill_1
XFILLER_88_150 VGND VGND VPWR VPWR sky130_fd_sc_hd__decap_3
XFILLER_49_548 VGND VGND VPWR VPWR sky130_fd_sc_hd__fill_2
XFILLER_76_312 VGND VGND VPWR VPWR sky130_fd_sc_hd__decap_3
XFILLER_88_183 VGND VGND VPWR VPWR sky130_fd_sc_hd__decap_3
XFILLER_64_507 VGND VGND VPWR VPWR sky130_fd_sc_hd__decap_3
XFILLER_67_76 VGND VGND VPWR VPWR sky130_fd_sc_hd__decap_3
XFILLER_67_98 VGND VGND VPWR VPWR sky130_fd_sc_hd__fill_2
XFILLER_91_315 VGND VGND VPWR VPWR sky130_fd_sc_hd__decap_3
XTAP_TAPCELL_ROW_19_418 VGND VPWR sky130_fd_sc_hd__tapvpwrvgnd_1
XFILLER_91_337 VGND VGND VPWR VPWR sky130_fd_sc_hd__decap_3
XFILLER_32_415 VGND VGND VPWR VPWR sky130_fd_sc_hd__decap_3
XFILLER_72_562 VGND VGND VPWR VPWR sky130_fd_sc_hd__decap_3
XFILLER_44_286 VGND VGND VPWR VPWR sky130_fd_sc_hd__fill_1
XFILLER_44_297 VGND VGND VPWR VPWR sky130_fd_sc_hd__decap_3
XFILLER_72_595 VGND VGND VPWR VPWR sky130_fd_sc_hd__decap_3
XTAP_TAPCELL_ROW_55_793 VGND VPWR sky130_fd_sc_hd__tapvpwrvgnd_1
XFILLER_12_150 VGND VGND VPWR VPWR sky130_fd_sc_hd__decap_3
XFILLER_12_194 VGND VGND VPWR VPWR sky130_fd_sc_hd__fill_2
X_4250_ _4227_/Y _4229_/A _4246_/Y _4251_/A2 VGND VGND VPWR VPWR _4253_/B sky130_fd_sc_hd__o211ai_2
X_4181_ _6083_/B _4181_/B _4420_/C _4538_/D VGND VGND VPWR VPWR _4184_/A sky130_fd_sc_hd__and4_2
XFILLER_67_323 VGND VGND VPWR VPWR sky130_fd_sc_hd__decap_3
XFILLER_79_172 VGND VGND VPWR VPWR sky130_fd_sc_hd__decap_3
XFILLER_94_131 VGND VGND VPWR VPWR sky130_fd_sc_hd__fill_1
XFILLER_67_389 VGND VGND VPWR VPWR sky130_fd_sc_hd__decap_3
XFILLER_94_186 VGND VGND VPWR VPWR sky130_fd_sc_hd__decap_3
XTAP_TAPCELL_ROW_85_1110 VGND VPWR sky130_fd_sc_hd__tapvpwrvgnd_1
X_6822_ _6822_/A _6822_/B VGND VGND VPWR VPWR _6822_/X sky130_fd_sc_hd__xor2_2
XFILLER_23_415 VGND VGND VPWR VPWR sky130_fd_sc_hd__decap_3
XFILLER_50_212 VGND VGND VPWR VPWR sky130_fd_sc_hd__decap_3
XFILLER_50_245 VGND VGND VPWR VPWR sky130_fd_sc_hd__decap_3
XFILLER_50_256 VGND VGND VPWR VPWR sky130_fd_sc_hd__decap_3
X_6753_ _6923_/A _6739_/X _6741_/Y _6752_/X VGND VGND VPWR VPWR _6989_/C sky130_fd_sc_hd__a211o_4
X_3965_ _3966_/A _3966_/B VGND VGND VPWR VPWR _3984_/A sky130_fd_sc_hd__nand2_2
XFILLER_50_289 VGND VGND VPWR VPWR sky130_fd_sc_hd__fill_1
X_6684_ _6146_/Y _6819_/A2 _6672_/X _6683_/X _6671_/X VGND VGND VPWR VPWR _6684_/X
+ sky130_fd_sc_hd__a311o_2
X_5704_ _5703_/B _5703_/C _5703_/A VGND VGND VPWR VPWR _5705_/C sky130_fd_sc_hd__o21bai_2
X_3896_ _3897_/A _3897_/B VGND VGND VPWR VPWR _3916_/A sky130_fd_sc_hd__nand2_2
XFILLER_12_27 VGND VGND VPWR VPWR sky130_fd_sc_hd__fill_1
X_5635_ _5634_/A _5634_/B _5634_/C VGND VGND VPWR VPWR _5636_/D sky130_fd_sc_hd__a21o_2
XFILLER_12_38 VGND VGND VPWR VPWR sky130_fd_sc_hd__fill_1
X_5566_ _5409_/X _5411_/Y _5566_/B1 _5565_/X VGND VGND VPWR VPWR _5566_/Y sky130_fd_sc_hd__a211oi_2
XFILLER_2_319 VGND VGND VPWR VPWR sky130_fd_sc_hd__fill_1
X_5497_ _6109_/A _5536_/B VGND VGND VPWR VPWR _5527_/A sky130_fd_sc_hd__nand2_2
X_4517_ _4662_/B _4659_/A _4517_/C _4517_/D VGND VGND VPWR VPWR _4517_/X sky130_fd_sc_hd__and4_2
X_4448_ _4448_/A _4448_/B VGND VGND VPWR VPWR _4451_/B sky130_fd_sc_hd__xor2_2
Xfanout612 _6879_/B2 VGND VGND VPWR VPWR _4551_/A sky130_fd_sc_hd__clkdlybuf4s25_1
Xfanout623 input15/X VGND VGND VPWR VPWR fanout623/X sky130_fd_sc_hd__clkdlybuf4s25_1
XFILLER_58_312 VGND VGND VPWR VPWR sky130_fd_sc_hd__decap_3
Xfanout634 _6014_/B VGND VGND VPWR VPWR _3757_/A sky130_fd_sc_hd__buf_6
Xfanout645 _4003_/B VGND VGND VPWR VPWR _3955_/A sky130_fd_sc_hd__clkbuf_2
Xfanout656 input10/X VGND VGND VPWR VPWR _4282_/A sky130_fd_sc_hd__dlymetal6s4s_1
Xfanout667 _6006_/A VGND VGND VPWR VPWR _4067_/A sky130_fd_sc_hd__clkdlybuf4s25_1
X_4379_ _4378_/A _4439_/C1 _4254_/A _4329_/X VGND VGND VPWR VPWR _4440_/A sky130_fd_sc_hd__o211a_2
XFILLER_98_470 VGND VGND VPWR VPWR sky130_fd_sc_hd__fill_1
XFILLER_37_13 VGND VGND VPWR VPWR sky130_fd_sc_hd__decap_3
X_6118_ _6228_/A _6118_/B VGND VGND VPWR VPWR _6120_/B sky130_fd_sc_hd__nor2_2
XFILLER_100_464 VGND VGND VPWR VPWR sky130_fd_sc_hd__decap_3
XFILLER_100_486 VGND VGND VPWR VPWR sky130_fd_sc_hd__decap_3
XFILLER_37_57 VGND VGND VPWR VPWR sky130_fd_sc_hd__fill_2
XFILLER_46_529 VGND VGND VPWR VPWR sky130_fd_sc_hd__decap_3
XFILLER_58_389 VGND VGND VPWR VPWR sky130_fd_sc_hd__decap_3
XFILLER_73_315 VGND VGND VPWR VPWR sky130_fd_sc_hd__decap_3
X_6049_ _6049_/A _6049_/B VGND VGND VPWR VPWR _6050_/B sky130_fd_sc_hd__xnor2_2
XFILLER_73_337 VGND VGND VPWR VPWR sky130_fd_sc_hd__fill_1
XFILLER_26_253 VGND VGND VPWR VPWR sky130_fd_sc_hd__fill_2
XFILLER_54_562 VGND VGND VPWR VPWR sky130_fd_sc_hd__decap_3
XFILLER_53_45 VGND VGND VPWR VPWR sky130_fd_sc_hd__decap_3
XFILLER_54_595 VGND VGND VPWR VPWR sky130_fd_sc_hd__decap_3
XFILLER_41_245 VGND VGND VPWR VPWR sky130_fd_sc_hd__decap_3
XTAP_TAPCELL_ROW_52_763 VGND VPWR sky130_fd_sc_hd__tapvpwrvgnd_1
XTAP_TAPCELL_ROW_24_465 VGND VPWR sky130_fd_sc_hd__tapvpwrvgnd_1
XFILLER_5_113 VGND VGND VPWR VPWR sky130_fd_sc_hd__fill_2
XFILLER_78_64 VGND VGND VPWR VPWR sky130_fd_sc_hd__decap_3
XFILLER_96_418 VGND VGND VPWR VPWR sky130_fd_sc_hd__fill_2
XFILLER_49_323 VGND VGND VPWR VPWR sky130_fd_sc_hd__decap_3
XFILLER_49_367 VGND VGND VPWR VPWR sky130_fd_sc_hd__decap_3
XFILLER_64_315 VGND VGND VPWR VPWR sky130_fd_sc_hd__decap_3
XFILLER_76_153 VGND VGND VPWR VPWR sky130_fd_sc_hd__decap_3
XFILLER_17_220 VGND VGND VPWR VPWR sky130_fd_sc_hd__decap_3
XFILLER_64_348 VGND VGND VPWR VPWR sky130_fd_sc_hd__decap_3
XFILLER_76_197 VGND VGND VPWR VPWR sky130_fd_sc_hd__fill_1
XFILLER_94_85 VGND VGND VPWR VPWR sky130_fd_sc_hd__decap_3
XFILLER_17_253 VGND VGND VPWR VPWR sky130_fd_sc_hd__decap_3
XFILLER_45_595 VGND VGND VPWR VPWR sky130_fd_sc_hd__decap_3
XFILLER_20_429 VGND VGND VPWR VPWR sky130_fd_sc_hd__decap_3
XFILLER_60_576 VGND VGND VPWR VPWR sky130_fd_sc_hd__fill_2
X_3750_ _3748_/A _4662_/C _4662_/D input8/X VGND VGND VPWR VPWR _3751_/B sky130_fd_sc_hd__a22o_2
XTAP_TAPCELL_ROW_80_1062 VGND VPWR sky130_fd_sc_hd__tapvpwrvgnd_1
XFILLER_13_492 VGND VGND VPWR VPWR sky130_fd_sc_hd__decap_3
X_3681_ _3680_/A _3851_/B _5948_/A _6079_/B VGND VGND VPWR VPWR _3682_/B sky130_fd_sc_hd__a22oi_2
XFILLER_9_485 VGND VGND VPWR VPWR sky130_fd_sc_hd__fill_1
XFILLER_64_3 VGND VGND VPWR VPWR sky130_fd_sc_hd__decap_3
X_5420_ _5420_/A _5420_/B VGND VGND VPWR VPWR _5421_/B sky130_fd_sc_hd__nand2_2
X_5351_ _5351_/A _5428_/A _5351_/C VGND VGND VPWR VPWR _5428_/B sky130_fd_sc_hd__nand3_2
X_5282_ _5395_/A _5282_/B VGND VGND VPWR VPWR _5360_/A sky130_fd_sc_hd__nand2_2
X_4302_ _4302_/A _4302_/B _4302_/C VGND VGND VPWR VPWR _4418_/A sky130_fd_sc_hd__and3_2
XFILLER_99_245 VGND VGND VPWR VPWR sky130_fd_sc_hd__fill_1
XFILLER_99_234 VGND VGND VPWR VPWR sky130_fd_sc_hd__decap_3
XFILLER_99_223 VGND VGND VPWR VPWR sky130_fd_sc_hd__fill_1
X_4233_ _4476_/A _4593_/C _4593_/D _4482_/A VGND VGND VPWR VPWR _4234_/B sky130_fd_sc_hd__a22o_2
XFILLER_99_256 VGND VGND VPWR VPWR sky130_fd_sc_hd__decap_3
XFILLER_4_72 VGND VGND VPWR VPWR sky130_fd_sc_hd__decap_3
XFILLER_87_429 VGND VGND VPWR VPWR sky130_fd_sc_hd__decap_3
XFILLER_67_142 VGND VGND VPWR VPWR sky130_fd_sc_hd__decap_3
X_4164_ _4280_/B _4282_/A _4406_/C _4406_/D VGND VGND VPWR VPWR _4167_/A sky130_fd_sc_hd__and4_2
XFILLER_55_315 VGND VGND VPWR VPWR sky130_fd_sc_hd__decap_3
XFILLER_67_175 VGND VGND VPWR VPWR sky130_fd_sc_hd__decap_3
XFILLER_82_101 VGND VGND VPWR VPWR sky130_fd_sc_hd__decap_3
X_4095_ _4095_/A _4095_/B VGND VGND VPWR VPWR _4103_/A sky130_fd_sc_hd__xnor2_2
XFILLER_95_473 VGND VGND VPWR VPWR sky130_fd_sc_hd__decap_3
XFILLER_82_123 VGND VGND VPWR VPWR sky130_fd_sc_hd__fill_1
XFILLER_95_495 VGND VGND VPWR VPWR sky130_fd_sc_hd__decap_3
XFILLER_82_167 VGND VGND VPWR VPWR sky130_fd_sc_hd__decap_3
XFILLER_23_223 VGND VGND VPWR VPWR sky130_fd_sc_hd__fill_1
XFILLER_36_573 VGND VGND VPWR VPWR sky130_fd_sc_hd__fill_2
XFILLER_36_595 VGND VGND VPWR VPWR sky130_fd_sc_hd__decap_3
XFILLER_63_370 VGND VGND VPWR VPWR sky130_fd_sc_hd__decap_3
XFILLER_23_234 VGND VGND VPWR VPWR sky130_fd_sc_hd__fill_1
XFILLER_51_543 VGND VGND VPWR VPWR sky130_fd_sc_hd__decap_3
X_6805_ _6819_/A2 _6795_/Y _6803_/X _6804_/X VGND VGND VPWR VPWR _6983_/A sky130_fd_sc_hd__a211o_2
XFILLER_23_267 VGND VGND VPWR VPWR sky130_fd_sc_hd__decap_3
X_6736_ _6757_/C _6725_/Y _6727_/Y _6819_/A2 _6735_/Y VGND VGND VPWR VPWR _6736_/X
+ sky130_fd_sc_hd__a221o_2
X_4997_ _4994_/A _4995_/Y _4991_/A _5084_/A VGND VGND VPWR VPWR _4998_/D sky130_fd_sc_hd__o211ai_2
X_3948_ _6039_/A _3947_/B _3947_/C VGND VGND VPWR VPWR _3950_/C sky130_fd_sc_hd__o21a_2
XTAP_TAPCELL_ROW_21_435 VGND VPWR sky130_fd_sc_hd__tapvpwrvgnd_1
X_6667_ _6923_/A _6650_/X _6651_/Y _6666_/X VGND VGND VPWR VPWR _6988_/A sky130_fd_sc_hd__a31o_2
X_3879_ _3880_/A _3880_/B _3880_/C VGND VGND VPWR VPWR _3881_/A sky130_fd_sc_hd__o21a_2
X_6598_ _6597_/A _6597_/B _6777_/A VGND VGND VPWR VPWR _6598_/Y sky130_fd_sc_hd__a21oi_2
X_5618_ _5618_/A _5618_/B VGND VGND VPWR VPWR _5645_/A sky130_fd_sc_hd__xnor2_2
XTAP_TAPCELL_ROW_94_1209 VGND VPWR sky130_fd_sc_hd__tapvpwrvgnd_1
X_5549_ _5579_/A _5579_/B _5579_/C VGND VGND VPWR VPWR _5599_/A sky130_fd_sc_hd__o21a_2
XFILLER_2_138 VGND VGND VPWR VPWR sky130_fd_sc_hd__fill_2
XFILLER_78_418 VGND VGND VPWR VPWR sky130_fd_sc_hd__fill_2
Xfanout431 _6212_/B VGND VGND VPWR VPWR _5115_/B sky130_fd_sc_hd__buf_4
XFILLER_58_131 VGND VGND VPWR VPWR sky130_fd_sc_hd__decap_3
Xfanout442 _3941_/B VGND VGND VPWR VPWR _4662_/C sky130_fd_sc_hd__dlymetal6s4s_1
Xfanout464 _6402_/S VGND VGND VPWR VPWR _3867_/B sky130_fd_sc_hd__dlymetal6s4s_1
Xfanout475 wire482/A VGND VGND VPWR VPWR fanout475/X sky130_fd_sc_hd__buf_4
XFILLER_58_175 VGND VGND VPWR VPWR sky130_fd_sc_hd__decap_3
Xfanout497 _5361_/A VGND VGND VPWR VPWR _5134_/A sky130_fd_sc_hd__buf_4
XTAP_TAPCELL_ROW_57_811 VGND VPWR sky130_fd_sc_hd__tapvpwrvgnd_1
XFILLER_58_197 VGND VGND VPWR VPWR sky130_fd_sc_hd__decap_3
XFILLER_73_134 VGND VGND VPWR VPWR sky130_fd_sc_hd__decap_3
XTAP_TAPCELL_ROW_29_524 VGND VPWR sky130_fd_sc_hd__tapvpwrvgnd_1
XFILLER_64_44 VGND VGND VPWR VPWR sky130_fd_sc_hd__decap_3
XFILLER_73_156 VGND VGND VPWR VPWR sky130_fd_sc_hd__decap_3
XFILLER_27_595 VGND VGND VPWR VPWR sky130_fd_sc_hd__decap_3
XFILLER_64_88 VGND VGND VPWR VPWR sky130_fd_sc_hd__decap_3
XFILLER_73_178 VGND VGND VPWR VPWR sky130_fd_sc_hd__decap_3
XFILLER_14_223 VGND VGND VPWR VPWR sky130_fd_sc_hd__fill_2
XFILLER_14_256 VGND VGND VPWR VPWR sky130_fd_sc_hd__fill_1
XFILLER_42_543 VGND VGND VPWR VPWR sky130_fd_sc_hd__decap_3
XFILLER_80_43 VGND VGND VPWR VPWR sky130_fd_sc_hd__fill_1
XFILLER_10_473 VGND VGND VPWR VPWR sky130_fd_sc_hd__decap_3
XFILLER_6_466 VGND VGND VPWR VPWR sky130_fd_sc_hd__fill_2
XFILLER_69_418 VGND VGND VPWR VPWR sky130_fd_sc_hd__decap_3
XFILLER_96_237 VGND VGND VPWR VPWR sky130_fd_sc_hd__decap_3
XFILLER_37_304 VGND VGND VPWR VPWR sky130_fd_sc_hd__decap_3
XFILLER_49_142 VGND VGND VPWR VPWR sky130_fd_sc_hd__decap_3
XFILLER_49_175 VGND VGND VPWR VPWR sky130_fd_sc_hd__decap_3
XFILLER_37_337 VGND VGND VPWR VPWR sky130_fd_sc_hd__decap_3
XFILLER_92_421 VGND VGND VPWR VPWR sky130_fd_sc_hd__fill_1
XFILLER_92_443 VGND VGND VPWR VPWR sky130_fd_sc_hd__decap_3
XFILLER_64_167 VGND VGND VPWR VPWR sky130_fd_sc_hd__decap_3
X_4920_ _5913_/A _4918_/X _4588_/Y _4591_/Y VGND VGND VPWR VPWR _4920_/X sky130_fd_sc_hd__o211a_2
XFILLER_33_543 VGND VGND VPWR VPWR sky130_fd_sc_hd__fill_2
X_4851_ _4847_/X _4849_/Y _4641_/X _4851_/C1 VGND VGND VPWR VPWR _4852_/C sky130_fd_sc_hd__o211ai_2
XFILLER_33_576 VGND VGND VPWR VPWR sky130_fd_sc_hd__decap_3
X_3802_ _3900_/A _3977_/B _3909_/D _3972_/A VGND VGND VPWR VPWR _3803_/B sky130_fd_sc_hd__a22oi_2
XFILLER_20_226 VGND VGND VPWR VPWR sky130_fd_sc_hd__decap_3
X_4782_ _6254_/B _4782_/B VGND VGND VPWR VPWR _4791_/A sky130_fd_sc_hd__nand2_2
XFILLER_20_259 VGND VGND VPWR VPWR sky130_fd_sc_hd__decap_3
X_6521_ _6569_/A _6521_/B VGND VGND VPWR VPWR _6678_/B sky130_fd_sc_hd__nand2_2
X_3733_ _3733_/A _3733_/B VGND VGND VPWR VPWR _4077_/A sky130_fd_sc_hd__xnor2_2
X_6452_ _6424_/X _6425_/Y _6451_/X VGND VGND VPWR VPWR _6985_/A sky130_fd_sc_hd__a21o_2
X_3664_ _3664_/A _3664_/B _3933_/B _3933_/D VGND VGND VPWR VPWR _3669_/B sky130_fd_sc_hd__nand4_2
XFILLER_9_293 VGND VGND VPWR VPWR sky130_fd_sc_hd__decap_3
XFILLER_9_271 VGND VGND VPWR VPWR sky130_fd_sc_hd__decap_3
X_5403_ _6109_/A _5399_/B _5361_/X _5362_/Y VGND VGND VPWR VPWR _5404_/C sky130_fd_sc_hd__o2bb2a_2
X_6383_ _6383_/A _6383_/B _6672_/B _6383_/D VGND VGND VPWR VPWR _6385_/C sky130_fd_sc_hd__or4_2
X_3595_ _3821_/A _3595_/B VGND VGND VPWR VPWR _3597_/B sky130_fd_sc_hd__nor2_2
X_5334_ _5334_/A _5334_/B VGND VGND VPWR VPWR _5390_/A sky130_fd_sc_hd__nor2_4
XFILLER_87_204 VGND VGND VPWR VPWR sky130_fd_sc_hd__fill_1
X_5265_ _5374_/A _5284_/B VGND VGND VPWR VPWR _5274_/A sky130_fd_sc_hd__nand2_2
XFILLER_68_440 VGND VGND VPWR VPWR sky130_fd_sc_hd__decap_3
X_5196_ _5194_/X _5196_/B VGND VGND VPWR VPWR _5418_/A sky130_fd_sc_hd__and2b_2
X_4216_ _4216_/A _4216_/B VGND VGND VPWR VPWR _4331_/A sky130_fd_sc_hd__xnor2_2
XFILLER_28_315 VGND VGND VPWR VPWR sky130_fd_sc_hd__decap_3
X_4147_ _4662_/B _4659_/A _4387_/C _4387_/D VGND VGND VPWR VPWR _4150_/A sky130_fd_sc_hd__nand4_2
XFILLER_28_337 VGND VGND VPWR VPWR sky130_fd_sc_hd__decap_3
XFILLER_55_101 VGND VGND VPWR VPWR sky130_fd_sc_hd__fill_1
XFILLER_55_123 VGND VGND VPWR VPWR sky130_fd_sc_hd__decap_3
XFILLER_83_421 VGND VGND VPWR VPWR sky130_fd_sc_hd__decap_3
XFILLER_83_443 VGND VGND VPWR VPWR sky130_fd_sc_hd__decap_3
XFILLER_43_307 VGND VGND VPWR VPWR sky130_fd_sc_hd__decap_3
XFILLER_55_145 VGND VGND VPWR VPWR sky130_fd_sc_hd__decap_3
X_4078_ _4057_/B _4061_/X _4072_/X _4075_/X VGND VGND VPWR VPWR _4079_/D sky130_fd_sc_hd__a211o_2
XFILLER_55_178 VGND VGND VPWR VPWR sky130_fd_sc_hd__decap_3
XFILLER_51_340 VGND VGND VPWR VPWR sky130_fd_sc_hd__fill_2
XFILLER_70_159 VGND VGND VPWR VPWR sky130_fd_sc_hd__decap_3
XFILLER_51_351 VGND VGND VPWR VPWR sky130_fd_sc_hd__decap_3
XFILLER_51_373 VGND VGND VPWR VPWR sky130_fd_sc_hd__decap_3
XTAP_TAPCELL_ROW_34_571 VGND VPWR sky130_fd_sc_hd__tapvpwrvgnd_1
XFILLER_50_13 VGND VGND VPWR VPWR sky130_fd_sc_hd__fill_2
X_6719_ _6244_/B _6781_/A2 _6716_/X _6718_/X VGND VGND VPWR VPWR _6719_/X sky130_fd_sc_hd__o211a_2
XFILLER_50_57 VGND VGND VPWR VPWR sky130_fd_sc_hd__decap_3
XFILLER_59_55 VGND VGND VPWR VPWR sky130_fd_sc_hd__fill_1
XFILLER_78_215 VGND VGND VPWR VPWR sky130_fd_sc_hd__decap_3
XFILLER_78_248 VGND VGND VPWR VPWR sky130_fd_sc_hd__decap_3
Xfanout250 input60/X VGND VGND VPWR VPWR _5947_/A sky130_fd_sc_hd__clkbuf_2
XFILLER_93_207 VGND VGND VPWR VPWR sky130_fd_sc_hd__fill_1
Xfanout261 _6779_/A VGND VGND VPWR VPWR _5490_/C sky130_fd_sc_hd__buf_6
Xfanout272 _3870_/A2 VGND VGND VPWR VPWR _6369_/A sky130_fd_sc_hd__clkdlybuf4s25_1
Xfanout283 _6314_/B VGND VGND VPWR VPWR _4978_/D sky130_fd_sc_hd__dlymetal6s4s_1
XTAP_TAPCELL_ROW_6_285 VGND VPWR sky130_fd_sc_hd__tapvpwrvgnd_1
XFILLER_46_112 VGND VGND VPWR VPWR sky130_fd_sc_hd__fill_2
XFILLER_74_410 VGND VGND VPWR VPWR sky130_fd_sc_hd__decap_3
XFILLER_74_421 VGND VGND VPWR VPWR sky130_fd_sc_hd__fill_2
XFILLER_86_292 VGND VGND VPWR VPWR sky130_fd_sc_hd__decap_3
Xfanout294 _6789_/A1 VGND VGND VPWR VPWR _6414_/S sky130_fd_sc_hd__dlymetal6s4s_1
XFILLER_46_167 VGND VGND VPWR VPWR sky130_fd_sc_hd__decap_3
XFILLER_75_76 VGND VGND VPWR VPWR sky130_fd_sc_hd__fill_1
XFILLER_75_87 VGND VGND VPWR VPWR sky130_fd_sc_hd__decap_3
XFILLER_15_521 VGND VGND VPWR VPWR sky130_fd_sc_hd__decap_3
XFILLER_91_31 VGND VGND VPWR VPWR sky130_fd_sc_hd__decap_3
XFILLER_15_576 VGND VGND VPWR VPWR sky130_fd_sc_hd__decap_3
XFILLER_30_502 VGND VGND VPWR VPWR sky130_fd_sc_hd__decap_3
XFILLER_42_362 VGND VGND VPWR VPWR sky130_fd_sc_hd__fill_2
XFILLER_24_80 VGND VGND VPWR VPWR sky130_fd_sc_hd__decap_3
XFILLER_30_568 VGND VGND VPWR VPWR sky130_fd_sc_hd__decap_3
XFILLER_10_281 VGND VGND VPWR VPWR sky130_fd_sc_hd__decap_3
XFILLER_69_215 VGND VGND VPWR VPWR sky130_fd_sc_hd__decap_3
Xload_slew601 fanout600/X VGND VGND VPWR VPWR _6673_/A2 sky130_fd_sc_hd__buf_4
XFILLER_69_237 VGND VGND VPWR VPWR sky130_fd_sc_hd__decap_3
X_5050_ _5361_/A _5322_/B _5049_/B _5046_/X VGND VGND VPWR VPWR _5052_/B sky130_fd_sc_hd__a31o_2
XFILLER_27_3 VGND VGND VPWR VPWR sky130_fd_sc_hd__decap_3
X_4001_ _6005_/S _4000_/C _4000_/A VGND VGND VPWR VPWR _4002_/B sky130_fd_sc_hd__a21oi_2
XTAP_TAPCELL_ROW_68_928 VGND VPWR sky130_fd_sc_hd__tapvpwrvgnd_1
XFILLER_77_281 VGND VGND VPWR VPWR sky130_fd_sc_hd__decap_3
XFILLER_84_229 VGND VGND VPWR VPWR sky130_fd_sc_hd__decap_3
XFILLER_65_476 VGND VGND VPWR VPWR sky130_fd_sc_hd__decap_3
XFILLER_92_262 VGND VGND VPWR VPWR sky130_fd_sc_hd__decap_3
XFILLER_92_284 VGND VGND VPWR VPWR sky130_fd_sc_hd__decap_3
X_5952_ _5952_/A _5952_/B VGND VGND VPWR VPWR _5969_/A sky130_fd_sc_hd__xnor2_2
XFILLER_18_392 VGND VGND VPWR VPWR sky130_fd_sc_hd__decap_3
X_4903_ _4903_/A _4903_/B _4903_/C VGND VGND VPWR VPWR _4904_/A sky130_fd_sc_hd__and3_2
XFILLER_33_340 VGND VGND VPWR VPWR sky130_fd_sc_hd__decap_3
X_5883_ _4558_/B _4558_/C _4558_/A _4558_/D VGND VGND VPWR VPWR _5883_/Y sky130_fd_sc_hd__o22ai_2
XFILLER_60_170 VGND VGND VPWR VPWR sky130_fd_sc_hd__decap_3
X_4834_ _4834_/A _4834_/B _4834_/C _4834_/D VGND VGND VPWR VPWR _4834_/Y sky130_fd_sc_hd__nor4_4
X_4765_ _6105_/A _6110_/B _4706_/X _6213_/A _6108_/A VGND VGND VPWR VPWR _4771_/A
+ sky130_fd_sc_hd__a32o_2
XTAP_TAPCELL_ROW_31_541 VGND VPWR sky130_fd_sc_hd__tapvpwrvgnd_1
X_6504_ _6501_/X _6503_/X _6589_/A VGND VGND VPWR VPWR _6504_/X sky130_fd_sc_hd__mux2_1
Xrebuffer828 _6994_/A VGND VGND VPWR VPWR output92/A sky130_fd_sc_hd__buf_6
X_3716_ _6079_/B _4526_/B _3688_/C _3688_/D VGND VGND VPWR VPWR _3717_/C sky130_fd_sc_hd__a22o_2
X_4696_ _4694_/A _4694_/C _4944_/D _5306_/A VGND VGND VPWR VPWR _4697_/C sky130_fd_sc_hd__a22oi_2
X_6435_ _5477_/A _5701_/A _6435_/S VGND VGND VPWR VPWR _6435_/X sky130_fd_sc_hd__mux2_1
X_3647_ _3647_/A _4362_/B _3648_/A _3647_/D VGND VGND VPWR VPWR _4122_/A sky130_fd_sc_hd__nand4_2
X_6366_ _6764_/A _6498_/B VGND VGND VPWR VPWR _6829_/A sky130_fd_sc_hd__nand2_2
X_3578_ _3578_/A _3639_/A _3977_/B _5983_/C VGND VGND VPWR VPWR _3578_/X sky130_fd_sc_hd__and4_2
X_5317_ _5317_/A _5338_/A _5317_/C VGND VGND VPWR VPWR _5338_/B sky130_fd_sc_hd__nand3_2
XFILLER_88_557 VGND VGND VPWR VPWR sky130_fd_sc_hd__fill_2
X_6297_ _6211_/A _6358_/A2 _5431_/A VGND VGND VPWR VPWR _6297_/Y sky130_fd_sc_hd__o21ai_2
XFILLER_75_218 VGND VGND VPWR VPWR sky130_fd_sc_hd__fill_1
XFILLER_88_579 VGND VGND VPWR VPWR sky130_fd_sc_hd__decap_3
X_5248_ _5248_/A _5248_/B _5248_/C VGND VGND VPWR VPWR _5831_/A sky130_fd_sc_hd__and3_4
XFILLER_68_270 VGND VGND VPWR VPWR sky130_fd_sc_hd__decap_3
X_5179_ _5093_/Y _5175_/X _5174_/Y _5179_/C1 VGND VGND VPWR VPWR _5180_/C sky130_fd_sc_hd__a211o_2
XTAP_TAPCELL_ROW_3_244 VGND VPWR sky130_fd_sc_hd__tapvpwrvgnd_1
XFILLER_83_240 VGND VGND VPWR VPWR sky130_fd_sc_hd__decap_3
XTAP_TAPCELL_ROW_39_630 VGND VPWR sky130_fd_sc_hd__tapvpwrvgnd_1
XFILLER_16_329 VGND VGND VPWR VPWR sky130_fd_sc_hd__decap_3
XFILLER_28_167 VGND VGND VPWR VPWR sky130_fd_sc_hd__decap_3
XFILLER_45_35 VGND VGND VPWR VPWR sky130_fd_sc_hd__decap_3
XFILLER_71_424 VGND VGND VPWR VPWR sky130_fd_sc_hd__decap_3
XFILLER_83_273 VGND VGND VPWR VPWR sky130_fd_sc_hd__decap_3
XFILLER_83_284 VGND VGND VPWR VPWR sky130_fd_sc_hd__decap_3
XFILLER_45_57 VGND VGND VPWR VPWR sky130_fd_sc_hd__fill_1
XFILLER_45_79 VGND VGND VPWR VPWR sky130_fd_sc_hd__decap_3
XFILLER_24_362 VGND VGND VPWR VPWR sky130_fd_sc_hd__fill_2
XFILLER_61_67 VGND VGND VPWR VPWR sky130_fd_sc_hd__fill_1
XFILLER_61_78 VGND VGND VPWR VPWR sky130_fd_sc_hd__decap_3
XFILLER_6_29 VGND VGND VPWR VPWR sky130_fd_sc_hd__decap_3
XFILLER_3_222 VGND VGND VPWR VPWR sky130_fd_sc_hd__fill_2
XFILLER_3_277 VGND VGND VPWR VPWR sky130_fd_sc_hd__decap_3
XFILLER_79_524 VGND VGND VPWR VPWR sky130_fd_sc_hd__decap_3
XFILLER_94_505 VGND VGND VPWR VPWR sky130_fd_sc_hd__fill_1
XFILLER_59_281 VGND VGND VPWR VPWR sky130_fd_sc_hd__fill_1
XFILLER_86_97 VGND VGND VPWR VPWR sky130_fd_sc_hd__decap_3
XFILLER_74_240 VGND VGND VPWR VPWR sky130_fd_sc_hd__decap_3
XFILLER_19_167 VGND VGND VPWR VPWR sky130_fd_sc_hd__fill_1
XFILLER_47_498 VGND VGND VPWR VPWR sky130_fd_sc_hd__decap_3
XFILLER_62_424 VGND VGND VPWR VPWR sky130_fd_sc_hd__decap_3
XFILLER_74_284 VGND VGND VPWR VPWR sky130_fd_sc_hd__decap_3
XTAP_TAPCELL_ROW_73_986 VGND VPWR sky130_fd_sc_hd__tapvpwrvgnd_1
XTAP_TAPCELL_ROW_45_688 VGND VPWR sky130_fd_sc_hd__tapvpwrvgnd_1
XFILLER_15_373 VGND VGND VPWR VPWR sky130_fd_sc_hd__decap_3
XFILLER_30_321 VGND VGND VPWR VPWR sky130_fd_sc_hd__decap_3
XFILLER_30_365 VGND VGND VPWR VPWR sky130_fd_sc_hd__decap_3
XFILLER_30_387 VGND VGND VPWR VPWR sky130_fd_sc_hd__fill_2
X_4550_ _4550_/A _4550_/B VGND VGND VPWR VPWR _4552_/B sky130_fd_sc_hd__nor2_2
XFILLER_7_561 VGND VGND VPWR VPWR sky130_fd_sc_hd__decap_3
X_4481_ _4481_/A _4481_/B _4481_/C VGND VGND VPWR VPWR _4489_/A sky130_fd_sc_hd__nand3_2
X_3501_ _4539_/B VGND VGND VPWR VPWR _3501_/Y sky130_fd_sc_hd__inv_2
XTAP_TAPCELL_ROW_77_1023 VGND VPWR sky130_fd_sc_hd__tapvpwrvgnd_1
X_6220_ _6373_/A _6220_/B VGND VGND VPWR VPWR _6441_/B sky130_fd_sc_hd__nand2b_2
X_6151_ _6152_/A _6211_/B VGND VGND VPWR VPWR _6151_/Y sky130_fd_sc_hd__nor2_2
Xload_slew420 _4607_/C VGND VGND VPWR VPWR _4387_/C sky130_fd_sc_hd__buf_4
X_5102_ _5102_/A _5102_/B VGND VGND VPWR VPWR _5113_/A sky130_fd_sc_hd__xnor2_2
XPHY_EDGE_ROW_29_Left_130 VGND VGND VPWR VPWR sky130_fd_sc_hd__decap_3
XFILLER_97_332 VGND VGND VPWR VPWR sky130_fd_sc_hd__decap_3
X_6082_ _6083_/A _6083_/B VGND VGND VPWR VPWR _6082_/Y sky130_fd_sc_hd__nor2_2
XFILLER_38_421 VGND VGND VPWR VPWR sky130_fd_sc_hd__fill_2
X_5033_ _5383_/A _5115_/B VGND VGND VPWR VPWR _5035_/B sky130_fd_sc_hd__nand2_2
XFILLER_97_387 VGND VGND VPWR VPWR sky130_fd_sc_hd__decap_3
XTAP_TAPCELL_ROW_88_1141 VGND VPWR sky130_fd_sc_hd__tapvpwrvgnd_1
XTAP_TAPCELL_ROW_0_203 VGND VPWR sky130_fd_sc_hd__tapvpwrvgnd_1
XFILLER_53_424 VGND VGND VPWR VPWR sky130_fd_sc_hd__decap_3
XFILLER_65_251 VGND VGND VPWR VPWR sky130_fd_sc_hd__decap_3
XTAP_TAPCELL_ROW_36_600 VGND VPWR sky130_fd_sc_hd__tapvpwrvgnd_1
XTAP_TAPCELL_ROW_0_214 VGND VPWR sky130_fd_sc_hd__tapvpwrvgnd_1
XFILLER_93_593 VGND VGND VPWR VPWR sky130_fd_sc_hd__decap_3
XFILLER_25_137 VGND VGND VPWR VPWR sky130_fd_sc_hd__decap_3
XFILLER_80_221 VGND VGND VPWR VPWR sky130_fd_sc_hd__decap_3
X_6984_ _6984_/A _6984_/B _6984_/C VGND VGND VPWR VPWR _6991_/B sky130_fd_sc_hd__or3_2
X_5935_ _5917_/X _5930_/X _5934_/X _5930_/B VGND VGND VPWR VPWR _6935_/B sky130_fd_sc_hd__a22o_4
XFILLER_21_310 VGND VGND VPWR VPWR sky130_fd_sc_hd__decap_3
XFILLER_33_181 VGND VGND VPWR VPWR sky130_fd_sc_hd__decap_3
X_5866_ _5862_/A _5862_/C _5862_/B VGND VGND VPWR VPWR _5866_/X sky130_fd_sc_hd__a21o_4
X_4817_ _4816_/B _4816_/C _4816_/A VGND VGND VPWR VPWR _4817_/Y sky130_fd_sc_hd__a21oi_2
XTAP_TAPCELL_ROW_16_390 VGND VPWR sky130_fd_sc_hd__tapvpwrvgnd_1
X_5797_ _5797_/A _5797_/B VGND VGND VPWR VPWR _6484_/A sky130_fd_sc_hd__or2_2
X_4748_ _4748_/A _4748_/B _5321_/C _5321_/D VGND VGND VPWR VPWR _4748_/X sky130_fd_sc_hd__and4_2
X_4679_ _4678_/A _4677_/Y _4643_/X _4644_/Y VGND VGND VPWR VPWR _4870_/A sky130_fd_sc_hd__o211a_4
X_6418_ _5956_/B _3867_/B _3882_/A VGND VGND VPWR VPWR _6419_/B sky130_fd_sc_hd__o21ai_2
XTAP_TAPCELL_ROW_8_303 VGND VPWR sky130_fd_sc_hd__tapvpwrvgnd_1
XPHY_EDGE_ROW_1_Right_1 VGND VGND VPWR VPWR sky130_fd_sc_hd__decap_3
XFILLER_0_203 VGND VGND VPWR VPWR sky130_fd_sc_hd__decap_3
XFILLER_0_225 VGND VGND VPWR VPWR sky130_fd_sc_hd__decap_3
XFILLER_88_321 VGND VGND VPWR VPWR sky130_fd_sc_hd__decap_3
X_6349_ _6730_/A _6350_/B VGND VGND VPWR VPWR _6349_/Y sky130_fd_sc_hd__nor2_2
XFILLER_0_269 VGND VGND VPWR VPWR sky130_fd_sc_hd__decap_3
XFILLER_88_365 VGND VGND VPWR VPWR sky130_fd_sc_hd__decap_3
XFILLER_56_251 VGND VGND VPWR VPWR sky130_fd_sc_hd__fill_1
XFILLER_56_262 VGND VGND VPWR VPWR sky130_fd_sc_hd__decap_3
XFILLER_16_115 VGND VGND VPWR VPWR sky130_fd_sc_hd__decap_3
XFILLER_71_210 VGND VGND VPWR VPWR sky130_fd_sc_hd__decap_3
XFILLER_71_243 VGND VGND VPWR VPWR sky130_fd_sc_hd__decap_3
XFILLER_71_276 VGND VGND VPWR VPWR sky130_fd_sc_hd__decap_3
XFILLER_71_287 VGND VGND VPWR VPWR sky130_fd_sc_hd__decap_3
XFILLER_72_55 VGND VGND VPWR VPWR sky130_fd_sc_hd__decap_3
XFILLER_12_332 VGND VGND VPWR VPWR sky130_fd_sc_hd__fill_2
XTAP_TAPCELL_ROW_70_956 VGND VPWR sky130_fd_sc_hd__tapvpwrvgnd_1
XTAP_TAPCELL_ROW_42_658 VGND VPWR sky130_fd_sc_hd__tapvpwrvgnd_1
XFILLER_8_358 VGND VGND VPWR VPWR sky130_fd_sc_hd__decap_3
XFILLER_4_531 VGND VGND VPWR VPWR sky130_fd_sc_hd__fill_1
XFILLER_4_564 VGND VGND VPWR VPWR sky130_fd_sc_hd__decap_3
XFILLER_79_332 VGND VGND VPWR VPWR sky130_fd_sc_hd__decap_3
XFILLER_79_343 VGND VGND VPWR VPWR sky130_fd_sc_hd__decap_3
XFILLER_39_207 VGND VGND VPWR VPWR sky130_fd_sc_hd__decap_3
XFILLER_67_505 VGND VGND VPWR VPWR sky130_fd_sc_hd__decap_3
XFILLER_67_538 VGND VGND VPWR VPWR sky130_fd_sc_hd__decap_3
XFILLER_67_549 VGND VGND VPWR VPWR sky130_fd_sc_hd__decap_3
XFILLER_94_324 VGND VGND VPWR VPWR sky130_fd_sc_hd__decap_3
XFILLER_11_6 VGND VGND VPWR VPWR sky130_fd_sc_hd__decap_3
XFILLER_47_240 VGND VGND VPWR VPWR sky130_fd_sc_hd__decap_3
XFILLER_94_368 VGND VGND VPWR VPWR sky130_fd_sc_hd__decap_3
XFILLER_47_273 VGND VGND VPWR VPWR sky130_fd_sc_hd__fill_1
XFILLER_82_519 VGND VGND VPWR VPWR sky130_fd_sc_hd__decap_3
XFILLER_35_435 VGND VGND VPWR VPWR sky130_fd_sc_hd__decap_3
XFILLER_47_284 VGND VGND VPWR VPWR sky130_fd_sc_hd__decap_3
XFILLER_75_593 VGND VGND VPWR VPWR sky130_fd_sc_hd__decap_3
XFILLER_35_479 VGND VGND VPWR VPWR sky130_fd_sc_hd__decap_3
XFILLER_62_265 VGND VGND VPWR VPWR sky130_fd_sc_hd__decap_3
X_3981_ _3982_/A _3982_/B VGND VGND VPWR VPWR _3983_/A sky130_fd_sc_hd__and2_2
XFILLER_22_118 VGND VGND VPWR VPWR sky130_fd_sc_hd__decap_3
XFILLER_50_427 VGND VGND VPWR VPWR sky130_fd_sc_hd__decap_3
XFILLER_62_276 VGND VGND VPWR VPWR sky130_fd_sc_hd__fill_1
XFILLER_62_287 VGND VGND VPWR VPWR sky130_fd_sc_hd__decap_3
X_5720_ _5720_/A _5720_/B VGND VGND VPWR VPWR _5720_/Y sky130_fd_sc_hd__xnor2_2
XTAP_TAPCELL_ROW_83_1093 VGND VPWR sky130_fd_sc_hd__tapvpwrvgnd_1
XFILLER_94_3 VGND VGND VPWR VPWR sky130_fd_sc_hd__fill_1
XFILLER_30_151 VGND VGND VPWR VPWR sky130_fd_sc_hd__fill_1
X_5651_ _5652_/A _5817_/B _5652_/B VGND VGND VPWR VPWR _5651_/X sky130_fd_sc_hd__a21bo_2
X_5582_ _6109_/A _5582_/B VGND VGND VPWR VPWR _5598_/A sky130_fd_sc_hd__nand2_2
X_4602_ _4603_/A _4603_/B VGND VGND VPWR VPWR _4848_/A sky130_fd_sc_hd__nor2_2
X_4533_ _4414_/X _4503_/Y _4516_/X _4531_/Y VGND VGND VPWR VPWR _4554_/B sky130_fd_sc_hd__a211o_2
X_6203_ _6336_/A _6353_/C _6332_/A _6332_/B VGND VGND VPWR VPWR _6203_/X sky130_fd_sc_hd__or4_2
X_4464_ _4464_/A _4464_/B _4464_/C VGND VGND VPWR VPWR _4465_/C sky130_fd_sc_hd__and3_2
X_4395_ _4386_/A _4386_/B _4394_/B _4493_/A _4493_/B VGND VGND VPWR VPWR _4397_/B
+ sky130_fd_sc_hd__a32o_2
X_6134_ _6131_/Y _6133_/Y _6133_/A VGND VGND VPWR VPWR _6134_/X sky130_fd_sc_hd__o21a_2
XFILLER_85_302 VGND VGND VPWR VPWR sky130_fd_sc_hd__decap_3
XFILLER_85_335 VGND VGND VPWR VPWR sky130_fd_sc_hd__fill_1
X_6065_ _6337_/A _6350_/B VGND VGND VPWR VPWR _6999_/A sky130_fd_sc_hd__nand2_2
XFILLER_85_346 VGND VGND VPWR VPWR sky130_fd_sc_hd__decap_3
X_5016_ _5016_/A _5016_/B VGND VGND VPWR VPWR _5027_/A sky130_fd_sc_hd__nand2_2
XFILLER_26_15 VGND VGND VPWR VPWR sky130_fd_sc_hd__fill_2
XFILLER_38_240 VGND VGND VPWR VPWR sky130_fd_sc_hd__decap_3
XFILLER_26_26 VGND VGND VPWR VPWR sky130_fd_sc_hd__fill_2
XFILLER_26_424 VGND VGND VPWR VPWR sky130_fd_sc_hd__fill_2
XFILLER_26_446 VGND VGND VPWR VPWR sky130_fd_sc_hd__fill_1
XFILLER_81_541 VGND VGND VPWR VPWR sky130_fd_sc_hd__decap_3
XFILLER_93_390 VGND VGND VPWR VPWR sky130_fd_sc_hd__fill_2
XFILLER_26_59 VGND VGND VPWR VPWR sky130_fd_sc_hd__decap_3
X_6967_ _6291_/A _6957_/Y _6966_/Y _6955_/Y VGND VGND VPWR VPWR _6967_/X sky130_fd_sc_hd__a211o_2
XFILLER_41_416 VGND VGND VPWR VPWR sky130_fd_sc_hd__decap_3
XFILLER_41_449 VGND VGND VPWR VPWR sky130_fd_sc_hd__decap_3
XFILLER_53_276 VGND VGND VPWR VPWR sky130_fd_sc_hd__decap_3
XFILLER_81_585 VGND VGND VPWR VPWR sky130_fd_sc_hd__decap_3
X_5918_ _5911_/B _5914_/Y _5916_/A VGND VGND VPWR VPWR _5930_/A sky130_fd_sc_hd__a21oi_2
X_6898_ _6898_/A _6898_/B _6892_/X VGND VGND VPWR VPWR _6898_/X sky130_fd_sc_hd__or3b_2
X_5849_ _5831_/Y _5832_/X _5849_/B1 _5830_/C VGND VGND VPWR VPWR _5849_/Y sky130_fd_sc_hd__o211ai_2
XFILLER_1_567 VGND VGND VPWR VPWR sky130_fd_sc_hd__decap_3
XFILLER_49_505 VGND VGND VPWR VPWR sky130_fd_sc_hd__fill_2
XFILLER_67_44 VGND VGND VPWR VPWR sky130_fd_sc_hd__decap_3
XFILLER_76_324 VGND VGND VPWR VPWR sky130_fd_sc_hd__decap_3
XFILLER_88_162 VGND VGND VPWR VPWR sky130_fd_sc_hd__decap_3
XFILLER_76_357 VGND VGND VPWR VPWR sky130_fd_sc_hd__decap_3
XFILLER_76_368 VGND VGND VPWR VPWR sky130_fd_sc_hd__decap_3
XFILLER_88_195 VGND VGND VPWR VPWR sky130_fd_sc_hd__fill_1
XFILLER_17_402 VGND VGND VPWR VPWR sky130_fd_sc_hd__decap_3
XFILLER_29_273 VGND VGND VPWR VPWR sky130_fd_sc_hd__decap_3
XFILLER_64_519 VGND VGND VPWR VPWR sky130_fd_sc_hd__decap_3
XFILLER_91_327 VGND VGND VPWR VPWR sky130_fd_sc_hd__decap_3
XTAP_TAPCELL_ROW_47_706 VGND VPWR sky130_fd_sc_hd__tapvpwrvgnd_1
XTAP_TAPCELL_ROW_19_419 VGND VPWR sky130_fd_sc_hd__tapvpwrvgnd_1
XFILLER_17_446 VGND VGND VPWR VPWR sky130_fd_sc_hd__fill_2
XFILLER_91_349 VGND VGND VPWR VPWR sky130_fd_sc_hd__decap_3
XFILLER_17_479 VGND VGND VPWR VPWR sky130_fd_sc_hd__decap_3
XFILLER_16_70 VGND VGND VPWR VPWR sky130_fd_sc_hd__decap_3
XTAP_TAPCELL_ROW_55_794 VGND VPWR sky130_fd_sc_hd__tapvpwrvgnd_1
XTAP_TAPCELL_ROW_27_496 VGND VPWR sky130_fd_sc_hd__tapvpwrvgnd_1
XFILLER_66_7 VGND VGND VPWR VPWR sky130_fd_sc_hd__decap_3
XFILLER_8_166 VGND VGND VPWR VPWR sky130_fd_sc_hd__decap_3
XFILLER_4_350 VGND VGND VPWR VPWR sky130_fd_sc_hd__fill_2
XFILLER_59_6 VGND VGND VPWR VPWR sky130_fd_sc_hd__fill_1
XFILLER_99_405 VGND VGND VPWR VPWR sky130_fd_sc_hd__decap_3
XFILLER_99_449 VGND VGND VPWR VPWR sky130_fd_sc_hd__decap_3
X_4180_ _4180_/A _4180_/B VGND VGND VPWR VPWR _4186_/A sky130_fd_sc_hd__nor2_2
XFILLER_67_302 VGND VGND VPWR VPWR sky130_fd_sc_hd__decap_3
XFILLER_55_508 VGND VGND VPWR VPWR sky130_fd_sc_hd__decap_3
XFILLER_67_335 VGND VGND VPWR VPWR sky130_fd_sc_hd__fill_1
XFILLER_82_305 VGND VGND VPWR VPWR sky130_fd_sc_hd__decap_3
XTAP_TAPCELL_ROW_85_1111 VGND VPWR sky130_fd_sc_hd__tapvpwrvgnd_1
X_6821_ _5184_/A _5184_/B _5262_/B _6806_/A _6806_/B VGND VGND VPWR VPWR _6822_/B
+ sky130_fd_sc_hd__a32o_2
XFILLER_35_287 VGND VGND VPWR VPWR sky130_fd_sc_hd__decap_3
XFILLER_63_596 VGND VGND VPWR VPWR sky130_fd_sc_hd__fill_2
XFILLER_90_371 VGND VGND VPWR VPWR sky130_fd_sc_hd__decap_3
X_6752_ _6758_/B _6742_/Y _6747_/X _6751_/X VGND VGND VPWR VPWR _6752_/X sky130_fd_sc_hd__a211o_2
X_3964_ _3964_/A _3964_/B VGND VGND VPWR VPWR _3966_/B sky130_fd_sc_hd__xnor2_2
XFILLER_50_268 VGND VGND VPWR VPWR sky130_fd_sc_hd__decap_3
X_6683_ _6672_/B _6339_/Y _6682_/X VGND VGND VPWR VPWR _6683_/X sky130_fd_sc_hd__a21bo_2
X_5703_ _5703_/A _5703_/B _5703_/C VGND VGND VPWR VPWR _5732_/A sky130_fd_sc_hd__or3_2
X_3895_ _3895_/A _3895_/B VGND VGND VPWR VPWR _3897_/B sky130_fd_sc_hd__xnor2_2
XFILLER_31_482 VGND VGND VPWR VPWR sky130_fd_sc_hd__decap_3
X_5634_ _5634_/A _5634_/B _5634_/C VGND VGND VPWR VPWR _5716_/A sky130_fd_sc_hd__nand3_2
X_5565_ _5513_/X _5563_/Y _5562_/Y _5562_/B VGND VGND VPWR VPWR _5565_/X sky130_fd_sc_hd__o211a_2
XFILLER_2_309 VGND VGND VPWR VPWR sky130_fd_sc_hd__decap_3
X_5496_ _5498_/A _5498_/B VGND VGND VPWR VPWR _5496_/X sky130_fd_sc_hd__and2b_2
X_4516_ _4516_/A _4516_/B _4516_/C VGND VGND VPWR VPWR _4516_/X sky130_fd_sc_hd__and3_2
X_4447_ _4176_/A _4900_/B _4190_/B _4188_/X VGND VGND VPWR VPWR _4451_/A sky130_fd_sc_hd__a31o_2
Xfanout602 _5981_/D VGND VGND VPWR VPWR _4662_/A sky130_fd_sc_hd__dlymetal6s4s_1
Xfanout613 _6879_/B2 VGND VGND VPWR VPWR _6182_/B sky130_fd_sc_hd__clkdlybuf4s25_1
Xfanout635 _6014_/B VGND VGND VPWR VPWR _3614_/A sky130_fd_sc_hd__clkdlybuf4s25_1
Xfanout646 input12/X VGND VGND VPWR VPWR _4003_/B sky130_fd_sc_hd__clkdlybuf4s25_1
Xfanout657 wire659/A VGND VGND VPWR VPWR _6019_/B sky130_fd_sc_hd__clkdlybuf4s25_1
X_6117_ _6117_/A _6117_/B VGND VGND VPWR VPWR _6381_/B sky130_fd_sc_hd__nand2_2
X_4378_ _4378_/A _4378_/B _4378_/C _4378_/D VGND VGND VPWR VPWR _4378_/Y sky130_fd_sc_hd__nor4_4
XFILLER_46_508 VGND VGND VPWR VPWR sky130_fd_sc_hd__decap_3
XFILLER_85_154 VGND VGND VPWR VPWR sky130_fd_sc_hd__decap_3
X_6048_ _6048_/A _6048_/B VGND VGND VPWR VPWR _6049_/B sky130_fd_sc_hd__xnor2_2
XFILLER_100_498 VGND VGND VPWR VPWR sky130_fd_sc_hd__decap_3
XFILLER_37_69 VGND VGND VPWR VPWR sky130_fd_sc_hd__decap_3
XFILLER_73_327 VGND VGND VPWR VPWR sky130_fd_sc_hd__fill_1
XFILLER_14_405 VGND VGND VPWR VPWR sky130_fd_sc_hd__decap_3
XFILLER_26_232 VGND VGND VPWR VPWR sky130_fd_sc_hd__decap_3
XFILLER_26_243 VGND VGND VPWR VPWR sky130_fd_sc_hd__fill_1
XFILLER_26_276 VGND VGND VPWR VPWR sky130_fd_sc_hd__decap_3
XFILLER_53_13 VGND VGND VPWR VPWR sky130_fd_sc_hd__fill_2
XFILLER_81_371 VGND VGND VPWR VPWR sky130_fd_sc_hd__decap_3
XFILLER_41_257 VGND VGND VPWR VPWR sky130_fd_sc_hd__decap_3
XFILLER_53_57 VGND VGND VPWR VPWR sky130_fd_sc_hd__decap_3
XTAP_TAPCELL_ROW_52_764 VGND VPWR sky130_fd_sc_hd__tapvpwrvgnd_1
XTAP_TAPCELL_ROW_24_466 VGND VPWR sky130_fd_sc_hd__tapvpwrvgnd_1
XFILLER_5_136 VGND VGND VPWR VPWR sky130_fd_sc_hd__decap_3
XFILLER_5_169 VGND VGND VPWR VPWR sky130_fd_sc_hd__decap_3
XFILLER_78_76 VGND VGND VPWR VPWR sky130_fd_sc_hd__fill_1
XFILLER_49_302 VGND VGND VPWR VPWR sky130_fd_sc_hd__decap_3
XFILLER_89_471 VGND VGND VPWR VPWR sky130_fd_sc_hd__decap_3
XFILLER_49_335 VGND VGND VPWR VPWR sky130_fd_sc_hd__fill_1
XFILLER_49_346 VGND VGND VPWR VPWR sky130_fd_sc_hd__fill_1
XFILLER_76_121 VGND VGND VPWR VPWR sky130_fd_sc_hd__decap_3
XFILLER_37_508 VGND VGND VPWR VPWR sky130_fd_sc_hd__fill_2
XFILLER_49_379 VGND VGND VPWR VPWR sky130_fd_sc_hd__decap_3
XFILLER_64_305 VGND VGND VPWR VPWR sky130_fd_sc_hd__decap_3
XFILLER_76_165 VGND VGND VPWR VPWR sky130_fd_sc_hd__decap_3
XFILLER_64_327 VGND VGND VPWR VPWR sky130_fd_sc_hd__decap_3
XFILLER_60_511 VGND VGND VPWR VPWR sky130_fd_sc_hd__decap_3
XFILLER_32_246 VGND VGND VPWR VPWR sky130_fd_sc_hd__fill_1
XFILLER_60_533 VGND VGND VPWR VPWR sky130_fd_sc_hd__decap_3
XFILLER_72_393 VGND VGND VPWR VPWR sky130_fd_sc_hd__fill_2
XTAP_TAPCELL_ROW_80_1052 VGND VPWR sky130_fd_sc_hd__tapvpwrvgnd_1
X_3680_ _3680_/A _6079_/B _3851_/B _5948_/A VGND VGND VPWR VPWR _3682_/A sky130_fd_sc_hd__and4_2
XFILLER_57_3 VGND VGND VPWR VPWR sky130_fd_sc_hd__decap_3
X_5350_ _5349_/A _5349_/C _5349_/B VGND VGND VPWR VPWR _5351_/C sky130_fd_sc_hd__a21o_2
X_5281_ _5283_/A _5283_/B VGND VGND VPWR VPWR _5287_/B sky130_fd_sc_hd__and2b_2
X_4301_ _4299_/A _4299_/B _4299_/C VGND VGND VPWR VPWR _4302_/C sky130_fd_sc_hd__o21ai_2
XFILLER_87_408 VGND VGND VPWR VPWR sky130_fd_sc_hd__decap_3
X_4232_ _4617_/A _4476_/B VGND VGND VPWR VPWR _4340_/A sky130_fd_sc_hd__nand2_2
XFILLER_99_268 VGND VGND VPWR VPWR sky130_fd_sc_hd__decap_3
XTAP_TAPCELL_ROW_91_1170 VGND VPWR sky130_fd_sc_hd__tapvpwrvgnd_1
XFILLER_67_121 VGND VGND VPWR VPWR sky130_fd_sc_hd__decap_3
X_4163_ _4163_/A _4163_/B _4163_/C VGND VGND VPWR VPWR _4170_/A sky130_fd_sc_hd__nand3_2
XFILLER_95_441 VGND VGND VPWR VPWR sky130_fd_sc_hd__decap_3
X_4094_ _4094_/A _4222_/A _4094_/C VGND VGND VPWR VPWR _4106_/B sky130_fd_sc_hd__nand3_2
XFILLER_95_452 VGND VGND VPWR VPWR sky130_fd_sc_hd__decap_3
XFILLER_55_349 VGND VGND VPWR VPWR sky130_fd_sc_hd__decap_3
XFILLER_67_187 VGND VGND VPWR VPWR sky130_fd_sc_hd__decap_3
XFILLER_51_511 VGND VGND VPWR VPWR sky130_fd_sc_hd__decap_3
XFILLER_63_382 VGND VGND VPWR VPWR sky130_fd_sc_hd__decap_3
XFILLER_82_179 VGND VGND VPWR VPWR sky130_fd_sc_hd__decap_3
XFILLER_23_246 VGND VGND VPWR VPWR sky130_fd_sc_hd__decap_3
XFILLER_63_393 VGND VGND VPWR VPWR sky130_fd_sc_hd__decap_3
X_6804_ _6791_/Y _6792_/X _6794_/Y _6757_/C VGND VGND VPWR VPWR _6804_/X sky130_fd_sc_hd__a2bb2o_2
X_4996_ _4991_/A _5084_/A _4994_/A _4995_/Y VGND VGND VPWR VPWR _4998_/C sky130_fd_sc_hd__a211o_2
XFILLER_23_279 VGND VGND VPWR VPWR sky130_fd_sc_hd__fill_1
X_6735_ _6735_/A _6735_/B VGND VGND VPWR VPWR _6735_/Y sky130_fd_sc_hd__nand2_2
X_3947_ _6039_/A _3947_/B _3947_/C VGND VGND VPWR VPWR _6039_/B sky130_fd_sc_hd__nor3_2
XTAP_TAPCELL_ROW_21_436 VGND VPWR sky130_fd_sc_hd__tapvpwrvgnd_1
X_6666_ _6819_/A2 _6654_/X _6655_/Y _6665_/Y VGND VGND VPWR VPWR _6666_/X sky130_fd_sc_hd__a31o_2
X_3878_ _3878_/A _3878_/B VGND VGND VPWR VPWR _3880_/C sky130_fd_sc_hd__xnor2_2
X_6597_ _6597_/A _6597_/B VGND VGND VPWR VPWR _6597_/X sky130_fd_sc_hd__or2_2
X_5617_ _5611_/A _5612_/X _5500_/X _5502_/X VGND VGND VPWR VPWR _5617_/X sky130_fd_sc_hd__a211o_2
X_5548_ _5548_/A _5548_/B VGND VGND VPWR VPWR _5579_/C sky130_fd_sc_hd__xnor2_2
X_5479_ _5476_/X _5479_/B VGND VGND VPWR VPWR _5548_/B sky130_fd_sc_hd__and2b_2
Xfanout421 _6019_/A VGND VGND VPWR VPWR _3665_/A2 sky130_fd_sc_hd__clkdlybuf4s25_1
XFILLER_86_430 VGND VGND VPWR VPWR sky130_fd_sc_hd__decap_3
Xfanout443 _6016_/A VGND VGND VPWR VPWR _3941_/B sky130_fd_sc_hd__clkbuf_2
Xfanout454 _6492_/S0 VGND VGND VPWR VPWR _6958_/S0 sky130_fd_sc_hd__clkdlybuf4s25_1
XFILLER_100_251 VGND VGND VPWR VPWR sky130_fd_sc_hd__fill_1
XFILLER_100_262 VGND VGND VPWR VPWR sky130_fd_sc_hd__decap_3
XFILLER_19_519 VGND VGND VPWR VPWR sky130_fd_sc_hd__decap_3
XFILLER_86_452 VGND VGND VPWR VPWR sky130_fd_sc_hd__decap_3
Xfanout487 fanout489/X VGND VGND VPWR VPWR _6110_/A sky130_fd_sc_hd__clkdlybuf4s25_1
XTAP_TAPCELL_ROW_57_812 VGND VPWR sky130_fd_sc_hd__tapvpwrvgnd_1
XFILLER_100_284 VGND VGND VPWR VPWR sky130_fd_sc_hd__decap_3
XFILLER_73_113 VGND VGND VPWR VPWR sky130_fd_sc_hd__decap_3
XTAP_TAPCELL_ROW_29_525 VGND VPWR sky130_fd_sc_hd__tapvpwrvgnd_1
XFILLER_27_530 VGND VGND VPWR VPWR sky130_fd_sc_hd__fill_2
XFILLER_64_23 VGND VGND VPWR VPWR sky130_fd_sc_hd__decap_3
XFILLER_42_500 VGND VGND VPWR VPWR sky130_fd_sc_hd__decap_3
XFILLER_61_319 VGND VGND VPWR VPWR sky130_fd_sc_hd__decap_3
XFILLER_81_190 VGND VGND VPWR VPWR sky130_fd_sc_hd__decap_3
XFILLER_14_279 VGND VGND VPWR VPWR sky130_fd_sc_hd__decap_3
XFILLER_9_29 VGND VGND VPWR VPWR sky130_fd_sc_hd__decap_3
XFILLER_80_66 VGND VGND VPWR VPWR sky130_fd_sc_hd__decap_3
XFILLER_13_60 VGND VGND VPWR VPWR sky130_fd_sc_hd__decap_3
XFILLER_6_412 VGND VGND VPWR VPWR sky130_fd_sc_hd__fill_1
XFILLER_6_489 VGND VGND VPWR VPWR sky130_fd_sc_hd__decap_3
XFILLER_96_205 VGND VGND VPWR VPWR sky130_fd_sc_hd__fill_1
XFILLER_89_290 VGND VGND VPWR VPWR sky130_fd_sc_hd__decap_3
XFILLER_96_249 VGND VGND VPWR VPWR sky130_fd_sc_hd__decap_3
XFILLER_77_452 VGND VGND VPWR VPWR sky130_fd_sc_hd__decap_3
XFILLER_92_400 VGND VGND VPWR VPWR sky130_fd_sc_hd__decap_3
XFILLER_92_477 VGND VGND VPWR VPWR sky130_fd_sc_hd__decap_3
XFILLER_45_371 VGND VGND VPWR VPWR sky130_fd_sc_hd__decap_3
XFILLER_64_179 VGND VGND VPWR VPWR sky130_fd_sc_hd__decap_3
XFILLER_33_555 VGND VGND VPWR VPWR sky130_fd_sc_hd__decap_3
XFILLER_45_393 VGND VGND VPWR VPWR sky130_fd_sc_hd__fill_1
XFILLER_60_330 VGND VGND VPWR VPWR sky130_fd_sc_hd__decap_3
X_4850_ _4641_/X _4643_/X _4847_/X _4849_/Y VGND VGND VPWR VPWR _4852_/B sky130_fd_sc_hd__a211o_4
X_3801_ _3900_/A _3972_/A _3977_/B _3909_/D VGND VGND VPWR VPWR _3803_/A sky130_fd_sc_hd__and4_2
X_6520_ _6229_/A _6757_/C _6520_/C VGND VGND VPWR VPWR _6540_/C sky130_fd_sc_hd__and3b_2
X_4781_ _6085_/B _4989_/B VGND VGND VPWR VPWR _4805_/A sky130_fd_sc_hd__nand2_2
X_3732_ _3887_/B _3732_/B VGND VGND VPWR VPWR _3733_/B sky130_fd_sc_hd__nor2_2
X_6451_ _6372_/B _6448_/Y _6450_/Y _6440_/Y _6444_/X VGND VGND VPWR VPWR _6451_/X
+ sky130_fd_sc_hd__a2111o_2
X_3663_ _3663_/A _6102_/B VGND VGND VPWR VPWR _3663_/Y sky130_fd_sc_hd__nand2_2
X_6382_ _6382_/A _6382_/B VGND VGND VPWR VPWR _6385_/B sky130_fd_sc_hd__nand2_2
X_5402_ _5636_/A _5399_/B _5401_/B _5398_/X VGND VGND VPWR VPWR _5404_/B sky130_fd_sc_hd__a31oi_2
X_5333_ _5327_/A _5327_/C _5327_/B VGND VGND VPWR VPWR _5334_/B sky130_fd_sc_hd__a21oi_2
X_3594_ _5983_/B _3814_/C _3814_/D _5983_/D VGND VGND VPWR VPWR _3595_/B sky130_fd_sc_hd__a22oi_2
XPHY_EDGE_ROW_10_Left_111 VGND VGND VPWR VPWR sky130_fd_sc_hd__decap_3
XFILLER_87_216 VGND VGND VPWR VPWR sky130_fd_sc_hd__decap_3
X_5264_ _6806_/A _6822_/A VGND VGND VPWR VPWR _5264_/Y sky130_fd_sc_hd__nand2_2
XFILLER_87_238 VGND VGND VPWR VPWR sky130_fd_sc_hd__fill_1
X_5195_ _5194_/A _5194_/C _5194_/B VGND VGND VPWR VPWR _5196_/B sky130_fd_sc_hd__a21o_2
X_4215_ _4217_/A _4217_/B VGND VGND VPWR VPWR _4220_/B sky130_fd_sc_hd__nand2b_2
X_4146_ _4146_/A _4146_/B VGND VGND VPWR VPWR _4152_/A sky130_fd_sc_hd__nand2_2
XFILLER_18_27 VGND VGND VPWR VPWR sky130_fd_sc_hd__fill_1
XFILLER_18_38 VGND VGND VPWR VPWR sky130_fd_sc_hd__fill_1
XFILLER_95_293 VGND VGND VPWR VPWR sky130_fd_sc_hd__decap_3
XFILLER_83_455 VGND VGND VPWR VPWR sky130_fd_sc_hd__decap_3
X_4077_ _4077_/A _4077_/B _4077_/C VGND VGND VPWR VPWR _4079_/C sky130_fd_sc_hd__nand3_2
XFILLER_24_500 VGND VGND VPWR VPWR sky130_fd_sc_hd__decap_3
XFILLER_43_319 VGND VGND VPWR VPWR sky130_fd_sc_hd__decap_3
XFILLER_83_488 VGND VGND VPWR VPWR sky130_fd_sc_hd__decap_3
XFILLER_24_522 VGND VGND VPWR VPWR sky130_fd_sc_hd__fill_2
XFILLER_24_544 VGND VGND VPWR VPWR sky130_fd_sc_hd__decap_3
XFILLER_36_382 VGND VGND VPWR VPWR sky130_fd_sc_hd__decap_3
XFILLER_70_127 VGND VGND VPWR VPWR sky130_fd_sc_hd__decap_3
XFILLER_11_205 VGND VGND VPWR VPWR sky130_fd_sc_hd__fill_2
XFILLER_51_363 VGND VGND VPWR VPWR sky130_fd_sc_hd__fill_1
XTAP_TAPCELL_ROW_62_870 VGND VPWR sky130_fd_sc_hd__tapvpwrvgnd_1
XFILLER_51_396 VGND VGND VPWR VPWR sky130_fd_sc_hd__decap_3
X_4979_ _4979_/A _6501_/S VGND VGND VPWR VPWR _5072_/A sky130_fd_sc_hd__nand2_2
XTAP_TAPCELL_ROW_34_572 VGND VPWR sky130_fd_sc_hd__tapvpwrvgnd_1
X_6718_ _3597_/A _6797_/A2 _6810_/B1 _6709_/A _6717_/X VGND VGND VPWR VPWR _6718_/X
+ sky130_fd_sc_hd__o221a_2
Xwire118 _4287_/Y VGND VGND VPWR VPWR wire118/X sky130_fd_sc_hd__clkdlybuf4s25_1
XFILLER_50_36 VGND VGND VPWR VPWR sky130_fd_sc_hd__decap_3
X_6649_ _6757_/C _6635_/Y _6648_/X _6634_/X VGND VGND VPWR VPWR _6987_/C sky130_fd_sc_hd__a211o_2
XFILLER_78_227 VGND VGND VPWR VPWR sky130_fd_sc_hd__decap_3
XFILLER_59_452 VGND VGND VPWR VPWR sky130_fd_sc_hd__decap_3
XFILLER_93_219 VGND VGND VPWR VPWR sky130_fd_sc_hd__decap_3
XTAP_TAPCELL_ROW_6_275 VGND VPWR sky130_fd_sc_hd__tapvpwrvgnd_1
XFILLER_46_124 VGND VGND VPWR VPWR sky130_fd_sc_hd__decap_3
XFILLER_86_271 VGND VGND VPWR VPWR sky130_fd_sc_hd__decap_3
Xfanout284 _3869_/D VGND VGND VPWR VPWR _4538_/D sky130_fd_sc_hd__buf_4
XFILLER_74_455 VGND VGND VPWR VPWR sky130_fd_sc_hd__decap_3
XFILLER_34_319 VGND VGND VPWR VPWR sky130_fd_sc_hd__fill_2
XFILLER_46_179 VGND VGND VPWR VPWR sky130_fd_sc_hd__fill_1
XFILLER_74_488 VGND VGND VPWR VPWR sky130_fd_sc_hd__decap_3
XFILLER_27_393 VGND VGND VPWR VPWR sky130_fd_sc_hd__decap_3
XFILLER_54_190 VGND VGND VPWR VPWR sky130_fd_sc_hd__decap_3
XFILLER_61_127 VGND VGND VPWR VPWR sky130_fd_sc_hd__decap_3
XFILLER_42_341 VGND VGND VPWR VPWR sky130_fd_sc_hd__decap_3
XFILLER_91_65 VGND VGND VPWR VPWR sky130_fd_sc_hd__decap_3
XFILLER_30_514 VGND VGND VPWR VPWR sky130_fd_sc_hd__decap_3
XFILLER_30_536 VGND VGND VPWR VPWR sky130_fd_sc_hd__decap_3
XFILLER_42_385 VGND VGND VPWR VPWR sky130_fd_sc_hd__decap_3
XFILLER_6_253 VGND VGND VPWR VPWR sky130_fd_sc_hd__decap_3
XFILLER_6_286 VGND VGND VPWR VPWR sky130_fd_sc_hd__fill_2
XFILLER_69_205 VGND VGND VPWR VPWR sky130_fd_sc_hd__decap_3
XFILLER_97_503 VGND VGND VPWR VPWR sky130_fd_sc_hd__fill_1
XFILLER_69_249 VGND VGND VPWR VPWR sky130_fd_sc_hd__decap_3
Xload_slew624 fanout623/X VGND VGND VPWR VPWR _6016_/D sky130_fd_sc_hd__clkbuf_4
Xload_slew668 _4067_/A VGND VGND VPWR VPWR _3996_/B sky130_fd_sc_hd__buf_4
X_4000_ _4000_/A _6005_/S _4000_/C VGND VGND VPWR VPWR _6003_/A sky130_fd_sc_hd__and3_2
XTAP_TAPCELL_ROW_68_929 VGND VPWR sky130_fd_sc_hd__tapvpwrvgnd_1
XFILLER_37_113 VGND VGND VPWR VPWR sky130_fd_sc_hd__decap_3
XFILLER_37_124 VGND VGND VPWR VPWR sky130_fd_sc_hd__decap_3
XFILLER_77_260 VGND VGND VPWR VPWR sky130_fd_sc_hd__decap_3
XFILLER_1_74 VGND VGND VPWR VPWR sky130_fd_sc_hd__decap_3
XFILLER_65_455 VGND VGND VPWR VPWR sky130_fd_sc_hd__decap_3
XFILLER_77_293 VGND VGND VPWR VPWR sky130_fd_sc_hd__decap_3
XFILLER_92_241 VGND VGND VPWR VPWR sky130_fd_sc_hd__decap_3
XFILLER_65_488 VGND VGND VPWR VPWR sky130_fd_sc_hd__decap_3
XFILLER_92_274 VGND VGND VPWR VPWR sky130_fd_sc_hd__decap_3
X_5951_ _5951_/A _5951_/B VGND VGND VPWR VPWR _5952_/B sky130_fd_sc_hd__xnor2_2
XFILLER_33_330 VGND VGND VPWR VPWR sky130_fd_sc_hd__decap_3
XFILLER_80_447 VGND VGND VPWR VPWR sky130_fd_sc_hd__decap_3
XFILLER_92_296 VGND VGND VPWR VPWR sky130_fd_sc_hd__decap_3
X_4902_ _4902_/A _4902_/B VGND VGND VPWR VPWR _4903_/C sky130_fd_sc_hd__nor2_2
X_5882_ _5882_/A _5888_/A VGND VGND VPWR VPWR _5882_/Y sky130_fd_sc_hd__nor2_2
XFILLER_60_182 VGND VGND VPWR VPWR sky130_fd_sc_hd__decap_3
X_4833_ _4830_/X _4831_/Y _4806_/A _4993_/A VGND VGND VPWR VPWR _4834_/A sky130_fd_sc_hd__o211a_2
XFILLER_60_193 VGND VGND VPWR VPWR sky130_fd_sc_hd__decap_3
X_4764_ _4764_/A _4764_/B VGND VGND VPWR VPWR _4773_/A sky130_fd_sc_hd__nand2_2
XTAP_TAPCELL_ROW_31_542 VGND VPWR sky130_fd_sc_hd__tapvpwrvgnd_1
X_6503_ _6426_/X _6432_/X _6433_/X _6435_/X _6493_/A _6569_/B VGND VGND VPWR VPWR
+ _6503_/X sky130_fd_sc_hd__mux4_2
Xrebuffer829 _5011_/Y VGND VGND VPWR VPWR _6857_/A sky130_fd_sc_hd__buf_2
X_3715_ _4282_/A _3712_/B _3714_/B _3711_/X VGND VGND VPWR VPWR _3717_/B sky130_fd_sc_hd__a31o_2
X_6434_ _6432_/X _6433_/X _6434_/S VGND VGND VPWR VPWR _6434_/X sky130_fd_sc_hd__mux2_1
X_4695_ _4748_/A _4695_/B VGND VGND VPWR VPWR _4697_/B sky130_fd_sc_hd__nand2_2
XFILLER_20_39 VGND VGND VPWR VPWR sky130_fd_sc_hd__decap_3
X_3646_ _4505_/B _4361_/C _4361_/D _4387_/B VGND VGND VPWR VPWR _3647_/D sky130_fd_sc_hd__a22o_2
X_6365_ _6369_/A _6368_/B VGND VGND VPWR VPWR _6365_/Y sky130_fd_sc_hd__nor2_2
X_3577_ _3900_/A _6098_/A VGND VGND VPWR VPWR _3581_/A sky130_fd_sc_hd__nand2_2
XFILLER_88_514 VGND VGND VPWR VPWR sky130_fd_sc_hd__decap_3
X_6296_ _6698_/A _6767_/A VGND VGND VPWR VPWR _6296_/Y sky130_fd_sc_hd__nor2_2
X_5316_ _5346_/B _5315_/C _5315_/A VGND VGND VPWR VPWR _5317_/C sky130_fd_sc_hd__a21o_2
XFILLER_88_536 VGND VGND VPWR VPWR sky130_fd_sc_hd__fill_1
X_5247_ _5245_/Y _5244_/X _5219_/Y _5827_/A1 VGND VGND VPWR VPWR _5248_/A sky130_fd_sc_hd__a211o_4
XFILLER_29_48 VGND VGND VPWR VPWR sky130_fd_sc_hd__decap_3
X_5178_ _5178_/A VGND VGND VPWR VPWR _5180_/B sky130_fd_sc_hd__inv_2
XFILLER_68_293 VGND VGND VPWR VPWR sky130_fd_sc_hd__decap_3
X_4129_ _4129_/A _4129_/B _4129_/C VGND VGND VPWR VPWR _4246_/A sky130_fd_sc_hd__nand3_2
XTAP_TAPCELL_ROW_3_245 VGND VPWR sky130_fd_sc_hd__tapvpwrvgnd_1
XTAP_TAPCELL_ROW_39_631 VGND VPWR sky130_fd_sc_hd__tapvpwrvgnd_1
XFILLER_28_179 VGND VGND VPWR VPWR sky130_fd_sc_hd__decap_3
XFILLER_43_116 VGND VGND VPWR VPWR sky130_fd_sc_hd__decap_3
XFILLER_56_499 VGND VGND VPWR VPWR sky130_fd_sc_hd__decap_3
XFILLER_83_252 VGND VGND VPWR VPWR sky130_fd_sc_hd__decap_3
XFILLER_43_138 VGND VGND VPWR VPWR sky130_fd_sc_hd__decap_3
XFILLER_83_296 VGND VGND VPWR VPWR sky130_fd_sc_hd__decap_3
XFILLER_24_341 VGND VGND VPWR VPWR sky130_fd_sc_hd__decap_3
XFILLER_24_385 VGND VGND VPWR VPWR sky130_fd_sc_hd__decap_3
XFILLER_12_558 VGND VGND VPWR VPWR sky130_fd_sc_hd__fill_1
XFILLER_8_518 VGND VGND VPWR VPWR sky130_fd_sc_hd__fill_1
XFILLER_8_529 VGND VGND VPWR VPWR sky130_fd_sc_hd__decap_3
XFILLER_3_234 VGND VGND VPWR VPWR sky130_fd_sc_hd__decap_3
XFILLER_3_256 VGND VGND VPWR VPWR sky130_fd_sc_hd__fill_1
XFILLER_79_503 VGND VGND VPWR VPWR sky130_fd_sc_hd__fill_1
XFILLER_86_21 VGND VGND VPWR VPWR sky130_fd_sc_hd__fill_1
XFILLER_86_32 VGND VGND VPWR VPWR sky130_fd_sc_hd__decap_3
XFILLER_94_517 VGND VGND VPWR VPWR sky130_fd_sc_hd__decap_3
XFILLER_47_411 VGND VGND VPWR VPWR sky130_fd_sc_hd__decap_3
XFILLER_59_271 VGND VGND VPWR VPWR sky130_fd_sc_hd__decap_3
XFILLER_87_591 VGND VGND VPWR VPWR sky130_fd_sc_hd__decap_3
XFILLER_94_539 VGND VGND VPWR VPWR sky130_fd_sc_hd__decap_3
XFILLER_19_70 VGND VGND VPWR VPWR sky130_fd_sc_hd__decap_3
XFILLER_47_444 VGND VGND VPWR VPWR sky130_fd_sc_hd__decap_3
XFILLER_47_455 VGND VGND VPWR VPWR sky130_fd_sc_hd__decap_3
XFILLER_47_488 VGND VGND VPWR VPWR sky130_fd_sc_hd__fill_2
XFILLER_62_403 VGND VGND VPWR VPWR sky130_fd_sc_hd__fill_2
XFILLER_74_296 VGND VGND VPWR VPWR sky130_fd_sc_hd__decap_3
XFILLER_15_330 VGND VGND VPWR VPWR sky130_fd_sc_hd__decap_3
XFILLER_15_352 VGND VGND VPWR VPWR sky130_fd_sc_hd__fill_1
XTAP_TAPCELL_ROW_73_987 VGND VPWR sky130_fd_sc_hd__tapvpwrvgnd_1
XFILLER_35_80 VGND VGND VPWR VPWR sky130_fd_sc_hd__decap_3
XTAP_TAPCELL_ROW_45_689 VGND VPWR sky130_fd_sc_hd__tapvpwrvgnd_1
XFILLER_30_377 VGND VGND VPWR VPWR sky130_fd_sc_hd__decap_3
X_3500_ _5585_/B VGND VGND VPWR VPWR _3500_/Y sky130_fd_sc_hd__inv_2
XFILLER_7_573 VGND VGND VPWR VPWR sky130_fd_sc_hd__decap_3
Xwire471 wire471/A VGND VGND VPWR VPWR _5275_/B sky130_fd_sc_hd__buf_6
Xwire482 wire482/A VGND VGND VPWR VPWR wire482/X sky130_fd_sc_hd__clkbuf_4
X_4480_ _4364_/A _4364_/C _4364_/B VGND VGND VPWR VPWR _4481_/C sky130_fd_sc_hd__o21ai_2
XTAP_TAPCELL_ROW_77_1024 VGND VPWR sky130_fd_sc_hd__tapvpwrvgnd_1
X_6150_ _6150_/A _6717_/A VGND VGND VPWR VPWR _6709_/A sky130_fd_sc_hd__or2_2
Xload_slew410 _4617_/B VGND VGND VPWR VPWR _4362_/B sky130_fd_sc_hd__buf_6
X_5101_ _5098_/A _5096_/X _4802_/Y _4804_/Y VGND VGND VPWR VPWR _5101_/X sky130_fd_sc_hd__o211a_2
XFILLER_97_311 VGND VGND VPWR VPWR sky130_fd_sc_hd__decap_3
XFILLER_57_208 VGND VGND VPWR VPWR sky130_fd_sc_hd__decap_3
Xload_slew465 _3867_/B VGND VGND VPWR VPWR _6405_/S sky130_fd_sc_hd__clkbuf_4
Xload_slew432 _5115_/B VGND VGND VPWR VPWR _5304_/B sky130_fd_sc_hd__clkbuf_2
X_6081_ _6083_/A _6083_/B VGND VGND VPWR VPWR _6842_/B sky130_fd_sc_hd__nand2_2
Xload_slew498 _5134_/A VGND VGND VPWR VPWR _5313_/A sky130_fd_sc_hd__buf_2
Xload_slew476 fanout475/X VGND VGND VPWR VPWR _4749_/A sky130_fd_sc_hd__buf_4
X_5032_ _5341_/A _5341_/B _5188_/C _5290_/C VGND VGND VPWR VPWR _5035_/A sky130_fd_sc_hd__and4_2
XFILLER_97_399 VGND VGND VPWR VPWR sky130_fd_sc_hd__fill_2
XFILLER_38_455 VGND VGND VPWR VPWR sky130_fd_sc_hd__fill_1
XTAP_TAPCELL_ROW_88_1142 VGND VPWR sky130_fd_sc_hd__tapvpwrvgnd_1
XFILLER_38_466 VGND VGND VPWR VPWR sky130_fd_sc_hd__fill_1
XFILLER_53_403 VGND VGND VPWR VPWR sky130_fd_sc_hd__decap_3
XFILLER_65_263 VGND VGND VPWR VPWR sky130_fd_sc_hd__decap_3
XFILLER_80_200 VGND VGND VPWR VPWR sky130_fd_sc_hd__decap_3
XTAP_TAPCELL_ROW_0_215 VGND VPWR sky130_fd_sc_hd__tapvpwrvgnd_1
XTAP_TAPCELL_ROW_0_204 VGND VPWR sky130_fd_sc_hd__tapvpwrvgnd_1
XFILLER_93_572 VGND VGND VPWR VPWR sky130_fd_sc_hd__decap_3
XFILLER_25_116 VGND VGND VPWR VPWR sky130_fd_sc_hd__decap_3
X_6983_ _6983_/A _6983_/B VGND VGND VPWR VPWR _6992_/C sky130_fd_sc_hd__or2_2
XFILLER_53_458 VGND VGND VPWR VPWR sky130_fd_sc_hd__decap_3
XFILLER_53_469 VGND VGND VPWR VPWR sky130_fd_sc_hd__fill_1
X_5934_ _5934_/A _5934_/B _5934_/C VGND VGND VPWR VPWR _5934_/X sky130_fd_sc_hd__or3_4
X_5865_ _5871_/A _5871_/B VGND VGND VPWR VPWR _6754_/A sky130_fd_sc_hd__or2_2
XFILLER_21_322 VGND VGND VPWR VPWR sky130_fd_sc_hd__decap_3
X_4816_ _4816_/A _4816_/B _4816_/C VGND VGND VPWR VPWR _4816_/Y sky130_fd_sc_hd__nand3_2
XTAP_TAPCELL_ROW_16_380 VGND VPWR sky130_fd_sc_hd__tapvpwrvgnd_1
XFILLER_21_377 VGND VGND VPWR VPWR sky130_fd_sc_hd__decap_3
X_5796_ _5801_/A _5796_/B VGND VGND VPWR VPWR _5797_/B sky130_fd_sc_hd__nor2_2
XFILLER_31_49 VGND VGND VPWR VPWR sky130_fd_sc_hd__decap_3
X_4747_ _4747_/A _4747_/B _4747_/C VGND VGND VPWR VPWR _4747_/Y sky130_fd_sc_hd__nand3_2
XTAP_TAPCELL_ROW_99_1260 VGND VPWR sky130_fd_sc_hd__tapvpwrvgnd_1
X_4678_ _4678_/A _4678_/B _4678_/C VGND VGND VPWR VPWR _4678_/X sky130_fd_sc_hd__or3_2
X_6417_ _6493_/A _6417_/B VGND VGND VPWR VPWR _6417_/X sky130_fd_sc_hd__and2_2
X_3629_ _3629_/A _3661_/A VGND VGND VPWR VPWR _3631_/B sky130_fd_sc_hd__nor2_2
X_6348_ _6348_/A _6970_/A _6348_/C _6957_/A VGND VGND VPWR VPWR _6348_/Y sky130_fd_sc_hd__nand4_2
XTAP_TAPCELL_ROW_8_304 VGND VPWR sky130_fd_sc_hd__tapvpwrvgnd_1
XFILLER_0_237 VGND VGND VPWR VPWR sky130_fd_sc_hd__decap_3
XFILLER_88_333 VGND VGND VPWR VPWR sky130_fd_sc_hd__fill_2
XFILLER_88_377 VGND VGND VPWR VPWR sky130_fd_sc_hd__decap_3
X_6279_ _6931_/B _6278_/Y _6931_/A VGND VGND VPWR VPWR _6279_/X sky130_fd_sc_hd__o21a_2
XFILLER_29_422 VGND VGND VPWR VPWR sky130_fd_sc_hd__fill_1
XFILLER_29_455 VGND VGND VPWR VPWR sky130_fd_sc_hd__decap_3
XFILLER_56_274 VGND VGND VPWR VPWR sky130_fd_sc_hd__decap_3
XFILLER_56_68 VGND VGND VPWR VPWR sky130_fd_sc_hd__fill_2
XFILLER_56_79 VGND VGND VPWR VPWR sky130_fd_sc_hd__decap_3
XFILLER_56_296 VGND VGND VPWR VPWR sky130_fd_sc_hd__decap_3
XFILLER_71_222 VGND VGND VPWR VPWR sky130_fd_sc_hd__fill_2
XFILLER_16_149 VGND VGND VPWR VPWR sky130_fd_sc_hd__decap_3
XFILLER_71_255 VGND VGND VPWR VPWR sky130_fd_sc_hd__decap_3
XFILLER_71_299 VGND VGND VPWR VPWR sky130_fd_sc_hd__decap_3
XFILLER_12_322 VGND VGND VPWR VPWR sky130_fd_sc_hd__fill_1
XTAP_TAPCELL_ROW_70_957 VGND VPWR sky130_fd_sc_hd__tapvpwrvgnd_1
XTAP_TAPCELL_ROW_42_659 VGND VPWR sky130_fd_sc_hd__tapvpwrvgnd_1
XFILLER_12_377 VGND VGND VPWR VPWR sky130_fd_sc_hd__decap_3
XFILLER_8_315 VGND VGND VPWR VPWR sky130_fd_sc_hd__decap_3
XFILLER_39_219 VGND VGND VPWR VPWR sky130_fd_sc_hd__decap_3
XFILLER_67_517 VGND VGND VPWR VPWR sky130_fd_sc_hd__decap_3
XFILLER_79_388 VGND VGND VPWR VPWR sky130_fd_sc_hd__decap_3
XFILLER_79_399 VGND VGND VPWR VPWR sky130_fd_sc_hd__decap_3
XFILLER_94_303 VGND VGND VPWR VPWR sky130_fd_sc_hd__decap_3
XFILLER_75_561 VGND VGND VPWR VPWR sky130_fd_sc_hd__decap_3
XFILLER_35_447 VGND VGND VPWR VPWR sky130_fd_sc_hd__fill_1
XFILLER_62_200 VGND VGND VPWR VPWR sky130_fd_sc_hd__decap_3
XFILLER_62_233 VGND VGND VPWR VPWR sky130_fd_sc_hd__decap_3
XFILLER_90_542 VGND VGND VPWR VPWR sky130_fd_sc_hd__fill_1
XFILLER_90_553 VGND VGND VPWR VPWR sky130_fd_sc_hd__fill_2
X_3980_ _3980_/A _3980_/B VGND VGND VPWR VPWR _3982_/B sky130_fd_sc_hd__xor2_2
XFILLER_62_299 VGND VGND VPWR VPWR sky130_fd_sc_hd__decap_3
X_5650_ _5647_/Y _5649_/Y _5614_/Y _5617_/X VGND VGND VPWR VPWR _5817_/B sky130_fd_sc_hd__o211a_2
XFILLER_30_141 VGND VGND VPWR VPWR sky130_fd_sc_hd__decap_3
XFILLER_30_163 VGND VGND VPWR VPWR sky130_fd_sc_hd__decap_3
X_4601_ _4836_/A _4836_/B VGND VGND VPWR VPWR _4603_/B sky130_fd_sc_hd__xnor2_2
XTAP_TAPCELL_ROW_13_350 VGND VPWR sky130_fd_sc_hd__tapvpwrvgnd_1
X_5581_ _5599_/A _5657_/A _5581_/C VGND VGND VPWR VPWR _5599_/B sky130_fd_sc_hd__and3b_2
X_4532_ _4516_/X _4531_/Y _4414_/X _4503_/Y VGND VGND VPWR VPWR _4554_/A sky130_fd_sc_hd__o211ai_2
X_4463_ _4464_/B _4464_/C _4464_/A VGND VGND VPWR VPWR _4473_/B sky130_fd_sc_hd__a21oi_2
X_6202_ _6336_/A _6353_/C _6332_/A _6332_/B VGND VGND VPWR VPWR _6202_/Y sky130_fd_sc_hd__nor4_1
X_4394_ _4394_/A _4394_/B VGND VGND VPWR VPWR _4493_/B sky130_fd_sc_hd__xnor2_2
XPHY_EDGE_ROW_15_Right_15 VGND VGND VPWR VPWR sky130_fd_sc_hd__decap_3
Xload_slew240 _3685_/D VGND VGND VPWR VPWR _4406_/D sky130_fd_sc_hd__buf_6
X_6133_ _6133_/A _6550_/A VGND VGND VPWR VPWR _6133_/Y sky130_fd_sc_hd__nand2_2
XFILLER_58_528 VGND VGND VPWR VPWR sky130_fd_sc_hd__decap_3
Xload_slew273 _6369_/A VGND VGND VPWR VPWR _6392_/A sky130_fd_sc_hd__buf_4
Xload_slew262 _5490_/C VGND VGND VPWR VPWR _5151_/C sky130_fd_sc_hd__buf_2
X_6064_ _6337_/A _6350_/B VGND VGND VPWR VPWR _6331_/A sky130_fd_sc_hd__or2_2
Xload_slew295 _6414_/S VGND VGND VPWR VPWR _6501_/S sky130_fd_sc_hd__buf_4
X_5015_ _5015_/A _5015_/B VGND VGND VPWR VPWR _5016_/B sky130_fd_sc_hd__or2_2
XFILLER_66_550 VGND VGND VPWR VPWR sky130_fd_sc_hd__decap_3
XFILLER_66_572 VGND VGND VPWR VPWR sky130_fd_sc_hd__fill_2
XFILLER_85_369 VGND VGND VPWR VPWR sky130_fd_sc_hd__decap_3
XFILLER_38_296 VGND VGND VPWR VPWR sky130_fd_sc_hd__decap_3
XFILLER_53_222 VGND VGND VPWR VPWR sky130_fd_sc_hd__fill_2
XFILLER_81_553 VGND VGND VPWR VPWR sky130_fd_sc_hd__decap_3
X_6966_ _6392_/A _6700_/Y _6962_/X _6965_/X VGND VGND VPWR VPWR _6966_/Y sky130_fd_sc_hd__o211ai_2
XPHY_EDGE_ROW_24_Right_24 VGND VGND VPWR VPWR sky130_fd_sc_hd__decap_3
XFILLER_41_428 VGND VGND VPWR VPWR sky130_fd_sc_hd__decap_3
XFILLER_81_597 VGND VGND VPWR VPWR sky130_fd_sc_hd__fill_1
X_5917_ _5261_/Y _5877_/X _5916_/X VGND VGND VPWR VPWR _5917_/X sky130_fd_sc_hd__a21o_4
XFILLER_34_480 VGND VGND VPWR VPWR sky130_fd_sc_hd__decap_3
X_6897_ _6623_/X _6896_/X _6897_/S VGND VGND VPWR VPWR _6898_/A sky130_fd_sc_hd__mux2_1
X_5848_ _5848_/A _5848_/B _5848_/C VGND VGND VPWR VPWR _5848_/Y sky130_fd_sc_hd__nor3_4
XFILLER_21_185 VGND VGND VPWR VPWR sky130_fd_sc_hd__decap_3
X_5779_ _5779_/A _5791_/B VGND VGND VPWR VPWR _5792_/A sky130_fd_sc_hd__nand2_2
XFILLER_5_318 VGND VGND VPWR VPWR sky130_fd_sc_hd__decap_3
XPHY_EDGE_ROW_2_Left_103 VGND VGND VPWR VPWR sky130_fd_sc_hd__decap_3
XFILLER_1_502 VGND VGND VPWR VPWR sky130_fd_sc_hd__fill_2
XPHY_EDGE_ROW_33_Right_33 VGND VGND VPWR VPWR sky130_fd_sc_hd__decap_3
XFILLER_1_535 VGND VGND VPWR VPWR sky130_fd_sc_hd__decap_3
XFILLER_67_12 VGND VGND VPWR VPWR sky130_fd_sc_hd__fill_2
XFILLER_88_141 VGND VGND VPWR VPWR sky130_fd_sc_hd__decap_3
XFILLER_49_528 VGND VGND VPWR VPWR sky130_fd_sc_hd__decap_3
XFILLER_76_303 VGND VGND VPWR VPWR sky130_fd_sc_hd__decap_3
XFILLER_88_174 VGND VGND VPWR VPWR sky130_fd_sc_hd__decap_3
XFILLER_67_67 VGND VGND VPWR VPWR sky130_fd_sc_hd__decap_3
XFILLER_91_306 VGND VGND VPWR VPWR sky130_fd_sc_hd__decap_3
XTAP_TAPCELL_ROW_47_707 VGND VPWR sky130_fd_sc_hd__tapvpwrvgnd_1
XFILLER_44_211 VGND VGND VPWR VPWR sky130_fd_sc_hd__decap_3
XFILLER_57_583 VGND VGND VPWR VPWR sky130_fd_sc_hd__fill_1
XFILLER_83_33 VGND VGND VPWR VPWR sky130_fd_sc_hd__decap_3
XFILLER_84_380 VGND VGND VPWR VPWR sky130_fd_sc_hd__decap_3
XPHY_EDGE_ROW_48_Left_149 VGND VGND VPWR VPWR sky130_fd_sc_hd__decap_3
XPHY_EDGE_ROW_42_Right_42 VGND VGND VPWR VPWR sky130_fd_sc_hd__decap_3
XFILLER_72_553 VGND VGND VPWR VPWR sky130_fd_sc_hd__decap_3
XFILLER_83_55 VGND VGND VPWR VPWR sky130_fd_sc_hd__fill_1
XFILLER_83_66 VGND VGND VPWR VPWR sky130_fd_sc_hd__decap_3
XFILLER_32_428 VGND VGND VPWR VPWR sky130_fd_sc_hd__decap_3
XFILLER_44_277 VGND VGND VPWR VPWR sky130_fd_sc_hd__decap_3
XTAP_TAPCELL_ROW_55_795 VGND VPWR sky130_fd_sc_hd__tapvpwrvgnd_1
XFILLER_16_82 VGND VGND VPWR VPWR sky130_fd_sc_hd__fill_2
XTAP_TAPCELL_ROW_27_497 VGND VPWR sky130_fd_sc_hd__tapvpwrvgnd_1
XFILLER_12_141 VGND VGND VPWR VPWR sky130_fd_sc_hd__decap_3
XFILLER_40_450 VGND VGND VPWR VPWR sky130_fd_sc_hd__decap_3
XFILLER_8_112 VGND VGND VPWR VPWR sky130_fd_sc_hd__fill_1
XFILLER_73_9 VGND VGND VPWR VPWR sky130_fd_sc_hd__fill_2
XTAP_TAPCELL_ROW_10_320 VGND VPWR sky130_fd_sc_hd__tapvpwrvgnd_1
XPHY_EDGE_ROW_57_Left_158 VGND VGND VPWR VPWR sky130_fd_sc_hd__decap_3
XPHY_EDGE_ROW_51_Right_51 VGND VGND VPWR VPWR sky130_fd_sc_hd__decap_3
XFILLER_79_130 VGND VGND VPWR VPWR sky130_fd_sc_hd__decap_3
XFILLER_67_314 VGND VGND VPWR VPWR sky130_fd_sc_hd__decap_3
XFILLER_79_163 VGND VGND VPWR VPWR sky130_fd_sc_hd__decap_3
XPHY_EDGE_ROW_66_Left_167 VGND VGND VPWR VPWR sky130_fd_sc_hd__decap_3
XPHY_EDGE_ROW_60_Right_60 VGND VGND VPWR VPWR sky130_fd_sc_hd__decap_3
XFILLER_94_177 VGND VGND VPWR VPWR sky130_fd_sc_hd__decap_3
XFILLER_75_380 VGND VGND VPWR VPWR sky130_fd_sc_hd__decap_3
XTAP_TAPCELL_ROW_85_1112 VGND VPWR sky130_fd_sc_hd__tapvpwrvgnd_1
XFILLER_35_233 VGND VGND VPWR VPWR sky130_fd_sc_hd__decap_3
XFILLER_63_564 VGND VGND VPWR VPWR sky130_fd_sc_hd__fill_2
X_6820_ _6923_/A _6806_/X _6819_/X VGND VGND VPWR VPWR _6984_/C sky130_fd_sc_hd__a21o_2
XFILLER_35_277 VGND VGND VPWR VPWR sky130_fd_sc_hd__decap_3
XFILLER_50_203 VGND VGND VPWR VPWR sky130_fd_sc_hd__decap_3
XFILLER_90_383 VGND VGND VPWR VPWR sky130_fd_sc_hd__fill_1
XFILLER_16_480 VGND VGND VPWR VPWR sky130_fd_sc_hd__decap_3
X_6751_ _6586_/A _6407_/X _6930_/A _6750_/Y VGND VGND VPWR VPWR _6751_/X sky130_fd_sc_hd__a211o_2
X_3963_ _3963_/A _3963_/B VGND VGND VPWR VPWR _3964_/B sky130_fd_sc_hd__nor2_2
XFILLER_31_461 VGND VGND VPWR VPWR sky130_fd_sc_hd__decap_3
X_6682_ _6498_/A _6677_/Y _6680_/X _6730_/B _6681_/X VGND VGND VPWR VPWR _6682_/X
+ sky130_fd_sc_hd__o221a_2
X_5702_ _5700_/A _5700_/B _5700_/C VGND VGND VPWR VPWR _5703_/C sky130_fd_sc_hd__a21oi_2
X_3894_ _3894_/A _3894_/B VGND VGND VPWR VPWR _3895_/B sky130_fd_sc_hd__nor2_2
X_5633_ _5632_/B _5632_/C _5632_/A VGND VGND VPWR VPWR _5634_/C sky130_fd_sc_hd__o21bai_2
XPHY_EDGE_ROW_75_Left_176 VGND VGND VPWR VPWR sky130_fd_sc_hd__decap_3
XFILLER_12_29 VGND VGND VPWR VPWR sky130_fd_sc_hd__decap_3
X_5564_ _5562_/B _5562_/Y _5563_/Y _5513_/X VGND VGND VPWR VPWR _5564_/Y sky130_fd_sc_hd__a211oi_2
X_4515_ _4412_/A _4412_/C _4412_/B VGND VGND VPWR VPWR _4516_/C sky130_fd_sc_hd__a21o_2
XTAP_TAPCELL_ROW_96_1230 VGND VPWR sky130_fd_sc_hd__tapvpwrvgnd_1
X_5495_ _5495_/A _5495_/B VGND VGND VPWR VPWR _5498_/B sky130_fd_sc_hd__xnor2_2
X_4446_ _4448_/A _4448_/B VGND VGND VPWR VPWR _4446_/X sky130_fd_sc_hd__or2_2
Xfanout614 input17/X VGND VGND VPWR VPWR _6879_/B2 sky130_fd_sc_hd__clkdlybuf4s25_1
X_4377_ _4348_/A _4348_/B _4348_/C VGND VGND VPWR VPWR _4378_/D sky130_fd_sc_hd__a21oi_2
XFILLER_98_450 VGND VGND VPWR VPWR sky130_fd_sc_hd__decap_3
XFILLER_58_303 VGND VGND VPWR VPWR sky130_fd_sc_hd__decap_3
Xfanout625 _6083_/B VGND VGND VPWR VPWR _4826_/A sky130_fd_sc_hd__clkbuf_2
Xfanout647 input12/X VGND VGND VPWR VPWR _4593_/B sky130_fd_sc_hd__clkdlybuf4s25_1
Xfanout658 input10/X VGND VGND VPWR VPWR wire659/A sky130_fd_sc_hd__clkdlybuf4s25_1
X_6116_ _6232_/B _6116_/B VGND VGND VPWR VPWR _6117_/B sky130_fd_sc_hd__or2_2
XPHY_EDGE_ROW_84_Left_185 VGND VGND VPWR VPWR sky130_fd_sc_hd__decap_3
XFILLER_58_336 VGND VGND VPWR VPWR sky130_fd_sc_hd__decap_3
XFILLER_85_122 VGND VGND VPWR VPWR sky130_fd_sc_hd__decap_3
Xfanout669 input1/X VGND VGND VPWR VPWR _4088_/B sky130_fd_sc_hd__clkdlybuf4s25_1
XFILLER_100_455 VGND VGND VPWR VPWR sky130_fd_sc_hd__decap_3
XFILLER_100_477 VGND VGND VPWR VPWR sky130_fd_sc_hd__decap_3
XFILLER_85_166 VGND VGND VPWR VPWR sky130_fd_sc_hd__fill_2
X_6047_ _6047_/A _6047_/B VGND VGND VPWR VPWR _6048_/B sky130_fd_sc_hd__xnor2_2
XFILLER_26_200 VGND VGND VPWR VPWR sky130_fd_sc_hd__decap_3
XFILLER_54_531 VGND VGND VPWR VPWR sky130_fd_sc_hd__fill_1
XFILLER_66_380 VGND VGND VPWR VPWR sky130_fd_sc_hd__decap_3
XFILLER_54_542 VGND VGND VPWR VPWR sky130_fd_sc_hd__decap_3
XFILLER_53_36 VGND VGND VPWR VPWR sky130_fd_sc_hd__fill_1
XFILLER_81_383 VGND VGND VPWR VPWR sky130_fd_sc_hd__decap_3
XFILLER_41_236 VGND VGND VPWR VPWR sky130_fd_sc_hd__decap_3
XFILLER_53_69 VGND VGND VPWR VPWR sky130_fd_sc_hd__fill_1
X_6949_ _6949_/A _6949_/B _6937_/X VGND VGND VPWR VPWR _6994_/B sky130_fd_sc_hd__or3b_4
XTAP_TAPCELL_ROW_52_765 VGND VPWR sky130_fd_sc_hd__tapvpwrvgnd_1
XTAP_TAPCELL_ROW_24_467 VGND VPWR sky130_fd_sc_hd__tapvpwrvgnd_1
XPHY_EDGE_ROW_93_Left_194 VGND VGND VPWR VPWR sky130_fd_sc_hd__decap_3
XFILLER_22_472 VGND VGND VPWR VPWR sky130_fd_sc_hd__decap_3
XFILLER_22_494 VGND VGND VPWR VPWR sky130_fd_sc_hd__decap_3
XFILLER_49_314 VGND VGND VPWR VPWR sky130_fd_sc_hd__decap_3
XFILLER_89_483 VGND VGND VPWR VPWR sky130_fd_sc_hd__decap_3
XFILLER_76_133 VGND VGND VPWR VPWR sky130_fd_sc_hd__decap_3
XFILLER_76_144 VGND VGND VPWR VPWR sky130_fd_sc_hd__decap_3
XFILLER_17_211 VGND VGND VPWR VPWR sky130_fd_sc_hd__decap_3
XFILLER_45_520 VGND VGND VPWR VPWR sky130_fd_sc_hd__decap_3
XFILLER_64_339 VGND VGND VPWR VPWR sky130_fd_sc_hd__decap_3
XFILLER_91_125 VGND VGND VPWR VPWR sky130_fd_sc_hd__fill_2
XFILLER_94_76 VGND VGND VPWR VPWR sky130_fd_sc_hd__decap_3
XFILLER_17_244 VGND VGND VPWR VPWR sky130_fd_sc_hd__decap_3
XFILLER_57_391 VGND VGND VPWR VPWR sky130_fd_sc_hd__fill_1
XFILLER_94_98 VGND VGND VPWR VPWR sky130_fd_sc_hd__decap_3
XFILLER_60_523 VGND VGND VPWR VPWR sky130_fd_sc_hd__decap_3
XFILLER_13_461 VGND VGND VPWR VPWR sky130_fd_sc_hd__decap_3
XFILLER_20_409 VGND VGND VPWR VPWR sky130_fd_sc_hd__decap_3
XFILLER_60_567 VGND VGND VPWR VPWR sky130_fd_sc_hd__decap_3
XFILLER_60_589 VGND VGND VPWR VPWR sky130_fd_sc_hd__decap_3
XTAP_TAPCELL_ROW_80_1053 VGND VPWR sky130_fd_sc_hd__tapvpwrvgnd_1
XFILLER_9_410 VGND VGND VPWR VPWR sky130_fd_sc_hd__decap_3
XFILLER_40_280 VGND VGND VPWR VPWR sky130_fd_sc_hd__decap_3
XFILLER_43_80 VGND VGND VPWR VPWR sky130_fd_sc_hd__fill_1
XFILLER_71_6 VGND VGND VPWR VPWR sky130_fd_sc_hd__fill_1
X_5280_ _5280_/A _5280_/B VGND VGND VPWR VPWR _5283_/B sky130_fd_sc_hd__nor2_4
X_4300_ _4551_/A _4568_/B VGND VGND VPWR VPWR _4302_/B sky130_fd_sc_hd__and2_2
XFILLER_99_225 VGND VGND VPWR VPWR sky130_fd_sc_hd__decap_3
X_4231_ _4476_/A _4482_/A _4593_/C _4593_/D VGND VGND VPWR VPWR _4231_/X sky130_fd_sc_hd__and4_2
XFILLER_4_85 VGND VGND VPWR VPWR sky130_fd_sc_hd__fill_1
XTAP_TAPCELL_ROW_91_1171 VGND VPWR sky130_fd_sc_hd__tapvpwrvgnd_1
XFILLER_67_133 VGND VGND VPWR VPWR sky130_fd_sc_hd__decap_3
X_4162_ _3757_/A _4526_/B _3758_/A _3757_/D VGND VGND VPWR VPWR _4163_/C sky130_fd_sc_hd__a22o_2
XFILLER_55_306 VGND VGND VPWR VPWR sky130_fd_sc_hd__decap_3
X_4093_ _4094_/A _4094_/C _4222_/A VGND VGND VPWR VPWR _4106_/A sky130_fd_sc_hd__a21o_2
XFILLER_95_464 VGND VGND VPWR VPWR sky130_fd_sc_hd__decap_3
XFILLER_36_531 VGND VGND VPWR VPWR sky130_fd_sc_hd__fill_1
XFILLER_36_542 VGND VGND VPWR VPWR sky130_fd_sc_hd__decap_3
XFILLER_82_158 VGND VGND VPWR VPWR sky130_fd_sc_hd__decap_3
XFILLER_23_203 VGND VGND VPWR VPWR sky130_fd_sc_hd__fill_2
XFILLER_36_564 VGND VGND VPWR VPWR sky130_fd_sc_hd__decap_3
XFILLER_23_225 VGND VGND VPWR VPWR sky130_fd_sc_hd__decap_3
XFILLER_51_534 VGND VGND VPWR VPWR sky130_fd_sc_hd__decap_3
XFILLER_51_556 VGND VGND VPWR VPWR sky130_fd_sc_hd__decap_3
X_6803_ _6803_/A _6803_/B _6803_/C VGND VGND VPWR VPWR _6803_/X sky130_fd_sc_hd__or3_2
X_4995_ _4993_/A _4993_/C _4993_/B VGND VGND VPWR VPWR _4995_/Y sky130_fd_sc_hd__a21oi_2
XFILLER_23_17 VGND VGND VPWR VPWR sky130_fd_sc_hd__decap_3
XFILLER_23_258 VGND VGND VPWR VPWR sky130_fd_sc_hd__decap_3
XFILLER_51_567 VGND VGND VPWR VPWR sky130_fd_sc_hd__decap_3
X_6734_ _6344_/X _6729_/Y _6764_/A VGND VGND VPWR VPWR _6735_/B sky130_fd_sc_hd__mux2_1
X_3946_ _3946_/A _3946_/B VGND VGND VPWR VPWR _3947_/C sky130_fd_sc_hd__xnor2_2
X_6665_ _6652_/Y _6653_/X _6664_/X VGND VGND VPWR VPWR _6665_/Y sky130_fd_sc_hd__o21ai_2
X_3877_ _3877_/A _3877_/B VGND VGND VPWR VPWR _3878_/B sky130_fd_sc_hd__nor2_2
XTAP_TAPCELL_ROW_21_437 VGND VPWR sky130_fd_sc_hd__tapvpwrvgnd_1
X_6596_ _5810_/Y _6582_/X _6583_/Y wire161/A _6595_/Y VGND VGND VPWR VPWR _6986_/D
+ sky130_fd_sc_hd__a221o_2
X_5616_ _5611_/Y _5613_/X _5567_/X _5571_/Y VGND VGND VPWR VPWR _5652_/B sky130_fd_sc_hd__o211ai_2
X_5547_ _5547_/A _5576_/D _5577_/B VGND VGND VPWR VPWR _5579_/B sky130_fd_sc_hd__and3_2
X_5478_ _5543_/A _6215_/B _5576_/C _5547_/A VGND VGND VPWR VPWR _5479_/B sky130_fd_sc_hd__a22o_2
XFILLER_78_409 VGND VGND VPWR VPWR sky130_fd_sc_hd__decap_3
X_4429_ _4428_/B _4428_/C _4428_/A VGND VGND VPWR VPWR _4431_/B sky130_fd_sc_hd__a21boi_2
Xfanout400 _4482_/D VGND VGND VPWR VPWR _4616_/D sky130_fd_sc_hd__dlymetal6s2s_1
Xfanout411 input38/X VGND VGND VPWR VPWR _5018_/B sky130_fd_sc_hd__buf_6
XFILLER_48_36 VGND VGND VPWR VPWR sky130_fd_sc_hd__decap_3
XFILLER_58_122 VGND VGND VPWR VPWR sky130_fd_sc_hd__decap_3
XFILLER_86_442 VGND VGND VPWR VPWR sky130_fd_sc_hd__decap_3
Xfanout433 input35/X VGND VGND VPWR VPWR _4695_/B sky130_fd_sc_hd__buf_6
Xfanout444 _6492_/S0 VGND VGND VPWR VPWR _6358_/A2 sky130_fd_sc_hd__clkdlybuf4s25_1
Xfanout466 _6397_/S VGND VGND VPWR VPWR _6402_/S sky130_fd_sc_hd__clkbuf_2
XFILLER_98_291 VGND VGND VPWR VPWR sky130_fd_sc_hd__decap_3
XFILLER_48_69 VGND VGND VPWR VPWR sky130_fd_sc_hd__decap_3
XFILLER_58_144 VGND VGND VPWR VPWR sky130_fd_sc_hd__decap_3
XFILLER_86_464 VGND VGND VPWR VPWR sky130_fd_sc_hd__decap_3
Xfanout477 wire482/X VGND VGND VPWR VPWR _4608_/A sky130_fd_sc_hd__dlygate4sd1_1
Xfanout499 _4748_/A VGND VGND VPWR VPWR _5361_/A sky130_fd_sc_hd__clkbuf_2
XFILLER_100_274 VGND VGND VPWR VPWR sky130_fd_sc_hd__decap_3
XFILLER_39_380 VGND VGND VPWR VPWR sky130_fd_sc_hd__decap_3
XFILLER_73_103 VGND VGND VPWR VPWR sky130_fd_sc_hd__fill_2
XFILLER_73_125 VGND VGND VPWR VPWR sky130_fd_sc_hd__decap_3
XTAP_TAPCELL_ROW_57_813 VGND VPWR sky130_fd_sc_hd__tapvpwrvgnd_1
XTAP_TAPCELL_ROW_29_526 VGND VPWR sky130_fd_sc_hd__tapvpwrvgnd_1
XFILLER_64_35 VGND VGND VPWR VPWR sky130_fd_sc_hd__decap_3
XFILLER_14_203 VGND VGND VPWR VPWR sky130_fd_sc_hd__decap_3
XFILLER_64_79 VGND VGND VPWR VPWR sky130_fd_sc_hd__decap_3
XFILLER_73_169 VGND VGND VPWR VPWR sky130_fd_sc_hd__decap_3
XFILLER_14_214 VGND VGND VPWR VPWR sky130_fd_sc_hd__decap_3
XFILLER_14_247 VGND VGND VPWR VPWR sky130_fd_sc_hd__decap_3
XFILLER_42_589 VGND VGND VPWR VPWR sky130_fd_sc_hd__fill_1
XFILLER_80_34 VGND VGND VPWR VPWR sky130_fd_sc_hd__decap_3
XFILLER_80_78 VGND VGND VPWR VPWR sky130_fd_sc_hd__decap_3
XFILLER_6_424 VGND VGND VPWR VPWR sky130_fd_sc_hd__fill_1
XFILLER_89_76 VGND VGND VPWR VPWR sky130_fd_sc_hd__fill_2
XFILLER_69_409 VGND VGND VPWR VPWR sky130_fd_sc_hd__decap_3
XFILLER_89_98 VGND VGND VPWR VPWR sky130_fd_sc_hd__decap_3
XFILLER_96_228 VGND VGND VPWR VPWR sky130_fd_sc_hd__decap_3
XFILLER_49_100 VGND VGND VPWR VPWR sky130_fd_sc_hd__decap_3
XFILLER_77_420 VGND VGND VPWR VPWR sky130_fd_sc_hd__decap_3
XFILLER_49_155 VGND VGND VPWR VPWR sky130_fd_sc_hd__decap_3
XFILLER_49_166 VGND VGND VPWR VPWR sky130_fd_sc_hd__fill_2
XFILLER_77_442 VGND VGND VPWR VPWR sky130_fd_sc_hd__decap_3
XFILLER_49_199 VGND VGND VPWR VPWR sky130_fd_sc_hd__fill_1
XFILLER_77_497 VGND VGND VPWR VPWR sky130_fd_sc_hd__fill_1
XFILLER_92_412 VGND VGND VPWR VPWR sky130_fd_sc_hd__decap_3
XFILLER_64_147 VGND VGND VPWR VPWR sky130_fd_sc_hd__fill_2
XFILLER_33_534 VGND VGND VPWR VPWR sky130_fd_sc_hd__decap_3
XFILLER_45_383 VGND VGND VPWR VPWR sky130_fd_sc_hd__fill_1
XFILLER_72_180 VGND VGND VPWR VPWR sky130_fd_sc_hd__decap_3
XFILLER_33_567 VGND VGND VPWR VPWR sky130_fd_sc_hd__decap_3
XFILLER_60_342 VGND VGND VPWR VPWR sky130_fd_sc_hd__decap_3
X_4780_ _4777_/Y _4778_/X _4747_/Y _4974_/C1 VGND VGND VPWR VPWR _4806_/B sky130_fd_sc_hd__o211ai_2
X_3800_ _3977_/A _3976_/B VGND VGND VPWR VPWR _3804_/A sky130_fd_sc_hd__nand2_2
X_3731_ _3730_/A _3730_/B _3730_/C VGND VGND VPWR VPWR _3732_/B sky130_fd_sc_hd__a21oi_2
X_6450_ _6441_/Y _6442_/X _6449_/X _6438_/Y VGND VGND VPWR VPWR _6450_/Y sky130_fd_sc_hd__o211ai_2
X_3662_ _6102_/A _6102_/B VGND VGND VPWR VPWR _6104_/A sky130_fd_sc_hd__and2_2
XFILLER_9_284 VGND VGND VPWR VPWR sky130_fd_sc_hd__decap_3
X_6381_ _6381_/A _6381_/B _6381_/C _6381_/D VGND VGND VPWR VPWR _6382_/B sky130_fd_sc_hd__and4_2
X_5401_ _5398_/X _5401_/B VGND VGND VPWR VPWR _5495_/B sky130_fd_sc_hd__and2b_2
X_3593_ _5983_/B _5983_/D _3814_/C _3814_/D VGND VGND VPWR VPWR _3821_/A sky130_fd_sc_hd__and4_2
X_5332_ _5331_/A _5381_/A VGND VGND VPWR VPWR _5390_/B sky130_fd_sc_hd__and2b_2
X_5263_ _5263_/A _5263_/B VGND VGND VPWR VPWR _6822_/A sky130_fd_sc_hd__nor2_4
X_5194_ _5194_/A _5194_/B _5194_/C VGND VGND VPWR VPWR _5194_/X sky130_fd_sc_hd__and3_2
X_4214_ _4214_/A _4333_/A VGND VGND VPWR VPWR _4217_/A sky130_fd_sc_hd__nor2_2
X_4145_ _4524_/A _4264_/B _3742_/A _3741_/D VGND VGND VPWR VPWR _4146_/B sky130_fd_sc_hd__a22o_2
XFILLER_28_328 VGND VGND VPWR VPWR sky130_fd_sc_hd__decap_3
XFILLER_83_412 VGND VGND VPWR VPWR sky130_fd_sc_hd__decap_3
XFILLER_95_272 VGND VGND VPWR VPWR sky130_fd_sc_hd__decap_3
XFILLER_83_467 VGND VGND VPWR VPWR sky130_fd_sc_hd__fill_2
X_4076_ _4072_/X _4075_/X _4057_/B _4061_/X VGND VGND VPWR VPWR _4080_/A sky130_fd_sc_hd__o211ai_2
XFILLER_55_169 VGND VGND VPWR VPWR sky130_fd_sc_hd__decap_3
XFILLER_70_106 VGND VGND VPWR VPWR sky130_fd_sc_hd__fill_2
XFILLER_34_27 VGND VGND VPWR VPWR sky130_fd_sc_hd__fill_1
XFILLER_36_394 VGND VGND VPWR VPWR sky130_fd_sc_hd__decap_3
XFILLER_70_139 VGND VGND VPWR VPWR sky130_fd_sc_hd__fill_1
XFILLER_24_556 VGND VGND VPWR VPWR sky130_fd_sc_hd__decap_3
XFILLER_24_589 VGND VGND VPWR VPWR sky130_fd_sc_hd__decap_3
XFILLER_51_386 VGND VGND VPWR VPWR sky130_fd_sc_hd__decap_3
X_4978_ _5152_/A _5068_/A _4978_/C _4978_/D VGND VGND VPWR VPWR _4978_/X sky130_fd_sc_hd__and4_2
XTAP_TAPCELL_ROW_62_871 VGND VPWR sky130_fd_sc_hd__tapvpwrvgnd_1
XTAP_TAPCELL_ROW_34_573 VGND VPWR sky130_fd_sc_hd__tapvpwrvgnd_1
X_6717_ _6717_/A _6717_/B VGND VGND VPWR VPWR _6717_/X sky130_fd_sc_hd__or2_2
X_3929_ _3929_/A _3929_/B VGND VGND VPWR VPWR _3930_/B sky130_fd_sc_hd__nor2_2
X_6648_ _6141_/B _6819_/A2 _6636_/Y _6647_/Y VGND VGND VPWR VPWR _6648_/X sky130_fd_sc_hd__a31o_2
X_6579_ _6498_/A _6498_/B _6578_/X _6577_/X _6586_/A VGND VGND VPWR VPWR _6580_/B
+ sky130_fd_sc_hd__a32o_2
XFILLER_1_6 VGND VGND VPWR VPWR sky130_fd_sc_hd__decap_3
XFILLER_59_46 VGND VGND VPWR VPWR sky130_fd_sc_hd__decap_3
XFILLER_59_57 VGND VGND VPWR VPWR sky130_fd_sc_hd__decap_3
XFILLER_59_68 VGND VGND VPWR VPWR sky130_fd_sc_hd__decap_3
XFILLER_59_420 VGND VGND VPWR VPWR sky130_fd_sc_hd__decap_3
XFILLER_59_431 VGND VGND VPWR VPWR sky130_fd_sc_hd__decap_3
XFILLER_78_239 VGND VGND VPWR VPWR sky130_fd_sc_hd__decap_3
Xfanout230 _4767_/C VGND VGND VPWR VPWR _3685_/C sky130_fd_sc_hd__clkdlybuf4s25_1
Xfanout241 _5948_/A VGND VGND VPWR VPWR _4767_/D sky130_fd_sc_hd__buf_4
XFILLER_59_464 VGND VGND VPWR VPWR sky130_fd_sc_hd__decap_3
Xfanout252 _5286_/A VGND VGND VPWR VPWR _4767_/B sky130_fd_sc_hd__dlygate4sd1_1
Xfanout263 _6779_/A VGND VGND VPWR VPWR _5695_/C sky130_fd_sc_hd__buf_4
Xfanout274 _3870_/A2 VGND VGND VPWR VPWR _6313_/A sky130_fd_sc_hd__clkdlybuf4s25_1
XTAP_TAPCELL_ROW_6_276 VGND VPWR sky130_fd_sc_hd__tapvpwrvgnd_1
XFILLER_46_103 VGND VGND VPWR VPWR sky130_fd_sc_hd__decap_3
XFILLER_59_486 VGND VGND VPWR VPWR sky130_fd_sc_hd__decap_3
XFILLER_86_283 VGND VGND VPWR VPWR sky130_fd_sc_hd__decap_3
Xfanout285 _6314_/B VGND VGND VPWR VPWR _3869_/D sky130_fd_sc_hd__buf_6
Xfanout296 _6123_/B VGND VGND VPWR VPWR _5778_/C sky130_fd_sc_hd__buf_4
XFILLER_74_467 VGND VGND VPWR VPWR sky130_fd_sc_hd__fill_1
XFILLER_27_383 VGND VGND VPWR VPWR sky130_fd_sc_hd__decap_3
XFILLER_42_353 VGND VGND VPWR VPWR sky130_fd_sc_hd__decap_3
XFILLER_91_55 VGND VGND VPWR VPWR sky130_fd_sc_hd__fill_1
XFILLER_30_526 VGND VGND VPWR VPWR sky130_fd_sc_hd__decap_3
Xload_slew603 _4662_/A VGND VGND VPWR VPWR _4387_/B sky130_fd_sc_hd__buf_4
XFILLER_69_228 VGND VGND VPWR VPWR sky130_fd_sc_hd__decap_3
Xload_slew636 _3614_/A VGND VGND VPWR VPWR _3941_/A sky130_fd_sc_hd__clkbuf_4
XFILLER_84_209 VGND VGND VPWR VPWR sky130_fd_sc_hd__decap_3
XFILLER_1_20 VGND VGND VPWR VPWR sky130_fd_sc_hd__decap_3
XFILLER_77_272 VGND VGND VPWR VPWR sky130_fd_sc_hd__decap_3
XFILLER_92_220 VGND VGND VPWR VPWR sky130_fd_sc_hd__decap_3
XFILLER_1_97 VGND VGND VPWR VPWR sky130_fd_sc_hd__decap_3
XFILLER_52_106 VGND VGND VPWR VPWR sky130_fd_sc_hd__fill_1
XFILLER_65_467 VGND VGND VPWR VPWR sky130_fd_sc_hd__decap_3
XFILLER_80_404 VGND VGND VPWR VPWR sky130_fd_sc_hd__decap_3
XFILLER_92_253 VGND VGND VPWR VPWR sky130_fd_sc_hd__decap_3
X_5950_ _5950_/A _5950_/B VGND VGND VPWR VPWR _5951_/B sky130_fd_sc_hd__xnor2_2
XFILLER_52_117 VGND VGND VPWR VPWR sky130_fd_sc_hd__fill_2
XFILLER_80_459 VGND VGND VPWR VPWR sky130_fd_sc_hd__decap_3
X_4901_ _4900_/A _4900_/B _4900_/C VGND VGND VPWR VPWR _4902_/B sky130_fd_sc_hd__a21oi_2
X_5881_ _4903_/A _4904_/Y _5882_/A _5880_/X VGND VGND VPWR VPWR _5888_/A sky130_fd_sc_hd__a211oi_2
XFILLER_21_526 VGND VGND VPWR VPWR sky130_fd_sc_hd__fill_1
XFILLER_33_375 VGND VGND VPWR VPWR sky130_fd_sc_hd__fill_2
X_4832_ _4806_/A _4993_/A _4830_/X _4831_/Y VGND VGND VPWR VPWR _4834_/C sky130_fd_sc_hd__a211oi_2
XFILLER_21_559 VGND VGND VPWR VPWR sky130_fd_sc_hd__fill_1
X_4763_ _4702_/B _4709_/B _4700_/X VGND VGND VPWR VPWR _4775_/A sky130_fd_sc_hd__a21o_2
XTAP_TAPCELL_ROW_31_543 VGND VPWR sky130_fd_sc_hd__tapvpwrvgnd_1
X_6502_ _6426_/X _6433_/X _6569_/B VGND VGND VPWR VPWR _6502_/X sky130_fd_sc_hd__mux2_1
X_4694_ _4694_/A _5306_/A _4694_/C _4944_/D VGND VGND VPWR VPWR _4697_/A sky130_fd_sc_hd__and4_2
X_3714_ _3711_/X _3714_/B VGND VGND VPWR VPWR _3743_/B sky130_fd_sc_hd__and2b_2
X_6433_ _6214_/B _6110_/A _6435_/S VGND VGND VPWR VPWR _6433_/X sky130_fd_sc_hd__mux2_1
X_3645_ _4505_/B _4387_/B _4361_/C _4361_/D VGND VGND VPWR VPWR _3648_/A sky130_fd_sc_hd__nand4_2
X_6364_ _6897_/S _6390_/B VGND VGND VPWR VPWR _6770_/A sky130_fd_sc_hd__nand2_2
X_3576_ _3575_/A _3575_/B _3575_/C VGND VGND VPWR VPWR _3582_/B sky130_fd_sc_hd__a21o_2
XFILLER_0_419 VGND VGND VPWR VPWR sky130_fd_sc_hd__fill_1
XFILLER_88_526 VGND VGND VPWR VPWR sky130_fd_sc_hd__decap_3
X_6295_ _6369_/A _6767_/A VGND VGND VPWR VPWR _6830_/A sky130_fd_sc_hd__or2_2
X_5315_ _5315_/A _5346_/B _5315_/C VGND VGND VPWR VPWR _5338_/A sky130_fd_sc_hd__nand3_2
X_5246_ _5219_/Y _5827_/A1 _5244_/X _5245_/Y VGND VGND VPWR VPWR _5248_/B sky130_fd_sc_hd__o211ai_2
XFILLER_75_209 VGND VGND VPWR VPWR sky130_fd_sc_hd__decap_3
XPHY_EDGE_ROW_89_Right_89 VGND VGND VPWR VPWR sky130_fd_sc_hd__decap_3
XFILLER_28_114 VGND VGND VPWR VPWR sky130_fd_sc_hd__decap_3
XFILLER_68_261 VGND VGND VPWR VPWR sky130_fd_sc_hd__decap_3
X_5177_ _4988_/A _4988_/B _4989_/X VGND VGND VPWR VPWR _5178_/A sky130_fd_sc_hd__a21oi_2
XFILLER_83_231 VGND VGND VPWR VPWR sky130_fd_sc_hd__decap_3
X_4128_ _4122_/A _4122_/C _4122_/B VGND VGND VPWR VPWR _4129_/C sky130_fd_sc_hd__a21o_2
XTAP_TAPCELL_ROW_3_246 VGND VPWR sky130_fd_sc_hd__tapvpwrvgnd_1
XFILLER_71_415 VGND VGND VPWR VPWR sky130_fd_sc_hd__decap_3
XFILLER_83_264 VGND VGND VPWR VPWR sky130_fd_sc_hd__decap_3
X_4059_ _4059_/A _4059_/B VGND VGND VPWR VPWR _4060_/B sky130_fd_sc_hd__xnor2_2
XFILLER_12_504 VGND VGND VPWR VPWR sky130_fd_sc_hd__decap_3
XFILLER_51_172 VGND VGND VPWR VPWR sky130_fd_sc_hd__decap_3
XPHY_EDGE_ROW_98_Right_98 VGND VGND VPWR VPWR sky130_fd_sc_hd__decap_3
XFILLER_51_183 VGND VGND VPWR VPWR sky130_fd_sc_hd__decap_3
XFILLER_79_559 VGND VGND VPWR VPWR sky130_fd_sc_hd__fill_1
XFILLER_66_209 VGND VGND VPWR VPWR sky130_fd_sc_hd__decap_3
XFILLER_86_55 VGND VGND VPWR VPWR sky130_fd_sc_hd__fill_2
XFILLER_47_423 VGND VGND VPWR VPWR sky130_fd_sc_hd__decap_3
XFILLER_86_66 VGND VGND VPWR VPWR sky130_fd_sc_hd__decap_3
XFILLER_86_77 VGND VGND VPWR VPWR sky130_fd_sc_hd__decap_3
XFILLER_86_88 VGND VGND VPWR VPWR sky130_fd_sc_hd__decap_3
XFILLER_87_570 VGND VGND VPWR VPWR sky130_fd_sc_hd__fill_2
XFILLER_94_529 VGND VGND VPWR VPWR sky130_fd_sc_hd__decap_3
XFILLER_19_82 VGND VGND VPWR VPWR sky130_fd_sc_hd__decap_3
XFILLER_74_231 VGND VGND VPWR VPWR sky130_fd_sc_hd__decap_3
XFILLER_19_169 VGND VGND VPWR VPWR sky130_fd_sc_hd__decap_3
XFILLER_34_106 VGND VGND VPWR VPWR sky130_fd_sc_hd__fill_1
XFILLER_74_253 VGND VGND VPWR VPWR sky130_fd_sc_hd__decap_3
XFILLER_74_275 VGND VGND VPWR VPWR sky130_fd_sc_hd__decap_3
XFILLER_34_139 VGND VGND VPWR VPWR sky130_fd_sc_hd__fill_1
XFILLER_27_191 VGND VGND VPWR VPWR sky130_fd_sc_hd__decap_3
XTAP_TAPCELL_ROW_73_988 VGND VPWR sky130_fd_sc_hd__tapvpwrvgnd_1
XFILLER_15_364 VGND VGND VPWR VPWR sky130_fd_sc_hd__decap_3
XFILLER_35_92 VGND VGND VPWR VPWR sky130_fd_sc_hd__decap_3
XFILLER_42_161 VGND VGND VPWR VPWR sky130_fd_sc_hd__fill_2
XFILLER_89_7 VGND VGND VPWR VPWR sky130_fd_sc_hd__fill_1
XFILLER_7_585 VGND VGND VPWR VPWR sky130_fd_sc_hd__fill_1
Xwire494 _3969_/A VGND VGND VPWR VPWR _4362_/A sky130_fd_sc_hd__buf_6
XTAP_TAPCELL_ROW_77_1025 VGND VPWR sky130_fd_sc_hd__tapvpwrvgnd_1
XFILLER_32_3 VGND VGND VPWR VPWR sky130_fd_sc_hd__decap_3
Xload_slew422 _3665_/A2 VGND VGND VPWR VPWR _3933_/B sky130_fd_sc_hd__clkbuf_4
X_6080_ _6168_/A _6080_/B VGND VGND VPWR VPWR _6842_/A sky130_fd_sc_hd__nand2_2
X_5100_ _5100_/A _5100_/B VGND VGND VPWR VPWR _6839_/A sky130_fd_sc_hd__xnor2_2
Xload_slew455 _6958_/S0 VGND VGND VPWR VPWR _6410_/S sky130_fd_sc_hd__clkbuf_4
X_5031_ _5030_/A _5030_/C _5030_/B VGND VGND VPWR VPWR _5089_/B sky130_fd_sc_hd__o21a_2
Xload_slew488 _6110_/A VGND VGND VPWR VPWR _5636_/A sky130_fd_sc_hd__buf_4
XFILLER_65_231 VGND VGND VPWR VPWR sky130_fd_sc_hd__decap_3
XFILLER_25_106 VGND VGND VPWR VPWR sky130_fd_sc_hd__decap_3
XFILLER_53_415 VGND VGND VPWR VPWR sky130_fd_sc_hd__decap_3
XFILLER_65_242 VGND VGND VPWR VPWR sky130_fd_sc_hd__decap_3
XFILLER_65_275 VGND VGND VPWR VPWR sky130_fd_sc_hd__decap_3
XTAP_TAPCELL_ROW_88_1143 VGND VPWR sky130_fd_sc_hd__tapvpwrvgnd_1
XTAP_TAPCELL_ROW_0_216 VGND VPWR sky130_fd_sc_hd__tapvpwrvgnd_1
XTAP_TAPCELL_ROW_0_205 VGND VPWR sky130_fd_sc_hd__tapvpwrvgnd_1
XFILLER_93_584 VGND VGND VPWR VPWR sky130_fd_sc_hd__fill_1
XFILLER_93_551 VGND VGND VPWR VPWR sky130_fd_sc_hd__decap_3
XFILLER_80_212 VGND VGND VPWR VPWR sky130_fd_sc_hd__decap_3
X_6982_ _5941_/X _6982_/A2 _6969_/Y _6971_/X _6981_/X VGND VGND VPWR VPWR _6994_/C
+ sky130_fd_sc_hd__a311o_2
XFILLER_80_256 VGND VGND VPWR VPWR sky130_fd_sc_hd__decap_3
X_5933_ _6921_/A _5933_/B VGND VGND VPWR VPWR _5934_/C sky130_fd_sc_hd__or2_4
XFILLER_33_150 VGND VGND VPWR VPWR sky130_fd_sc_hd__decap_3
XFILLER_33_172 VGND VGND VPWR VPWR sky130_fd_sc_hd__decap_3
XFILLER_80_278 VGND VGND VPWR VPWR sky130_fd_sc_hd__decap_3
X_5864_ _5852_/Y _5857_/X _5862_/A _5862_/Y VGND VGND VPWR VPWR _5871_/B sky130_fd_sc_hd__o211a_4
X_4815_ _4816_/A _4816_/B _4816_/C VGND VGND VPWR VPWR _4815_/X sky130_fd_sc_hd__and3_2
XTAP_TAPCELL_ROW_16_381 VGND VPWR sky130_fd_sc_hd__tapvpwrvgnd_1
XFILLER_21_389 VGND VGND VPWR VPWR sky130_fd_sc_hd__decap_3
X_5795_ _5797_/A VGND VGND VPWR VPWR _6514_/A sky130_fd_sc_hd__inv_2
X_4746_ _4747_/A _4747_/B _4747_/C VGND VGND VPWR VPWR _4746_/X sky130_fd_sc_hd__and3_4
XTAP_TAPCELL_ROW_99_1261 VGND VPWR sky130_fd_sc_hd__tapvpwrvgnd_1
X_4677_ _4678_/A _4678_/B _4678_/C VGND VGND VPWR VPWR _4677_/Y sky130_fd_sc_hd__nor3_2
X_6416_ _6187_/B _6275_/B _4176_/A _3872_/A _6405_/S _3868_/B VGND VGND VPWR VPWR
+ _6417_/B sky130_fd_sc_hd__mux4_2
X_3628_ _3629_/A _3627_/Y _3628_/C _6014_/A VGND VGND VPWR VPWR _3661_/A sky130_fd_sc_hd__and4bb_2
X_6347_ _6063_/X _6058_/Y _6346_/X VGND VGND VPWR VPWR _6997_/S sky130_fd_sc_hd__o21ai_4
XTAP_TAPCELL_ROW_8_305 VGND VPWR sky130_fd_sc_hd__tapvpwrvgnd_1
XFILLER_88_312 VGND VGND VPWR VPWR sky130_fd_sc_hd__decap_3
X_3559_ _4362_/A _3977_/B _3909_/D _3900_/A VGND VGND VPWR VPWR _3560_/B sky130_fd_sc_hd__a22oi_2
XFILLER_0_249 VGND VGND VPWR VPWR sky130_fd_sc_hd__decap_3
XFILLER_88_356 VGND VGND VPWR VPWR sky130_fd_sc_hd__decap_3
X_6278_ _6278_/A _6278_/B VGND VGND VPWR VPWR _6278_/Y sky130_fd_sc_hd__nor2_2
XFILLER_76_518 VGND VGND VPWR VPWR sky130_fd_sc_hd__decap_3
X_5229_ _5231_/A _5231_/B VGND VGND VPWR VPWR _5229_/X sky130_fd_sc_hd__and2b_2
XFILLER_56_36 VGND VGND VPWR VPWR sky130_fd_sc_hd__decap_3
XFILLER_29_467 VGND VGND VPWR VPWR sky130_fd_sc_hd__fill_1
XFILLER_56_242 VGND VGND VPWR VPWR sky130_fd_sc_hd__decap_3
XFILLER_56_253 VGND VGND VPWR VPWR sky130_fd_sc_hd__decap_3
XFILLER_16_106 VGND VGND VPWR VPWR sky130_fd_sc_hd__decap_3
XFILLER_71_201 VGND VGND VPWR VPWR sky130_fd_sc_hd__decap_3
XFILLER_71_234 VGND VGND VPWR VPWR sky130_fd_sc_hd__decap_3
XFILLER_71_267 VGND VGND VPWR VPWR sky130_fd_sc_hd__decap_3
XFILLER_72_35 VGND VGND VPWR VPWR sky130_fd_sc_hd__decap_3
XTAP_TAPCELL_ROW_70_947 VGND VPWR sky130_fd_sc_hd__tapvpwrvgnd_1
XFILLER_4_533 VGND VGND VPWR VPWR sky130_fd_sc_hd__decap_3
XFILLER_79_323 VGND VGND VPWR VPWR sky130_fd_sc_hd__decap_3
XFILLER_97_54 VGND VGND VPWR VPWR sky130_fd_sc_hd__fill_2
XFILLER_79_367 VGND VGND VPWR VPWR sky130_fd_sc_hd__decap_3
XFILLER_97_98 VGND VGND VPWR VPWR sky130_fd_sc_hd__fill_2
XFILLER_94_315 VGND VGND VPWR VPWR sky130_fd_sc_hd__decap_3
XFILLER_75_540 VGND VGND VPWR VPWR sky130_fd_sc_hd__decap_3
XFILLER_94_337 VGND VGND VPWR VPWR sky130_fd_sc_hd__decap_3
XFILLER_75_573 VGND VGND VPWR VPWR sky130_fd_sc_hd__decap_3
XFILLER_62_212 VGND VGND VPWR VPWR sky130_fd_sc_hd__decap_3
XFILLER_75_584 VGND VGND VPWR VPWR sky130_fd_sc_hd__decap_3
XFILLER_62_245 VGND VGND VPWR VPWR sky130_fd_sc_hd__decap_3
XFILLER_62_256 VGND VGND VPWR VPWR sky130_fd_sc_hd__decap_3
XFILLER_15_161 VGND VGND VPWR VPWR sky130_fd_sc_hd__decap_3
XFILLER_15_172 VGND VGND VPWR VPWR sky130_fd_sc_hd__fill_2
XFILLER_15_194 VGND VGND VPWR VPWR sky130_fd_sc_hd__fill_1
XTAP_TAPCELL_ROW_83_1084 VGND VPWR sky130_fd_sc_hd__tapvpwrvgnd_1
X_4600_ _4600_/A _4600_/B VGND VGND VPWR VPWR _4836_/B sky130_fd_sc_hd__nor2_2
XTAP_TAPCELL_ROW_13_351 VGND VPWR sky130_fd_sc_hd__tapvpwrvgnd_1
XFILLER_30_197 VGND VGND VPWR VPWR sky130_fd_sc_hd__decap_3
X_5580_ _5599_/A _5581_/C VGND VGND VPWR VPWR _5621_/B sky130_fd_sc_hd__nand2b_2
XFILLER_7_63 VGND VGND VPWR VPWR sky130_fd_sc_hd__decap_3
X_4531_ _4529_/A _4859_/A _4530_/Y _4516_/X VGND VGND VPWR VPWR _4531_/Y sky130_fd_sc_hd__a211oi_2
X_4462_ _4835_/A _4835_/B VGND VGND VPWR VPWR _4464_/C sky130_fd_sc_hd__nand2b_2
X_6201_ _6348_/A _6999_/B VGND VGND VPWR VPWR _6201_/Y sky130_fd_sc_hd__nor2_2
X_4393_ _4393_/A _4393_/B VGND VGND VPWR VPWR _4493_/A sky130_fd_sc_hd__xnor2_2
X_6132_ _6217_/B _6216_/B VGND VGND VPWR VPWR _6550_/A sky130_fd_sc_hd__or2_2
XFILLER_85_326 VGND VGND VPWR VPWR sky130_fd_sc_hd__decap_3
X_6063_ _5941_/X _4322_/X _6057_/Y _6841_/A VGND VGND VPWR VPWR _6063_/X sky130_fd_sc_hd__a31o_4
XFILLER_38_220 VGND VGND VPWR VPWR sky130_fd_sc_hd__decap_3
XFILLER_85_337 VGND VGND VPWR VPWR sky130_fd_sc_hd__decap_3
X_5014_ _5014_/A _5014_/B VGND VGND VPWR VPWR _5102_/A sky130_fd_sc_hd__or2_2
XFILLER_26_404 VGND VGND VPWR VPWR sky130_fd_sc_hd__decap_3
XFILLER_38_253 VGND VGND VPWR VPWR sky130_fd_sc_hd__decap_3
XFILLER_66_562 VGND VGND VPWR VPWR sky130_fd_sc_hd__decap_3
XFILLER_26_39 VGND VGND VPWR VPWR sky130_fd_sc_hd__fill_1
XFILLER_53_201 VGND VGND VPWR VPWR sky130_fd_sc_hd__decap_3
XFILLER_93_370 VGND VGND VPWR VPWR sky130_fd_sc_hd__decap_3
XFILLER_93_381 VGND VGND VPWR VPWR sky130_fd_sc_hd__decap_3
X_6965_ _6965_/A _6965_/B _6965_/C VGND VGND VPWR VPWR _6965_/X sky130_fd_sc_hd__and3_2
XFILLER_41_407 VGND VGND VPWR VPWR sky130_fd_sc_hd__decap_3
XFILLER_53_267 VGND VGND VPWR VPWR sky130_fd_sc_hd__decap_3
X_5916_ _5916_/A _5916_/B _5911_/B VGND VGND VPWR VPWR _5916_/X sky130_fd_sc_hd__or3b_2
X_6896_ _6896_/A _6896_/B VGND VGND VPWR VPWR _6896_/X sky130_fd_sc_hd__or2_2
XFILLER_42_38 VGND VGND VPWR VPWR sky130_fd_sc_hd__fill_1
X_5847_ _5846_/B _5846_/C _5846_/A VGND VGND VPWR VPWR _5848_/C sky130_fd_sc_hd__a21oi_2
XFILLER_21_164 VGND VGND VPWR VPWR sky130_fd_sc_hd__decap_3
X_5778_ _5778_/A _5778_/B _5778_/C _6125_/B VGND VGND VPWR VPWR _5790_/A sky130_fd_sc_hd__and4_2
X_4729_ _4728_/B _4728_/C _4728_/A VGND VGND VPWR VPWR _4730_/B sky130_fd_sc_hd__a21oi_2
XFILLER_88_120 VGND VGND VPWR VPWR sky130_fd_sc_hd__fill_1
XFILLER_76_315 VGND VGND VPWR VPWR sky130_fd_sc_hd__decap_3
XFILLER_88_153 VGND VGND VPWR VPWR sky130_fd_sc_hd__decap_3
XFILLER_67_79 VGND VGND VPWR VPWR sky130_fd_sc_hd__decap_3
XFILLER_88_186 VGND VGND VPWR VPWR sky130_fd_sc_hd__decap_3
XFILLER_88_197 VGND VGND VPWR VPWR sky130_fd_sc_hd__decap_3
XFILLER_91_318 VGND VGND VPWR VPWR sky130_fd_sc_hd__decap_3
XTAP_TAPCELL_ROW_47_708 VGND VPWR sky130_fd_sc_hd__tapvpwrvgnd_1
XFILLER_16_61 VGND VGND VPWR VPWR sky130_fd_sc_hd__decap_3
XFILLER_32_418 VGND VGND VPWR VPWR sky130_fd_sc_hd__fill_2
XFILLER_83_89 VGND VGND VPWR VPWR sky130_fd_sc_hd__decap_3
XTAP_TAPCELL_ROW_55_796 VGND VPWR sky130_fd_sc_hd__tapvpwrvgnd_1
XTAP_TAPCELL_ROW_27_498 VGND VPWR sky130_fd_sc_hd__tapvpwrvgnd_1
XFILLER_12_153 VGND VGND VPWR VPWR sky130_fd_sc_hd__decap_3
XTAP_TAPCELL_ROW_10_321 VGND VPWR sky130_fd_sc_hd__tapvpwrvgnd_1
XFILLER_79_175 VGND VGND VPWR VPWR sky130_fd_sc_hd__fill_1
XFILLER_94_101 VGND VGND VPWR VPWR sky130_fd_sc_hd__decap_3
XFILLER_67_326 VGND VGND VPWR VPWR sky130_fd_sc_hd__decap_3
XFILLER_82_318 VGND VGND VPWR VPWR sky130_fd_sc_hd__decap_3
XFILLER_35_212 VGND VGND VPWR VPWR sky130_fd_sc_hd__decap_3
XFILLER_63_510 VGND VGND VPWR VPWR sky130_fd_sc_hd__decap_3
XTAP_TAPCELL_ROW_85_1113 VGND VPWR sky130_fd_sc_hd__tapvpwrvgnd_1
XTAP_TAPCELL_ROW_18_410 VGND VPWR sky130_fd_sc_hd__tapvpwrvgnd_1
XFILLER_94_189 VGND VGND VPWR VPWR sky130_fd_sc_hd__decap_3
XFILLER_35_256 VGND VGND VPWR VPWR sky130_fd_sc_hd__decap_3
XFILLER_63_554 VGND VGND VPWR VPWR sky130_fd_sc_hd__decap_3
XFILLER_90_340 VGND VGND VPWR VPWR sky130_fd_sc_hd__decap_3
XFILLER_23_418 VGND VGND VPWR VPWR sky130_fd_sc_hd__decap_3
XFILLER_50_215 VGND VGND VPWR VPWR sky130_fd_sc_hd__decap_3
XFILLER_90_362 VGND VGND VPWR VPWR sky130_fd_sc_hd__fill_2
X_6750_ _6255_/A _6810_/B1 _6749_/X VGND VGND VPWR VPWR _6750_/Y sky130_fd_sc_hd__o21ai_2
XFILLER_16_470 VGND VGND VPWR VPWR sky130_fd_sc_hd__decap_3
XFILLER_16_492 VGND VGND VPWR VPWR sky130_fd_sc_hd__decap_3
XFILLER_50_248 VGND VGND VPWR VPWR sky130_fd_sc_hd__decap_3
X_5701_ _5701_/A _5727_/B VGND VGND VPWR VPWR _5703_/B sky130_fd_sc_hd__nand2_2
X_3962_ _5993_/B _3961_/C _3961_/D _6008_/B VGND VGND VPWR VPWR _3963_/B sky130_fd_sc_hd__a22oi_2
XFILLER_31_440 VGND VGND VPWR VPWR sky130_fd_sc_hd__decap_3
XFILLER_50_259 VGND VGND VPWR VPWR sky130_fd_sc_hd__decap_3
X_6681_ _6144_/A _6781_/A2 _6391_/Y _6680_/C _6679_/X VGND VGND VPWR VPWR _6681_/X
+ sky130_fd_sc_hd__o221a_2
X_3893_ _3991_/B _3961_/C _3961_/D _5993_/B VGND VGND VPWR VPWR _3894_/B sky130_fd_sc_hd__a22oi_2
X_5632_ _5632_/A _5632_/B _5632_/C VGND VGND VPWR VPWR _5672_/A sky130_fd_sc_hd__or3_4
X_5563_ _5511_/X _5512_/Y _5514_/A VGND VGND VPWR VPWR _5563_/Y sky130_fd_sc_hd__a21oi_4
X_4514_ _4844_/A _4513_/B _4510_/X VGND VGND VPWR VPWR _4516_/B sky130_fd_sc_hd__a21o_2
XTAP_TAPCELL_ROW_96_1220 VGND VPWR sky130_fd_sc_hd__tapvpwrvgnd_1
X_5494_ _5659_/A _6789_/A1 _5493_/B _5490_/X VGND VGND VPWR VPWR _5498_/A sky130_fd_sc_hd__a31oi_2
X_4445_ _4445_/A _4445_/B VGND VGND VPWR VPWR _4448_/B sky130_fd_sc_hd__nor2_2
Xfanout604 _5981_/D VGND VGND VPWR VPWR _6639_/A0 sky130_fd_sc_hd__clkdlybuf4s25_1
Xfanout615 _4900_/A VGND VGND VPWR VPWR _6263_/B sky130_fd_sc_hd__clkbuf_2
X_4376_ _4350_/X _4352_/Y _4370_/Y _4473_/A VGND VGND VPWR VPWR _4378_/B sky130_fd_sc_hd__o211a_4
XFILLER_58_315 VGND VGND VPWR VPWR sky130_fd_sc_hd__decap_3
Xfanout637 _4925_/A VGND VGND VPWR VPWR _5300_/B sky130_fd_sc_hd__buf_6
Xfanout648 _4989_/A VGND VGND VPWR VPWR _6254_/B sky130_fd_sc_hd__clkbuf_2
X_6115_ _6232_/B _6116_/B VGND VGND VPWR VPWR _6115_/Y sky130_fd_sc_hd__nor2_2
XFILLER_58_348 VGND VGND VPWR VPWR sky130_fd_sc_hd__decap_3
XFILLER_100_467 VGND VGND VPWR VPWR sky130_fd_sc_hd__decap_3
XFILLER_85_145 VGND VGND VPWR VPWR sky130_fd_sc_hd__decap_3
X_6046_ _6046_/A _6046_/B VGND VGND VPWR VPWR _6047_/B sky130_fd_sc_hd__xnor2_2
XFILLER_100_489 VGND VGND VPWR VPWR sky130_fd_sc_hd__decap_3
XFILLER_39_595 VGND VGND VPWR VPWR sky130_fd_sc_hd__decap_3
XFILLER_73_318 VGND VGND VPWR VPWR sky130_fd_sc_hd__decap_3
XFILLER_85_178 VGND VGND VPWR VPWR sky130_fd_sc_hd__decap_3
XFILLER_26_223 VGND VGND VPWR VPWR sky130_fd_sc_hd__decap_3
XFILLER_54_554 VGND VGND VPWR VPWR sky130_fd_sc_hd__fill_1
XFILLER_66_392 VGND VGND VPWR VPWR sky130_fd_sc_hd__decap_3
XFILLER_81_340 VGND VGND VPWR VPWR sky130_fd_sc_hd__decap_3
XFILLER_41_215 VGND VGND VPWR VPWR sky130_fd_sc_hd__fill_2
XFILLER_54_565 VGND VGND VPWR VPWR sky130_fd_sc_hd__decap_3
XFILLER_54_587 VGND VGND VPWR VPWR sky130_fd_sc_hd__fill_1
XFILLER_41_248 VGND VGND VPWR VPWR sky130_fd_sc_hd__fill_2
XFILLER_53_48 VGND VGND VPWR VPWR sky130_fd_sc_hd__decap_3
X_6948_ _6284_/X _6947_/Y _6935_/X _6982_/A2 VGND VGND VPWR VPWR _6949_/B sky130_fd_sc_hd__a2bb2o_4
X_6879_ _6192_/A _6891_/B1 _6978_/B1 _6879_/B2 _6878_/Y VGND VGND VPWR VPWR _6879_/X
+ sky130_fd_sc_hd__o221a_2
XTAP_TAPCELL_ROW_52_766 VGND VPWR sky130_fd_sc_hd__tapvpwrvgnd_1
XTAP_TAPCELL_ROW_24_468 VGND VPWR sky130_fd_sc_hd__tapvpwrvgnd_1
XFILLER_5_105 VGND VGND VPWR VPWR sky130_fd_sc_hd__decap_3
XFILLER_78_12 VGND VGND VPWR VPWR sky130_fd_sc_hd__decap_3
XFILLER_1_333 VGND VGND VPWR VPWR sky130_fd_sc_hd__decap_3
XFILLER_78_67 VGND VGND VPWR VPWR sky130_fd_sc_hd__decap_3
XFILLER_89_462 VGND VGND VPWR VPWR sky130_fd_sc_hd__decap_3
XFILLER_49_326 VGND VGND VPWR VPWR sky130_fd_sc_hd__decap_3
XFILLER_49_337 VGND VGND VPWR VPWR sky130_fd_sc_hd__decap_3
XFILLER_76_112 VGND VGND VPWR VPWR sky130_fd_sc_hd__decap_3
XFILLER_76_156 VGND VGND VPWR VPWR sky130_fd_sc_hd__decap_3
XFILLER_64_318 VGND VGND VPWR VPWR sky130_fd_sc_hd__decap_3
XFILLER_17_223 VGND VGND VPWR VPWR sky130_fd_sc_hd__fill_1
XFILLER_27_60 VGND VGND VPWR VPWR sky130_fd_sc_hd__decap_3
XFILLER_45_532 VGND VGND VPWR VPWR sky130_fd_sc_hd__decap_3
XFILLER_91_148 VGND VGND VPWR VPWR sky130_fd_sc_hd__fill_2
XFILLER_94_88 VGND VGND VPWR VPWR sky130_fd_sc_hd__fill_1
XFILLER_17_256 VGND VGND VPWR VPWR sky130_fd_sc_hd__decap_3
XFILLER_17_278 VGND VGND VPWR VPWR sky130_fd_sc_hd__fill_2
XFILLER_27_82 VGND VGND VPWR VPWR sky130_fd_sc_hd__decap_3
XFILLER_27_93 VGND VGND VPWR VPWR sky130_fd_sc_hd__fill_1
XFILLER_32_204 VGND VGND VPWR VPWR sky130_fd_sc_hd__decap_3
XFILLER_60_502 VGND VGND VPWR VPWR sky130_fd_sc_hd__decap_3
XFILLER_32_237 VGND VGND VPWR VPWR sky130_fd_sc_hd__decap_3
XTAP_TAPCELL_ROW_80_1054 VGND VPWR sky130_fd_sc_hd__tapvpwrvgnd_1
XFILLER_9_444 VGND VGND VPWR VPWR sky130_fd_sc_hd__decap_3
XFILLER_40_292 VGND VGND VPWR VPWR sky130_fd_sc_hd__decap_3
XFILLER_64_6 VGND VGND VPWR VPWR sky130_fd_sc_hd__decap_3
X_4230_ _4129_/A _4129_/C _4129_/B VGND VGND VPWR VPWR _4246_/B sky130_fd_sc_hd__a21o_2
XFILLER_99_259 VGND VGND VPWR VPWR sky130_fd_sc_hd__decap_3
XFILLER_4_75 VGND VGND VPWR VPWR sky130_fd_sc_hd__decap_3
X_4161_ _4406_/B _4518_/B _4160_/B _4157_/X VGND VGND VPWR VPWR _4163_/B sky130_fd_sc_hd__a31o_2
XTAP_TAPCELL_ROW_91_1172 VGND VPWR sky130_fd_sc_hd__tapvpwrvgnd_1
XFILLER_95_432 VGND VGND VPWR VPWR sky130_fd_sc_hd__decap_3
XFILLER_67_145 VGND VGND VPWR VPWR sky130_fd_sc_hd__decap_3
XFILLER_67_167 VGND VGND VPWR VPWR sky130_fd_sc_hd__fill_1
X_4092_ _3583_/A _3582_/B _3582_/C VGND VGND VPWR VPWR _4094_/C sky130_fd_sc_hd__a21o_2
XFILLER_95_476 VGND VGND VPWR VPWR sky130_fd_sc_hd__fill_1
XFILLER_36_510 VGND VGND VPWR VPWR sky130_fd_sc_hd__decap_3
XFILLER_48_370 VGND VGND VPWR VPWR sky130_fd_sc_hd__decap_3
XFILLER_67_178 VGND VGND VPWR VPWR sky130_fd_sc_hd__decap_3
XFILLER_82_104 VGND VGND VPWR VPWR sky130_fd_sc_hd__fill_1
XFILLER_95_498 VGND VGND VPWR VPWR sky130_fd_sc_hd__decap_3
XFILLER_63_340 VGND VGND VPWR VPWR sky130_fd_sc_hd__decap_3
XFILLER_51_502 VGND VGND VPWR VPWR sky130_fd_sc_hd__fill_2
XFILLER_63_373 VGND VGND VPWR VPWR sky130_fd_sc_hd__decap_3
X_6802_ _6363_/Y _6495_/X _6498_/C _6365_/Y VGND VGND VPWR VPWR _6803_/C sky130_fd_sc_hd__a22o_2
XFILLER_51_546 VGND VGND VPWR VPWR sky130_fd_sc_hd__decap_3
X_4994_ _4994_/A VGND VGND VPWR VPWR _4994_/Y sky130_fd_sc_hd__inv_2
X_6733_ _6151_/Y _6717_/B _6810_/B1 _6727_/A _6732_/X VGND VGND VPWR VPWR _6735_/A
+ sky130_fd_sc_hd__o221a_2
X_3945_ _3945_/A _3945_/B VGND VGND VPWR VPWR _3946_/B sky130_fd_sc_hd__xor2_2
X_6664_ _6378_/A _6378_/B _6810_/B1 _6663_/X VGND VGND VPWR VPWR _6664_/X sky130_fd_sc_hd__o31a_2
X_5615_ _5567_/X _5571_/Y _5611_/Y _5613_/X VGND VGND VPWR VPWR _5652_/A sky130_fd_sc_hd__a211o_2
X_3876_ _3876_/A _3876_/B VGND VGND VPWR VPWR _3877_/B sky130_fd_sc_hd__nor2_2
XTAP_TAPCELL_ROW_21_438 VGND VPWR sky130_fd_sc_hd__tapvpwrvgnd_1
X_6595_ _6853_/A _6584_/Y _6594_/X VGND VGND VPWR VPWR _6595_/Y sky130_fd_sc_hd__o21ai_2
X_5546_ _5579_/A _5546_/B VGND VGND VPWR VPWR _5577_/B sky130_fd_sc_hd__nor2_2
X_5477_ _5477_/A _5576_/D VGND VGND VPWR VPWR _5548_/A sky130_fd_sc_hd__nand2_2
X_4428_ _4428_/A _4428_/B _4428_/C VGND VGND VPWR VPWR _4536_/A sky130_fd_sc_hd__and3_2
Xfanout412 input38/X VGND VGND VPWR VPWR _6148_/B sky130_fd_sc_hd__clkdlybuf4s25_1
Xfanout423 input37/X VGND VGND VPWR VPWR _6019_/A sky130_fd_sc_hd__buf_6
XFILLER_86_410 VGND VGND VPWR VPWR sky130_fd_sc_hd__decap_3
XFILLER_86_421 VGND VGND VPWR VPWR sky130_fd_sc_hd__decap_3
Xfanout456 input33/X VGND VGND VPWR VPWR _6492_/S0 sky130_fd_sc_hd__buf_4
X_4359_ wire482/X _4362_/B _4241_/A _4240_/D VGND VGND VPWR VPWR _4360_/C sky130_fd_sc_hd__a22o_2
XFILLER_100_242 VGND VGND VPWR VPWR sky130_fd_sc_hd__decap_3
XFILLER_100_253 VGND VGND VPWR VPWR sky130_fd_sc_hd__decap_3
XFILLER_58_134 VGND VGND VPWR VPWR sky130_fd_sc_hd__decap_3
Xfanout489 wire496/A VGND VGND VPWR VPWR fanout489/X sky130_fd_sc_hd__buf_6
XFILLER_58_178 VGND VGND VPWR VPWR sky130_fd_sc_hd__decap_3
X_6029_ _6025_/B _6029_/A2 _3926_/B _3924_/Y VGND VGND VPWR VPWR _6030_/B sky130_fd_sc_hd__a31o_2
XTAP_TAPCELL_ROW_57_814 VGND VPWR sky130_fd_sc_hd__tapvpwrvgnd_1
XFILLER_27_521 VGND VGND VPWR VPWR sky130_fd_sc_hd__decap_3
XFILLER_73_137 VGND VGND VPWR VPWR sky130_fd_sc_hd__decap_3
XFILLER_73_159 VGND VGND VPWR VPWR sky130_fd_sc_hd__decap_3
XFILLER_54_373 VGND VGND VPWR VPWR sky130_fd_sc_hd__decap_3
XFILLER_64_47 VGND VGND VPWR VPWR sky130_fd_sc_hd__decap_3
XFILLER_42_546 VGND VGND VPWR VPWR sky130_fd_sc_hd__decap_3
XFILLER_81_181 VGND VGND VPWR VPWR sky130_fd_sc_hd__decap_3
XFILLER_10_421 VGND VGND VPWR VPWR sky130_fd_sc_hd__decap_3
XFILLER_22_281 VGND VGND VPWR VPWR sky130_fd_sc_hd__decap_3
XFILLER_13_73 VGND VGND VPWR VPWR sky130_fd_sc_hd__decap_3
XFILLER_1_130 VGND VGND VPWR VPWR sky130_fd_sc_hd__decap_3
XFILLER_1_141 VGND VGND VPWR VPWR sky130_fd_sc_hd__fill_1
XFILLER_89_281 VGND VGND VPWR VPWR sky130_fd_sc_hd__decap_3
XFILLER_49_145 VGND VGND VPWR VPWR sky130_fd_sc_hd__decap_3
XFILLER_37_307 VGND VGND VPWR VPWR sky130_fd_sc_hd__decap_3
XFILLER_49_178 VGND VGND VPWR VPWR sky130_fd_sc_hd__decap_3
XFILLER_18_521 VGND VGND VPWR VPWR sky130_fd_sc_hd__decap_3
XFILLER_92_446 VGND VGND VPWR VPWR sky130_fd_sc_hd__decap_3
XFILLER_60_321 VGND VGND VPWR VPWR sky130_fd_sc_hd__decap_3
XFILLER_33_579 VGND VGND VPWR VPWR sky130_fd_sc_hd__decap_3
XFILLER_54_91 VGND VGND VPWR VPWR sky130_fd_sc_hd__decap_3
XFILLER_60_365 VGND VGND VPWR VPWR sky130_fd_sc_hd__decap_3
XFILLER_20_229 VGND VGND VPWR VPWR sky130_fd_sc_hd__decap_3
XFILLER_60_387 VGND VGND VPWR VPWR sky130_fd_sc_hd__decap_3
X_3730_ _3730_/A _3730_/B _3730_/C VGND VGND VPWR VPWR _3887_/B sky130_fd_sc_hd__and3_2
XFILLER_13_281 VGND VGND VPWR VPWR sky130_fd_sc_hd__decap_3
XFILLER_9_252 VGND VGND VPWR VPWR sky130_fd_sc_hd__decap_3
X_3661_ _3661_/A _3661_/B VGND VGND VPWR VPWR _3661_/Y sky130_fd_sc_hd__nor2_2
XFILLER_9_274 VGND VGND VPWR VPWR sky130_fd_sc_hd__decap_3
XFILLER_62_3 VGND VGND VPWR VPWR sky130_fd_sc_hd__decap_3
X_6380_ _6583_/A _6506_/A _6441_/A _6727_/A VGND VGND VPWR VPWR _6382_/A sky130_fd_sc_hd__and4_2
X_5400_ _5630_/A _5398_/C _5490_/D _5659_/A VGND VGND VPWR VPWR _5401_/B sky130_fd_sc_hd__a22o_2
X_3592_ _3626_/A _6024_/A VGND VGND VPWR VPWR _3597_/A sky130_fd_sc_hd__nand2_2
XFILLER_9_296 VGND VGND VPWR VPWR sky130_fd_sc_hd__decap_3
X_5331_ _5331_/A _6133_/A _5331_/C VGND VGND VPWR VPWR _5381_/A sky130_fd_sc_hd__or3_2
X_5262_ _5262_/A _5262_/B VGND VGND VPWR VPWR _6806_/A sky130_fd_sc_hd__xor2_2
XFILLER_68_421 VGND VGND VPWR VPWR sky130_fd_sc_hd__decap_3
X_5193_ _5117_/A _5117_/C _5117_/B VGND VGND VPWR VPWR _5194_/C sky130_fd_sc_hd__a21o_2
X_4213_ _4214_/A _4212_/Y _4592_/A _4457_/D VGND VGND VPWR VPWR _4333_/A sky130_fd_sc_hd__and4bb_2
XFILLER_68_443 VGND VGND VPWR VPWR sky130_fd_sc_hd__fill_1
X_4144_ _3747_/X _3761_/Y _4155_/A _3760_/A VGND VGND VPWR VPWR _4144_/X sky130_fd_sc_hd__o211a_2
XFILLER_95_240 VGND VGND VPWR VPWR sky130_fd_sc_hd__decap_3
XFILLER_18_29 VGND VGND VPWR VPWR sky130_fd_sc_hd__decap_3
XFILLER_28_318 VGND VGND VPWR VPWR sky130_fd_sc_hd__decap_3
XFILLER_83_424 VGND VGND VPWR VPWR sky130_fd_sc_hd__decap_3
XFILLER_55_126 VGND VGND VPWR VPWR sky130_fd_sc_hd__decap_3
XFILLER_55_148 VGND VGND VPWR VPWR sky130_fd_sc_hd__decap_3
XFILLER_83_446 VGND VGND VPWR VPWR sky130_fd_sc_hd__fill_2
X_4075_ _4075_/A _4075_/B _4075_/C VGND VGND VPWR VPWR _4075_/X sky130_fd_sc_hd__and3_2
XFILLER_36_373 VGND VGND VPWR VPWR sky130_fd_sc_hd__decap_3
XFILLER_51_332 VGND VGND VPWR VPWR sky130_fd_sc_hd__decap_3
XFILLER_51_354 VGND VGND VPWR VPWR sky130_fd_sc_hd__decap_3
X_6716_ _6392_/A _6657_/B _6715_/Y _6714_/Y _6392_/Y VGND VGND VPWR VPWR _6716_/X
+ sky130_fd_sc_hd__a32o_2
X_4977_ _4977_/A _4977_/B VGND VGND VPWR VPWR _4988_/A sky130_fd_sc_hd__xnor2_2
XTAP_TAPCELL_ROW_62_872 VGND VPWR sky130_fd_sc_hd__tapvpwrvgnd_1
XTAP_TAPCELL_ROW_34_574 VGND VPWR sky130_fd_sc_hd__tapvpwrvgnd_1
Xwire109 _6163_/Y VGND VGND VPWR VPWR wire109/X sky130_fd_sc_hd__clkdlybuf4s25_1
X_3928_ _3928_/A _3928_/B VGND VGND VPWR VPWR _3929_/B sky130_fd_sc_hd__nor2_2
X_6647_ _6647_/A _6647_/B VGND VGND VPWR VPWR _6647_/Y sky130_fd_sc_hd__nand2_2
X_3859_ _3859_/A _3859_/B VGND VGND VPWR VPWR _3861_/C sky130_fd_sc_hd__xor2_2
X_6578_ _6625_/A _6569_/X _6568_/X VGND VGND VPWR VPWR _6578_/X sky130_fd_sc_hd__a21o_2
XFILLER_3_417 VGND VGND VPWR VPWR sky130_fd_sc_hd__decap_3
X_5529_ _5529_/A _6498_/A VGND VGND VPWR VPWR _5529_/Y sky130_fd_sc_hd__nand2_2
XFILLER_78_218 VGND VGND VPWR VPWR sky130_fd_sc_hd__decap_3
Xfanout220 _4659_/B VGND VGND VPWR VPWR _3712_/B sky130_fd_sc_hd__clkdlybuf4s25_1
Xfanout242 input61/X VGND VGND VPWR VPWR _5948_/A sky130_fd_sc_hd__buf_6
Xfanout264 _6945_/B1 VGND VGND VPWR VPWR _6118_/B sky130_fd_sc_hd__clkdlybuf4s25_1
XTAP_TAPCELL_ROW_6_277 VGND VPWR sky130_fd_sc_hd__tapvpwrvgnd_1
XFILLER_19_318 VGND VGND VPWR VPWR sky130_fd_sc_hd__decap_3
XFILLER_74_413 VGND VGND VPWR VPWR sky130_fd_sc_hd__decap_3
XFILLER_86_262 VGND VGND VPWR VPWR sky130_fd_sc_hd__decap_3
Xfanout275 input59/X VGND VGND VPWR VPWR _3870_/A2 sky130_fd_sc_hd__clkbuf_2
Xfanout286 fanout291/X VGND VGND VPWR VPWR _6314_/B sky130_fd_sc_hd__clkbuf_4
Xfanout297 wire299/A VGND VGND VPWR VPWR _6123_/B sky130_fd_sc_hd__buf_4
XFILLER_86_295 VGND VGND VPWR VPWR sky130_fd_sc_hd__decap_3
XFILLER_27_340 VGND VGND VPWR VPWR sky130_fd_sc_hd__decap_3
XFILLER_15_524 VGND VGND VPWR VPWR sky130_fd_sc_hd__decap_3
XFILLER_15_535 VGND VGND VPWR VPWR sky130_fd_sc_hd__decap_3
XFILLER_54_181 VGND VGND VPWR VPWR sky130_fd_sc_hd__decap_3
XFILLER_82_490 VGND VGND VPWR VPWR sky130_fd_sc_hd__decap_3
XFILLER_15_579 VGND VGND VPWR VPWR sky130_fd_sc_hd__fill_1
XFILLER_42_332 VGND VGND VPWR VPWR sky130_fd_sc_hd__decap_3
XFILLER_91_34 VGND VGND VPWR VPWR sky130_fd_sc_hd__fill_1
XFILLER_30_505 VGND VGND VPWR VPWR sky130_fd_sc_hd__decap_3
XFILLER_24_83 VGND VGND VPWR VPWR sky130_fd_sc_hd__fill_1
XFILLER_10_251 VGND VGND VPWR VPWR sky130_fd_sc_hd__fill_1
XFILLER_6_200 VGND VGND VPWR VPWR sky130_fd_sc_hd__decap_3
XFILLER_10_284 VGND VGND VPWR VPWR sky130_fd_sc_hd__fill_2
XFILLER_69_218 VGND VGND VPWR VPWR sky130_fd_sc_hd__decap_3
Xload_slew626 _4826_/A VGND VGND VPWR VPWR _4822_/A sky130_fd_sc_hd__buf_4
XFILLER_97_538 VGND VGND VPWR VPWR sky130_fd_sc_hd__fill_2
XFILLER_49_80 VGND VGND VPWR VPWR sky130_fd_sc_hd__decap_3
XFILLER_65_402 VGND VGND VPWR VPWR sky130_fd_sc_hd__decap_3
XFILLER_77_251 VGND VGND VPWR VPWR sky130_fd_sc_hd__decap_3
XFILLER_77_284 VGND VGND VPWR VPWR sky130_fd_sc_hd__decap_3
XFILLER_92_232 VGND VGND VPWR VPWR sky130_fd_sc_hd__decap_3
XFILLER_18_351 VGND VGND VPWR VPWR sky130_fd_sc_hd__decap_3
XFILLER_65_479 VGND VGND VPWR VPWR sky130_fd_sc_hd__decap_3
XFILLER_92_265 VGND VGND VPWR VPWR sky130_fd_sc_hd__decap_3
XFILLER_18_395 VGND VGND VPWR VPWR sky130_fd_sc_hd__decap_3
XFILLER_33_321 VGND VGND VPWR VPWR sky130_fd_sc_hd__fill_1
XFILLER_45_181 VGND VGND VPWR VPWR sky130_fd_sc_hd__decap_3
XFILLER_92_287 VGND VGND VPWR VPWR sky130_fd_sc_hd__decap_3
X_5880_ _4553_/X _5878_/Y _4889_/B _4883_/Y VGND VGND VPWR VPWR _5880_/X sky130_fd_sc_hd__o211a_2
X_4900_ _4900_/A _4900_/B _4900_/C VGND VGND VPWR VPWR _4902_/A sky130_fd_sc_hd__and3_2
XFILLER_33_343 VGND VGND VPWR VPWR sky130_fd_sc_hd__fill_1
X_4831_ _4830_/B _4830_/C _4713_/B VGND VGND VPWR VPWR _4831_/Y sky130_fd_sc_hd__a21boi_2
XFILLER_21_505 VGND VGND VPWR VPWR sky130_fd_sc_hd__decap_3
XFILLER_60_173 VGND VGND VPWR VPWR sky130_fd_sc_hd__decap_3
X_4762_ _4760_/A _4956_/A _4746_/X _4761_/Y VGND VGND VPWR VPWR _4762_/X sky130_fd_sc_hd__a211o_4
XTAP_TAPCELL_ROW_31_544 VGND VPWR sky130_fd_sc_hd__tapvpwrvgnd_1
X_6501_ _6499_/X _6500_/X _6501_/S VGND VGND VPWR VPWR _6501_/X sky130_fd_sc_hd__mux2_1
X_4693_ _4693_/A _4693_/B VGND VGND VPWR VPWR _4923_/A sky130_fd_sc_hd__xnor2_2
X_3713_ _4406_/B _4517_/C _4517_/D _4280_/B VGND VGND VPWR VPWR _3714_/B sky130_fd_sc_hd__a22o_2
X_6432_ _5588_/A _5707_/A _6432_/S VGND VGND VPWR VPWR _6432_/X sky130_fd_sc_hd__mux2_1
X_3644_ _3644_/A _3644_/B _3644_/C VGND VGND VPWR VPWR _3651_/A sky130_fd_sc_hd__nand3_2
X_6363_ _6363_/A _6625_/B VGND VGND VPWR VPWR _6363_/Y sky130_fd_sc_hd__nor2_2
X_3575_ _3575_/A _3575_/B _3575_/C VGND VGND VPWR VPWR _3583_/A sky130_fd_sc_hd__nand3_2
X_6294_ _6392_/A _6767_/A VGND VGND VPWR VPWR _6294_/Y sky130_fd_sc_hd__nor2_2
X_5314_ _5313_/A _5313_/B _5346_/A _5313_/D VGND VGND VPWR VPWR _5315_/C sky130_fd_sc_hd__a22o_2
X_5245_ _5245_/A1 _5244_/C _5830_/A VGND VGND VPWR VPWR _5245_/Y sky130_fd_sc_hd__o21ai_2
XFILLER_68_240 VGND VGND VPWR VPWR sky130_fd_sc_hd__decap_3
XFILLER_68_273 VGND VGND VPWR VPWR sky130_fd_sc_hd__fill_2
X_5176_ _5179_/C1 _5174_/Y _5175_/X _5093_/Y VGND VGND VPWR VPWR _5180_/A sky130_fd_sc_hd__o211ai_2
XFILLER_28_137 VGND VGND VPWR VPWR sky130_fd_sc_hd__decap_3
XFILLER_28_148 VGND VGND VPWR VPWR sky130_fd_sc_hd__fill_2
XFILLER_56_457 VGND VGND VPWR VPWR sky130_fd_sc_hd__fill_2
XFILLER_83_221 VGND VGND VPWR VPWR sky130_fd_sc_hd__decap_3
X_4127_ _4126_/A _4237_/A VGND VGND VPWR VPWR _4129_/B sky130_fd_sc_hd__nand2b_2
XTAP_TAPCELL_ROW_67_920 VGND VPWR sky130_fd_sc_hd__tapvpwrvgnd_1
XTAP_TAPCELL_ROW_3_247 VGND VPWR sky130_fd_sc_hd__tapvpwrvgnd_1
XTAP_TAPCELL_ROW_39_622 VGND VPWR sky130_fd_sc_hd__tapvpwrvgnd_1
XFILLER_45_38 VGND VGND VPWR VPWR sky130_fd_sc_hd__decap_3
XFILLER_83_243 VGND VGND VPWR VPWR sky130_fd_sc_hd__decap_3
XFILLER_83_276 VGND VGND VPWR VPWR sky130_fd_sc_hd__decap_3
X_4058_ _4059_/A _4059_/B VGND VGND VPWR VPWR _4058_/X sky130_fd_sc_hd__and2b_2
XFILLER_43_129 VGND VGND VPWR VPWR sky130_fd_sc_hd__decap_3
XFILLER_71_427 VGND VGND VPWR VPWR sky130_fd_sc_hd__decap_3
XFILLER_71_449 VGND VGND VPWR VPWR sky130_fd_sc_hd__fill_1
XFILLER_83_287 VGND VGND VPWR VPWR sky130_fd_sc_hd__decap_3
XFILLER_24_321 VGND VGND VPWR VPWR sky130_fd_sc_hd__decap_3
XFILLER_24_332 VGND VGND VPWR VPWR sky130_fd_sc_hd__decap_3
XFILLER_36_181 VGND VGND VPWR VPWR sky130_fd_sc_hd__decap_3
XFILLER_24_365 VGND VGND VPWR VPWR sky130_fd_sc_hd__decap_3
XFILLER_51_151 VGND VGND VPWR VPWR sky130_fd_sc_hd__decap_3
XFILLER_61_48 VGND VGND VPWR VPWR sky130_fd_sc_hd__decap_3
XFILLER_3_225 VGND VGND VPWR VPWR sky130_fd_sc_hd__fill_1
XFILLER_79_505 VGND VGND VPWR VPWR sky130_fd_sc_hd__decap_3
XFILLER_79_527 VGND VGND VPWR VPWR sky130_fd_sc_hd__decap_3
XFILLER_59_240 VGND VGND VPWR VPWR sky130_fd_sc_hd__decap_3
XFILLER_74_243 VGND VGND VPWR VPWR sky130_fd_sc_hd__fill_1
XFILLER_62_427 VGND VGND VPWR VPWR sky130_fd_sc_hd__decap_3
XFILLER_74_287 VGND VGND VPWR VPWR sky130_fd_sc_hd__decap_3
XFILLER_15_321 VGND VGND VPWR VPWR sky130_fd_sc_hd__decap_3
XFILLER_15_376 VGND VGND VPWR VPWR sky130_fd_sc_hd__decap_3
XFILLER_35_71 VGND VGND VPWR VPWR sky130_fd_sc_hd__decap_3
XFILLER_70_482 VGND VGND VPWR VPWR sky130_fd_sc_hd__decap_3
XFILLER_30_324 VGND VGND VPWR VPWR sky130_fd_sc_hd__decap_3
XFILLER_30_346 VGND VGND VPWR VPWR sky130_fd_sc_hd__decap_3
XFILLER_30_368 VGND VGND VPWR VPWR sky130_fd_sc_hd__decap_3
XFILLER_7_520 VGND VGND VPWR VPWR sky130_fd_sc_hd__decap_3
XFILLER_7_542 VGND VGND VPWR VPWR sky130_fd_sc_hd__decap_3
XFILLER_7_553 VGND VGND VPWR VPWR sky130_fd_sc_hd__decap_3
XFILLER_7_564 VGND VGND VPWR VPWR sky130_fd_sc_hd__decap_3
Xwire462 _6373_/B VGND VGND VPWR VPWR _6439_/B sky130_fd_sc_hd__clkbuf_4
Xwire484 _5275_/A VGND VGND VPWR VPWR _5053_/D sky130_fd_sc_hd__buf_6
XTAP_TAPCELL_ROW_77_1026 VGND VPWR sky130_fd_sc_hd__tapvpwrvgnd_1
Xload_slew401 _4616_/D VGND VGND VPWR VPWR _4361_/D sky130_fd_sc_hd__buf_4
Xload_slew445 _6358_/A2 VGND VGND VPWR VPWR _5582_/B sky130_fd_sc_hd__buf_4
Xload_slew434 _4695_/B VGND VGND VPWR VPWR _6212_/B sky130_fd_sc_hd__buf_4
X_5030_ _5030_/A _5030_/B _5030_/C VGND VGND VPWR VPWR _5089_/A sky130_fd_sc_hd__nor3_2
XFILLER_97_335 VGND VGND VPWR VPWR sky130_fd_sc_hd__fill_1
XFILLER_38_413 VGND VGND VPWR VPWR sky130_fd_sc_hd__fill_1
Xload_slew478 _4608_/A VGND VGND VPWR VPWR _4505_/B sky130_fd_sc_hd__buf_4
Xload_slew467 _6402_/S VGND VGND VPWR VPWR _6744_/S0 sky130_fd_sc_hd__clkbuf_2
XFILLER_65_254 VGND VGND VPWR VPWR sky130_fd_sc_hd__decap_3
X_6981_ _6313_/A _6713_/X _6973_/Y _6980_/X VGND VGND VPWR VPWR _6981_/X sky130_fd_sc_hd__a211o_2
XTAP_TAPCELL_ROW_88_1144 VGND VPWR sky130_fd_sc_hd__tapvpwrvgnd_1
XTAP_TAPCELL_ROW_0_217 VGND VPWR sky130_fd_sc_hd__tapvpwrvgnd_1
XTAP_TAPCELL_ROW_0_206 VGND VPWR sky130_fd_sc_hd__tapvpwrvgnd_1
XFILLER_53_427 VGND VGND VPWR VPWR sky130_fd_sc_hd__decap_3
XFILLER_80_224 VGND VGND VPWR VPWR sky130_fd_sc_hd__decap_3
X_5932_ _5934_/A _5934_/B VGND VGND VPWR VPWR _6921_/B sky130_fd_sc_hd__nor2_2
XFILLER_93_596 VGND VGND VPWR VPWR sky130_fd_sc_hd__fill_2
XFILLER_15_19 VGND VGND VPWR VPWR sky130_fd_sc_hd__decap_3
XFILLER_46_490 VGND VGND VPWR VPWR sky130_fd_sc_hd__decap_3
XFILLER_53_449 VGND VGND VPWR VPWR sky130_fd_sc_hd__decap_3
X_5863_ _5862_/A _5862_/Y _5852_/Y _5857_/X VGND VGND VPWR VPWR _5871_/A sky130_fd_sc_hd__a211oi_2
XFILLER_21_313 VGND VGND VPWR VPWR sky130_fd_sc_hd__decap_3
XFILLER_33_184 VGND VGND VPWR VPWR sky130_fd_sc_hd__decap_3
X_5794_ _5801_/A _5796_/B VGND VGND VPWR VPWR _5797_/A sky130_fd_sc_hd__and2_2
X_4814_ _4813_/B _4813_/C _4813_/A VGND VGND VPWR VPWR _4816_/C sky130_fd_sc_hd__a21o_2
XTAP_TAPCELL_ROW_44_680 VGND VPWR sky130_fd_sc_hd__tapvpwrvgnd_1
XTAP_TAPCELL_ROW_16_382 VGND VPWR sky130_fd_sc_hd__tapvpwrvgnd_1
X_4745_ _4744_/B _4744_/C _4744_/A VGND VGND VPWR VPWR _4747_/C sky130_fd_sc_hd__a21o_2
XFILLER_31_29 VGND VGND VPWR VPWR sky130_fd_sc_hd__fill_1
X_4676_ _4676_/A _4676_/B _4676_/C VGND VGND VPWR VPWR _4678_/C sky130_fd_sc_hd__nor3_2
X_6415_ _6589_/A _6415_/B VGND VGND VPWR VPWR _6421_/B sky130_fd_sc_hd__nand2_2
X_3627_ _3626_/A _3933_/B _3933_/D _3812_/A VGND VGND VPWR VPWR _3627_/Y sky130_fd_sc_hd__a22oi_2
X_6346_ _6201_/Y _6204_/X _6291_/Y _6345_/X VGND VGND VPWR VPWR _6346_/X sky130_fd_sc_hd__o211a_2
X_3558_ _4362_/A _3900_/A _3977_/B _3909_/D VGND VGND VPWR VPWR _3599_/A sky130_fd_sc_hd__and4_2
XTAP_TAPCELL_ROW_8_306 VGND VPWR sky130_fd_sc_hd__tapvpwrvgnd_1
XFILLER_0_206 VGND VGND VPWR VPWR sky130_fd_sc_hd__decap_3
XFILLER_0_228 VGND VGND VPWR VPWR sky130_fd_sc_hd__decap_3
XFILLER_88_302 VGND VGND VPWR VPWR sky130_fd_sc_hd__decap_3
XFILLER_88_324 VGND VGND VPWR VPWR sky130_fd_sc_hd__decap_3
XFILLER_88_368 VGND VGND VPWR VPWR sky130_fd_sc_hd__decap_3
X_6277_ _6187_/A _3498_/Y _6276_/X VGND VGND VPWR VPWR _6278_/B sky130_fd_sc_hd__o21a_2
X_3489_ _6144_/A VGND VGND VPWR VPWR _3489_/Y sky130_fd_sc_hd__inv_2
X_5228_ _5228_/A _5228_/B VGND VGND VPWR VPWR _5231_/B sky130_fd_sc_hd__xnor2_2
XFILLER_29_446 VGND VGND VPWR VPWR sky130_fd_sc_hd__fill_2
XFILLER_56_210 VGND VGND VPWR VPWR sky130_fd_sc_hd__decap_3
XFILLER_84_530 VGND VGND VPWR VPWR sky130_fd_sc_hd__fill_2
X_5159_ _5159_/A _5159_/B VGND VGND VPWR VPWR _5222_/B sky130_fd_sc_hd__xnor2_2
XFILLER_56_265 VGND VGND VPWR VPWR sky130_fd_sc_hd__decap_3
XFILLER_16_118 VGND VGND VPWR VPWR sky130_fd_sc_hd__fill_1
XFILLER_71_213 VGND VGND VPWR VPWR sky130_fd_sc_hd__decap_3
XFILLER_84_596 VGND VGND VPWR VPWR sky130_fd_sc_hd__fill_2
XFILLER_71_246 VGND VGND VPWR VPWR sky130_fd_sc_hd__decap_3
XFILLER_72_25 VGND VGND VPWR VPWR sky130_fd_sc_hd__decap_3
XFILLER_52_471 VGND VGND VPWR VPWR sky130_fd_sc_hd__decap_3
XFILLER_71_279 VGND VGND VPWR VPWR sky130_fd_sc_hd__fill_1
XFILLER_72_58 VGND VGND VPWR VPWR sky130_fd_sc_hd__decap_3
XFILLER_72_69 VGND VGND VPWR VPWR sky130_fd_sc_hd__fill_1
XTAP_TAPCELL_ROW_70_948 VGND VPWR sky130_fd_sc_hd__tapvpwrvgnd_1
XFILLER_20_390 VGND VGND VPWR VPWR sky130_fd_sc_hd__decap_3
XFILLER_21_84 VGND VGND VPWR VPWR sky130_fd_sc_hd__fill_1
XFILLER_4_589 VGND VGND VPWR VPWR sky130_fd_sc_hd__decap_3
XFILLER_79_302 VGND VGND VPWR VPWR sky130_fd_sc_hd__decap_3
XFILLER_79_335 VGND VGND VPWR VPWR sky130_fd_sc_hd__fill_1
XFILLER_79_346 VGND VGND VPWR VPWR sky130_fd_sc_hd__decap_3
XFILLER_67_508 VGND VGND VPWR VPWR sky130_fd_sc_hd__decap_3
XFILLER_79_379 VGND VGND VPWR VPWR sky130_fd_sc_hd__decap_3
XFILLER_11_9 VGND VGND VPWR VPWR sky130_fd_sc_hd__decap_3
XFILLER_47_221 VGND VGND VPWR VPWR sky130_fd_sc_hd__decap_3
XFILLER_94_327 VGND VGND VPWR VPWR sky130_fd_sc_hd__fill_2
XFILLER_47_243 VGND VGND VPWR VPWR sky130_fd_sc_hd__decap_3
XFILLER_35_438 VGND VGND VPWR VPWR sky130_fd_sc_hd__decap_3
XFILLER_47_287 VGND VGND VPWR VPWR sky130_fd_sc_hd__fill_2
XFILLER_75_596 VGND VGND VPWR VPWR sky130_fd_sc_hd__fill_2
XFILLER_90_511 VGND VGND VPWR VPWR sky130_fd_sc_hd__decap_3
XFILLER_90_533 VGND VGND VPWR VPWR sky130_fd_sc_hd__decap_3
XFILLER_35_449 VGND VGND VPWR VPWR sky130_fd_sc_hd__decap_3
XFILLER_46_81 VGND VGND VPWR VPWR sky130_fd_sc_hd__decap_3
XFILLER_62_268 VGND VGND VPWR VPWR sky130_fd_sc_hd__fill_2
XTAP_TAPCELL_ROW_83_1085 VGND VPWR sky130_fd_sc_hd__tapvpwrvgnd_1
XFILLER_30_132 VGND VGND VPWR VPWR sky130_fd_sc_hd__decap_3
XFILLER_62_80 VGND VGND VPWR VPWR sky130_fd_sc_hd__decap_3
XTAP_TAPCELL_ROW_41_650 VGND VPWR sky130_fd_sc_hd__tapvpwrvgnd_1
XTAP_TAPCELL_ROW_13_352 VGND VPWR sky130_fd_sc_hd__tapvpwrvgnd_1
XFILLER_7_350 VGND VGND VPWR VPWR sky130_fd_sc_hd__decap_3
X_4530_ _4516_/A _4516_/C _4516_/B VGND VGND VPWR VPWR _4530_/Y sky130_fd_sc_hd__a21oi_2
X_4461_ _4461_/A _4461_/B VGND VGND VPWR VPWR _4835_/B sky130_fd_sc_hd__xnor2_2
X_6200_ _6200_/A _6971_/A VGND VGND VPWR VPWR _6999_/B sky130_fd_sc_hd__and2_2
X_6131_ _6119_/Y _6130_/Y _6120_/A VGND VGND VPWR VPWR _6131_/Y sky130_fd_sc_hd__a21oi_2
X_4392_ _4392_/A _4392_/B VGND VGND VPWR VPWR _4394_/B sky130_fd_sc_hd__nand2_2
Xload_slew231 _3685_/C VGND VGND VPWR VPWR _4406_/C sky130_fd_sc_hd__buf_4
Xload_slew253 _4767_/B VGND VGND VPWR VPWR _5068_/A sky130_fd_sc_hd__buf_4
X_6062_ _6332_/C _6384_/A VGND VGND VPWR VPWR _6062_/X sky130_fd_sc_hd__or2_2
XFILLER_85_349 VGND VGND VPWR VPWR sky130_fd_sc_hd__decap_3
X_5013_ _4925_/B _4646_/C _3490_/Y _5019_/A VGND VGND VPWR VPWR _5014_/B sky130_fd_sc_hd__o2bb2a_2
XFILLER_38_243 VGND VGND VPWR VPWR sky130_fd_sc_hd__fill_1
XFILLER_26_29 VGND VGND VPWR VPWR sky130_fd_sc_hd__fill_1
XFILLER_53_213 VGND VGND VPWR VPWR sky130_fd_sc_hd__decap_3
XFILLER_81_544 VGND VGND VPWR VPWR sky130_fd_sc_hd__decap_3
XFILLER_93_393 VGND VGND VPWR VPWR sky130_fd_sc_hd__decap_3
X_6964_ _6196_/B _6978_/B1 _6979_/B1 _6957_/A VGND VGND VPWR VPWR _6965_/C sky130_fd_sc_hd__o22a_2
XPHY_EDGE_ROW_5_Right_5 VGND VGND VPWR VPWR sky130_fd_sc_hd__decap_3
XFILLER_41_419 VGND VGND VPWR VPWR sky130_fd_sc_hd__decap_3
XFILLER_53_279 VGND VGND VPWR VPWR sky130_fd_sc_hd__fill_1
XFILLER_81_588 VGND VGND VPWR VPWR sky130_fd_sc_hd__decap_3
X_6895_ _6961_/A1 _6761_/X _6894_/X _6765_/B VGND VGND VPWR VPWR _6896_/B sky130_fd_sc_hd__a22o_2
X_5915_ _5915_/A _5915_/B VGND VGND VPWR VPWR _5916_/B sky130_fd_sc_hd__xnor2_2
X_5846_ _5846_/A _5846_/B _5846_/C VGND VGND VPWR VPWR _5848_/A sky130_fd_sc_hd__and3_4
XFILLER_61_290 VGND VGND VPWR VPWR sky130_fd_sc_hd__decap_3
X_5777_ _5777_/A _5777_/B VGND VGND VPWR VPWR _5777_/Y sky130_fd_sc_hd__nand2_2
X_4728_ _4728_/A _4728_/B _4728_/C VGND VGND VPWR VPWR _4730_/A sky130_fd_sc_hd__and3_2
X_4659_ _4659_/A _4659_/B VGND VGND VPWR VPWR _4665_/A sky130_fd_sc_hd__nand2_2
XFILLER_1_526 VGND VGND VPWR VPWR sky130_fd_sc_hd__decap_3
X_6329_ _6332_/A _6332_/B _6384_/D VGND VGND VPWR VPWR _6550_/B sky130_fd_sc_hd__nor3_4
XFILLER_67_47 VGND VGND VPWR VPWR sky130_fd_sc_hd__decap_3
XFILLER_88_165 VGND VGND VPWR VPWR sky130_fd_sc_hd__decap_3
XFILLER_76_327 VGND VGND VPWR VPWR sky130_fd_sc_hd__decap_3
XFILLER_57_541 VGND VGND VPWR VPWR sky130_fd_sc_hd__decap_3
XTAP_TAPCELL_ROW_47_709 VGND VPWR sky130_fd_sc_hd__tapvpwrvgnd_1
XFILLER_17_405 VGND VGND VPWR VPWR sky130_fd_sc_hd__decap_3
XFILLER_17_427 VGND VGND VPWR VPWR sky130_fd_sc_hd__decap_3
XFILLER_29_276 VGND VGND VPWR VPWR sky130_fd_sc_hd__decap_3
XFILLER_72_500 VGND VGND VPWR VPWR sky130_fd_sc_hd__decap_3
XFILLER_72_511 VGND VGND VPWR VPWR sky130_fd_sc_hd__decap_3
XFILLER_84_371 VGND VGND VPWR VPWR sky130_fd_sc_hd__decap_3
XFILLER_17_449 VGND VGND VPWR VPWR sky130_fd_sc_hd__decap_3
XFILLER_44_224 VGND VGND VPWR VPWR sky130_fd_sc_hd__fill_2
XFILLER_72_533 VGND VGND VPWR VPWR sky130_fd_sc_hd__decap_3
XFILLER_83_57 VGND VGND VPWR VPWR sky130_fd_sc_hd__decap_3
XFILLER_12_110 VGND VGND VPWR VPWR sky130_fd_sc_hd__decap_3
XFILLER_16_73 VGND VGND VPWR VPWR sky130_fd_sc_hd__decap_3
XTAP_TAPCELL_ROW_55_797 VGND VPWR sky130_fd_sc_hd__tapvpwrvgnd_1
XTAP_TAPCELL_ROW_27_499 VGND VPWR sky130_fd_sc_hd__tapvpwrvgnd_1
XFILLER_12_132 VGND VGND VPWR VPWR sky130_fd_sc_hd__decap_3
XFILLER_32_83 VGND VGND VPWR VPWR sky130_fd_sc_hd__fill_1
XFILLER_8_169 VGND VGND VPWR VPWR sky130_fd_sc_hd__decap_3
XTAP_TAPCELL_ROW_10_322 VGND VPWR sky130_fd_sc_hd__tapvpwrvgnd_1
XFILLER_4_320 VGND VGND VPWR VPWR sky130_fd_sc_hd__decap_3
XFILLER_4_342 VGND VGND VPWR VPWR sky130_fd_sc_hd__fill_1
XFILLER_99_408 VGND VGND VPWR VPWR sky130_fd_sc_hd__fill_1
XFILLER_79_121 VGND VGND VPWR VPWR sky130_fd_sc_hd__decap_3
XFILLER_67_305 VGND VGND VPWR VPWR sky130_fd_sc_hd__decap_3
XFILLER_79_154 VGND VGND VPWR VPWR sky130_fd_sc_hd__decap_3
XFILLER_0_570 VGND VGND VPWR VPWR sky130_fd_sc_hd__decap_3
XFILLER_0_592 VGND VGND VPWR VPWR sky130_fd_sc_hd__decap_3
XFILLER_94_113 VGND VGND VPWR VPWR sky130_fd_sc_hd__fill_2
XFILLER_63_522 VGND VGND VPWR VPWR sky130_fd_sc_hd__decap_3
XFILLER_75_371 VGND VGND VPWR VPWR sky130_fd_sc_hd__decap_3
XTAP_TAPCELL_ROW_85_1114 VGND VPWR sky130_fd_sc_hd__tapvpwrvgnd_1
XFILLER_75_393 VGND VGND VPWR VPWR sky130_fd_sc_hd__fill_2
XTAP_TAPCELL_ROW_18_411 VGND VPWR sky130_fd_sc_hd__tapvpwrvgnd_1
XFILLER_90_374 VGND VGND VPWR VPWR sky130_fd_sc_hd__decap_3
X_3961_ _5993_/B _6008_/B _3961_/C _3961_/D VGND VGND VPWR VPWR _3963_/A sky130_fd_sc_hd__and4_2
X_5700_ _5700_/A _5700_/B _5700_/C VGND VGND VPWR VPWR _5703_/A sky130_fd_sc_hd__and3_2
XFILLER_31_452 VGND VGND VPWR VPWR sky130_fd_sc_hd__decap_3
X_6680_ _6680_/A _6867_/A _6680_/C VGND VGND VPWR VPWR _6680_/X sky130_fd_sc_hd__and3_2
X_3892_ _3991_/B _5993_/B _3961_/C _3961_/D VGND VGND VPWR VPWR _3894_/A sky130_fd_sc_hd__and4_2
XFILLER_31_485 VGND VGND VPWR VPWR sky130_fd_sc_hd__decap_3
X_5631_ _5629_/A _5629_/C _5629_/B VGND VGND VPWR VPWR _5632_/C sky130_fd_sc_hd__a21oi_2
X_5562_ _5562_/A _5562_/B _5562_/C VGND VGND VPWR VPWR _5562_/Y sky130_fd_sc_hd__nand3_2
X_4513_ _4510_/X _4513_/B VGND VGND VPWR VPWR _4844_/B sky130_fd_sc_hd__and2b_2
XTAP_TAPCELL_ROW_96_1221 VGND VPWR sky130_fd_sc_hd__tapvpwrvgnd_1
X_5493_ _5490_/X _5493_/B VGND VGND VPWR VPWR _5534_/B sky130_fd_sc_hd__and2b_2
X_4444_ _4382_/Y _4441_/A _4445_/A _4443_/Y VGND VGND VPWR VPWR _4445_/B sky130_fd_sc_hd__a211oi_2
X_4375_ _4370_/Y _4473_/A _4351_/A _4352_/Y VGND VGND VPWR VPWR _4375_/X sky130_fd_sc_hd__a211o_2
Xfanout616 input16/X VGND VGND VPWR VPWR _4900_/A sky130_fd_sc_hd__dlymetal6s4s_1
Xfanout627 _6016_/B VGND VGND VPWR VPWR _3720_/A sky130_fd_sc_hd__dlygate4sd1_1
Xfanout638 input12/X VGND VGND VPWR VPWR _5321_/A sky130_fd_sc_hd__dlymetal6s2s_1
Xfanout649 _4165_/A VGND VGND VPWR VPWR _4989_/A sky130_fd_sc_hd__dlymetal6s2s_1
X_6114_ _6114_/A _6114_/B VGND VGND VPWR VPWR _6583_/A sky130_fd_sc_hd__or2_2
XFILLER_85_113 VGND VGND VPWR VPWR sky130_fd_sc_hd__fill_1
X_6045_ _6045_/A _6045_/B VGND VGND VPWR VPWR _6048_/A sky130_fd_sc_hd__xnor2_2
XFILLER_39_530 VGND VGND VPWR VPWR sky130_fd_sc_hd__decap_3
XFILLER_85_157 VGND VGND VPWR VPWR sky130_fd_sc_hd__decap_3
XFILLER_66_371 VGND VGND VPWR VPWR sky130_fd_sc_hd__decap_3
XFILLER_26_235 VGND VGND VPWR VPWR sky130_fd_sc_hd__fill_1
XFILLER_54_533 VGND VGND VPWR VPWR sky130_fd_sc_hd__decap_3
XFILLER_93_190 VGND VGND VPWR VPWR sky130_fd_sc_hd__decap_3
XFILLER_14_408 VGND VGND VPWR VPWR sky130_fd_sc_hd__decap_3
XFILLER_14_419 VGND VGND VPWR VPWR sky130_fd_sc_hd__fill_1
XFILLER_26_279 VGND VGND VPWR VPWR sky130_fd_sc_hd__decap_3
XFILLER_81_374 VGND VGND VPWR VPWR sky130_fd_sc_hd__decap_3
X_6947_ _6348_/C _6284_/B _6291_/A VGND VGND VPWR VPWR _6947_/Y sky130_fd_sc_hd__o21ai_2
X_6878_ _6878_/A _6977_/B VGND VGND VPWR VPWR _6878_/Y sky130_fd_sc_hd__nand2_2
XTAP_TAPCELL_ROW_52_767 VGND VPWR sky130_fd_sc_hd__tapvpwrvgnd_1
XTAP_TAPCELL_ROW_24_469 VGND VPWR sky130_fd_sc_hd__tapvpwrvgnd_1
XFILLER_22_463 VGND VGND VPWR VPWR sky130_fd_sc_hd__decap_3
X_5829_ _5826_/X _5827_/Y _5450_/Y _5829_/C1 VGND VGND VPWR VPWR _5830_/D sky130_fd_sc_hd__a211o_4
XFILLER_5_139 VGND VGND VPWR VPWR sky130_fd_sc_hd__decap_3
XFILLER_49_305 VGND VGND VPWR VPWR sky130_fd_sc_hd__decap_3
XFILLER_89_474 VGND VGND VPWR VPWR sky130_fd_sc_hd__decap_3
XFILLER_1_378 VGND VGND VPWR VPWR sky130_fd_sc_hd__decap_3
XFILLER_76_124 VGND VGND VPWR VPWR sky130_fd_sc_hd__decap_3
XFILLER_94_34 VGND VGND VPWR VPWR sky130_fd_sc_hd__fill_2
XFILLER_45_500 VGND VGND VPWR VPWR sky130_fd_sc_hd__decap_3
XFILLER_45_511 VGND VGND VPWR VPWR sky130_fd_sc_hd__decap_3
XFILLER_76_168 VGND VGND VPWR VPWR sky130_fd_sc_hd__decap_3
XFILLER_94_56 VGND VGND VPWR VPWR sky130_fd_sc_hd__fill_2
XFILLER_27_50 VGND VGND VPWR VPWR sky130_fd_sc_hd__decap_3
XFILLER_57_382 VGND VGND VPWR VPWR sky130_fd_sc_hd__decap_3
XFILLER_57_393 VGND VGND VPWR VPWR sky130_fd_sc_hd__fill_1
XFILLER_60_514 VGND VGND VPWR VPWR sky130_fd_sc_hd__decap_3
XFILLER_13_452 VGND VGND VPWR VPWR sky130_fd_sc_hd__decap_3
XFILLER_25_290 VGND VGND VPWR VPWR sky130_fd_sc_hd__fill_2
XFILLER_9_401 VGND VGND VPWR VPWR sky130_fd_sc_hd__decap_3
XFILLER_40_271 VGND VGND VPWR VPWR sky130_fd_sc_hd__decap_3
XFILLER_43_71 VGND VGND VPWR VPWR sky130_fd_sc_hd__decap_3
XTAP_TAPCELL_ROW_80_1055 VGND VPWR sky130_fd_sc_hd__tapvpwrvgnd_1
XFILLER_57_6 VGND VGND VPWR VPWR sky130_fd_sc_hd__decap_3
X_4160_ _4157_/X _4160_/B VGND VGND VPWR VPWR _4268_/B sky130_fd_sc_hd__and2b_2
XTAP_TAPCELL_ROW_91_1173 VGND VPWR sky130_fd_sc_hd__tapvpwrvgnd_1
XFILLER_67_124 VGND VGND VPWR VPWR sky130_fd_sc_hd__decap_3
X_4091_ _4346_/A _4221_/B VGND VGND VPWR VPWR _4222_/A sky130_fd_sc_hd__and2_2
XFILLER_95_455 VGND VGND VPWR VPWR sky130_fd_sc_hd__decap_3
XFILLER_95_444 VGND VGND VPWR VPWR sky130_fd_sc_hd__decap_3
XFILLER_36_533 VGND VGND VPWR VPWR sky130_fd_sc_hd__decap_3
XFILLER_51_514 VGND VGND VPWR VPWR sky130_fd_sc_hd__fill_2
XFILLER_63_352 VGND VGND VPWR VPWR sky130_fd_sc_hd__fill_1
X_6801_ _6658_/X _6944_/B1 _6800_/X _6372_/B VGND VGND VPWR VPWR _6803_/B sky130_fd_sc_hd__a22o_2
XFILLER_63_385 VGND VGND VPWR VPWR sky130_fd_sc_hd__decap_3
XFILLER_63_396 VGND VGND VPWR VPWR sky130_fd_sc_hd__fill_2
XFILLER_90_160 VGND VGND VPWR VPWR sky130_fd_sc_hd__decap_3
X_4993_ _4993_/A _4993_/B _4993_/C VGND VGND VPWR VPWR _4994_/A sky130_fd_sc_hd__and3_2
XFILLER_23_249 VGND VGND VPWR VPWR sky130_fd_sc_hd__decap_3
X_6732_ _6153_/A _6797_/A2 _6781_/A2 _6152_/A _6965_/A VGND VGND VPWR VPWR _6732_/X
+ sky130_fd_sc_hd__o221a_2
X_3944_ _6016_/D _3944_/B VGND VGND VPWR VPWR _3945_/B sky130_fd_sc_hd__nand2_2
X_6663_ _6105_/A _6781_/A2 _6661_/X _6662_/X VGND VGND VPWR VPWR _6663_/X sky130_fd_sc_hd__o211a_2
X_3875_ _3876_/A _3876_/B VGND VGND VPWR VPWR _3877_/A sky130_fd_sc_hd__and2_2
X_5614_ _5500_/X _5502_/X _5611_/A _5612_/X VGND VGND VPWR VPWR _5614_/Y sky130_fd_sc_hd__o211ai_2
XTAP_TAPCELL_ROW_21_439 VGND VPWR sky130_fd_sc_hd__tapvpwrvgnd_1
X_6594_ _6594_/A _6594_/B _6594_/C VGND VGND VPWR VPWR _6594_/X sky130_fd_sc_hd__and3_2
XTAP_TAPCELL_ROW_100_1280 VGND VPWR sky130_fd_sc_hd__tapvpwrvgnd_1
X_5545_ _5777_/A _6215_/B _5576_/C _5543_/A VGND VGND VPWR VPWR _5546_/B sky130_fd_sc_hd__a22oi_2
X_5476_ _5547_/A _5543_/A _6215_/B _5576_/C VGND VGND VPWR VPWR _5476_/X sky130_fd_sc_hd__and4_2
X_4427_ _4425_/A _4425_/B _4425_/C VGND VGND VPWR VPWR _4428_/C sky130_fd_sc_hd__o21ai_2
Xfanout402 fanout402/A VGND VGND VPWR VPWR _4482_/D sky130_fd_sc_hd__buf_2
XFILLER_86_433 VGND VGND VPWR VPWR sky130_fd_sc_hd__decap_3
Xfanout424 _4944_/D VGND VGND VPWR VPWR _5290_/C sky130_fd_sc_hd__buf_6
Xfanout435 _4264_/B VGND VGND VPWR VPWR _6014_/A sky130_fd_sc_hd__dlymetal6s4s_1
Xfanout446 _5487_/B VGND VGND VPWR VPWR _6435_/S sky130_fd_sc_hd__dlymetal6s4s_1
Xfanout457 _6474_/S VGND VGND VPWR VPWR _6432_/S sky130_fd_sc_hd__clkdlybuf4s25_1
X_4358_ _4355_/A _4476_/B _4357_/B _4354_/X VGND VGND VPWR VPWR _4360_/B sky130_fd_sc_hd__a31o_2
XFILLER_98_271 VGND VGND VPWR VPWR sky130_fd_sc_hd__decap_3
XFILLER_86_455 VGND VGND VPWR VPWR sky130_fd_sc_hd__decap_3
Xfanout468 input33/X VGND VGND VPWR VPWR _6397_/S sky130_fd_sc_hd__dlymetal6s2s_1
Xfanout479 _5981_/B VGND VGND VPWR VPWR _3969_/C sky130_fd_sc_hd__clkdlybuf4s25_1
X_4289_ _4172_/X _4260_/Y _4272_/X wire118/X VGND VGND VPWR VPWR _4309_/B sky130_fd_sc_hd__a211o_2
XFILLER_100_265 VGND VGND VPWR VPWR sky130_fd_sc_hd__decap_3
XFILLER_73_116 VGND VGND VPWR VPWR sky130_fd_sc_hd__decap_3
XFILLER_86_477 VGND VGND VPWR VPWR sky130_fd_sc_hd__fill_2
X_6028_ _5983_/D _5976_/C _3978_/X _3977_/X _3909_/D VGND VGND VPWR VPWR _6030_/A
+ sky130_fd_sc_hd__a32o_2
XTAP_TAPCELL_ROW_57_815 VGND VPWR sky130_fd_sc_hd__tapvpwrvgnd_1
XTAP_TAPCELL_ROW_29_517 VGND VPWR sky130_fd_sc_hd__tapvpwrvgnd_1
XFILLER_100_287 VGND VGND VPWR VPWR sky130_fd_sc_hd__fill_2
XFILLER_39_393 VGND VGND VPWR VPWR sky130_fd_sc_hd__fill_1
XFILLER_64_26 VGND VGND VPWR VPWR sky130_fd_sc_hd__fill_2
XFILLER_42_503 VGND VGND VPWR VPWR sky130_fd_sc_hd__fill_1
XFILLER_54_352 VGND VGND VPWR VPWR sky130_fd_sc_hd__decap_3
XFILLER_14_238 VGND VGND VPWR VPWR sky130_fd_sc_hd__decap_3
XFILLER_42_569 VGND VGND VPWR VPWR sky130_fd_sc_hd__decap_3
XFILLER_81_193 VGND VGND VPWR VPWR sky130_fd_sc_hd__decap_3
XFILLER_10_400 VGND VGND VPWR VPWR sky130_fd_sc_hd__fill_2
XFILLER_80_69 VGND VGND VPWR VPWR sky130_fd_sc_hd__decap_3
XFILLER_10_477 VGND VGND VPWR VPWR sky130_fd_sc_hd__fill_1
XFILLER_13_63 VGND VGND VPWR VPWR sky130_fd_sc_hd__decap_3
XFILLER_1_186 VGND VGND VPWR VPWR sky130_fd_sc_hd__fill_2
XFILLER_49_113 VGND VGND VPWR VPWR sky130_fd_sc_hd__decap_3
XFILLER_77_411 VGND VGND VPWR VPWR sky130_fd_sc_hd__decap_3
XFILLER_89_271 VGND VGND VPWR VPWR sky130_fd_sc_hd__decap_3
XFILLER_77_455 VGND VGND VPWR VPWR sky130_fd_sc_hd__decap_3
XFILLER_89_293 VGND VGND VPWR VPWR sky130_fd_sc_hd__decap_3
XFILLER_38_71 VGND VGND VPWR VPWR sky130_fd_sc_hd__fill_1
XFILLER_64_116 VGND VGND VPWR VPWR sky130_fd_sc_hd__decap_3
XFILLER_92_403 VGND VGND VPWR VPWR sky130_fd_sc_hd__decap_3
XFILLER_18_533 VGND VGND VPWR VPWR sky130_fd_sc_hd__decap_3
XFILLER_18_544 VGND VGND VPWR VPWR sky130_fd_sc_hd__decap_3
XFILLER_38_82 VGND VGND VPWR VPWR sky130_fd_sc_hd__fill_2
XFILLER_38_93 VGND VGND VPWR VPWR sky130_fd_sc_hd__fill_2
XFILLER_57_190 VGND VGND VPWR VPWR sky130_fd_sc_hd__decap_3
XFILLER_92_469 VGND VGND VPWR VPWR sky130_fd_sc_hd__decap_3
XFILLER_45_374 VGND VGND VPWR VPWR sky130_fd_sc_hd__decap_3
XFILLER_60_300 VGND VGND VPWR VPWR sky130_fd_sc_hd__fill_1
XFILLER_33_558 VGND VGND VPWR VPWR sky130_fd_sc_hd__fill_2
XFILLER_60_333 VGND VGND VPWR VPWR sky130_fd_sc_hd__decap_3
XFILLER_70_80 VGND VGND VPWR VPWR sky130_fd_sc_hd__decap_3
X_3660_ _3628_/C _6014_/A _3629_/A _3627_/Y VGND VGND VPWR VPWR _3661_/B sky130_fd_sc_hd__o2bb2a_2
X_3591_ _3626_/A _6024_/A VGND VGND VPWR VPWR _6150_/A sky130_fd_sc_hd__and2_2
XFILLER_55_3 VGND VGND VPWR VPWR sky130_fd_sc_hd__fill_1
X_5330_ _5382_/B _5382_/C _5382_/D _5383_/A VGND VGND VPWR VPWR _5331_/C sky130_fd_sc_hd__a22oi_2
XFILLER_5_492 VGND VGND VPWR VPWR sky130_fd_sc_hd__decap_3
X_5261_ _5009_/Y _6856_/A _5260_/Y _5011_/B VGND VGND VPWR VPWR _5261_/Y sky130_fd_sc_hd__o31ai_4
X_7000_ _6331_/A wire162/X _6999_/Y _6353_/D _7000_/B2 VGND VGND VPWR VPWR _7000_/X
+ sky130_fd_sc_hd__a32o_2
X_4212_ _4593_/B _4334_/C _4457_/C _4593_/A VGND VGND VPWR VPWR _4212_/Y sky130_fd_sc_hd__a22oi_2
XFILLER_68_400 VGND VGND VPWR VPWR sky130_fd_sc_hd__decap_3
XFILLER_87_219 VGND VGND VPWR VPWR sky130_fd_sc_hd__decap_3
X_5192_ _5341_/A _5304_/B _5190_/B _5188_/X VGND VGND VPWR VPWR _5194_/B sky130_fd_sc_hd__a31o_2
X_4143_ _4114_/Y _4139_/C _4141_/X _4077_/C VGND VGND VPWR VPWR _4143_/Y sky130_fd_sc_hd__o211ai_2
XFILLER_68_477 VGND VGND VPWR VPWR sky130_fd_sc_hd__fill_2
X_4074_ _4074_/A _4074_/B VGND VGND VPWR VPWR _4075_/C sky130_fd_sc_hd__xnor2_2
XFILLER_83_458 VGND VGND VPWR VPWR sky130_fd_sc_hd__decap_3
XFILLER_95_296 VGND VGND VPWR VPWR sky130_fd_sc_hd__decap_3
XFILLER_24_503 VGND VGND VPWR VPWR sky130_fd_sc_hd__decap_3
XFILLER_36_385 VGND VGND VPWR VPWR sky130_fd_sc_hd__decap_3
XFILLER_24_547 VGND VGND VPWR VPWR sky130_fd_sc_hd__decap_3
XFILLER_34_29 VGND VGND VPWR VPWR sky130_fd_sc_hd__decap_3
X_6715_ _6700_/A _6569_/X _6570_/X _6625_/Y VGND VGND VPWR VPWR _6715_/Y sky130_fd_sc_hd__a22oi_2
X_4976_ _4989_/A _4989_/B VGND VGND VPWR VPWR _4990_/A sky130_fd_sc_hd__nand2_2
XTAP_TAPCELL_ROW_62_873 VGND VPWR sky130_fd_sc_hd__tapvpwrvgnd_1
XTAP_TAPCELL_ROW_34_575 VGND VPWR sky130_fd_sc_hd__tapvpwrvgnd_1
XFILLER_51_399 VGND VGND VPWR VPWR sky130_fd_sc_hd__fill_1
X_3927_ _3928_/A _3928_/B VGND VGND VPWR VPWR _3929_/A sky130_fd_sc_hd__and2_2
XFILLER_50_39 VGND VGND VPWR VPWR sky130_fd_sc_hd__fill_2
X_6646_ _6238_/B _6781_/A2 _6810_/B1 _6635_/A _6645_/X VGND VGND VPWR VPWR _6647_/B
+ sky130_fd_sc_hd__o221a_2
X_3858_ _3858_/A _3858_/B VGND VGND VPWR VPWR _3859_/B sky130_fd_sc_hd__nor2_2
X_6577_ _6453_/X _6477_/X _6478_/X _6479_/X _6608_/S _6569_/A VGND VGND VPWR VPWR
+ _6577_/X sky130_fd_sc_hd__mux4_2
X_3789_ _3789_/A _3789_/B VGND VGND VPWR VPWR _4044_/A sky130_fd_sc_hd__xnor2_2
X_5528_ _5529_/A _5695_/C VGND VGND VPWR VPWR _6120_/A sky130_fd_sc_hd__and2_2
X_5459_ _5458_/A _5458_/B _5458_/C VGND VGND VPWR VPWR _5459_/Y sky130_fd_sc_hd__a21oi_2
Xfanout210 _6109_/B VGND VGND VPWR VPWR _5321_/D sky130_fd_sc_hd__clkbuf_4
Xfanout232 _3851_/B VGND VGND VPWR VPWR _4767_/C sky130_fd_sc_hd__buf_6
XFILLER_59_455 VGND VGND VPWR VPWR sky130_fd_sc_hd__decap_3
Xfanout243 _4757_/B VGND VGND VPWR VPWR _5383_/B sky130_fd_sc_hd__buf_4
Xfanout254 _3664_/B VGND VGND VPWR VPWR _4524_/A sky130_fd_sc_hd__dlymetal6s4s_1
XFILLER_75_36 VGND VGND VPWR VPWR sky130_fd_sc_hd__fill_1
XFILLER_86_274 VGND VGND VPWR VPWR sky130_fd_sc_hd__decap_3
Xfanout276 _5492_/B1 VGND VGND VPWR VPWR _5490_/D sky130_fd_sc_hd__buf_4
Xfanout287 _6678_/A VGND VGND VPWR VPWR _6462_/S sky130_fd_sc_hd__clkdlybuf4s25_1
Xfanout298 fanout300/X VGND VGND VPWR VPWR wire299/A sky130_fd_sc_hd__clkdlybuf4s25_1
XTAP_TAPCELL_ROW_6_278 VGND VPWR sky130_fd_sc_hd__tapvpwrvgnd_1
XFILLER_46_127 VGND VGND VPWR VPWR sky130_fd_sc_hd__decap_3
XFILLER_74_458 VGND VGND VPWR VPWR sky130_fd_sc_hd__decap_3
XFILLER_27_374 VGND VGND VPWR VPWR sky130_fd_sc_hd__decap_3
XFILLER_27_396 VGND VGND VPWR VPWR sky130_fd_sc_hd__decap_3
XFILLER_15_558 VGND VGND VPWR VPWR sky130_fd_sc_hd__fill_2
XFILLER_42_344 VGND VGND VPWR VPWR sky130_fd_sc_hd__decap_3
XFILLER_54_193 VGND VGND VPWR VPWR sky130_fd_sc_hd__decap_3
XFILLER_30_517 VGND VGND VPWR VPWR sky130_fd_sc_hd__decap_3
XFILLER_42_388 VGND VGND VPWR VPWR sky130_fd_sc_hd__decap_3
XFILLER_91_68 VGND VGND VPWR VPWR sky130_fd_sc_hd__decap_3
XFILLER_30_539 VGND VGND VPWR VPWR sky130_fd_sc_hd__fill_2
XFILLER_40_50 VGND VGND VPWR VPWR sky130_fd_sc_hd__fill_2
XFILLER_6_245 VGND VGND VPWR VPWR sky130_fd_sc_hd__decap_3
XFILLER_69_208 VGND VGND VPWR VPWR sky130_fd_sc_hd__fill_1
Xload_slew605 _6639_/A0 VGND VGND VPWR VPWR _3972_/A sky130_fd_sc_hd__clkbuf_4
XFILLER_77_263 VGND VGND VPWR VPWR sky130_fd_sc_hd__decap_3
XFILLER_37_127 VGND VGND VPWR VPWR sky130_fd_sc_hd__decap_3
XFILLER_65_425 VGND VGND VPWR VPWR sky130_fd_sc_hd__decap_3
XFILLER_65_447 VGND VGND VPWR VPWR sky130_fd_sc_hd__fill_1
XFILLER_77_296 VGND VGND VPWR VPWR sky130_fd_sc_hd__decap_3
XFILLER_92_211 VGND VGND VPWR VPWR sky130_fd_sc_hd__decap_3
XFILLER_1_77 VGND VGND VPWR VPWR sky130_fd_sc_hd__decap_3
XFILLER_65_458 VGND VGND VPWR VPWR sky130_fd_sc_hd__decap_3
XFILLER_92_244 VGND VGND VPWR VPWR sky130_fd_sc_hd__decap_3
XFILLER_65_91 VGND VGND VPWR VPWR sky130_fd_sc_hd__decap_3
XFILLER_92_277 VGND VGND VPWR VPWR sky130_fd_sc_hd__fill_2
XFILLER_92_299 VGND VGND VPWR VPWR sky130_fd_sc_hd__decap_3
XFILLER_33_333 VGND VGND VPWR VPWR sky130_fd_sc_hd__decap_3
XFILLER_60_130 VGND VGND VPWR VPWR sky130_fd_sc_hd__fill_1
XFILLER_73_491 VGND VGND VPWR VPWR sky130_fd_sc_hd__decap_3
X_4830_ _4713_/B _4830_/B _4830_/C VGND VGND VPWR VPWR _4830_/X sky130_fd_sc_hd__and3b_2
XFILLER_33_366 VGND VGND VPWR VPWR sky130_fd_sc_hd__decap_3
XFILLER_60_141 VGND VGND VPWR VPWR sky130_fd_sc_hd__decap_3
XFILLER_60_185 VGND VGND VPWR VPWR sky130_fd_sc_hd__fill_1
X_4761_ _4747_/B _4747_/C _4747_/A VGND VGND VPWR VPWR _4761_/Y sky130_fd_sc_hd__a21oi_2
X_6500_ _6409_/X _6430_/Y _6569_/B VGND VGND VPWR VPWR _6500_/X sky130_fd_sc_hd__mux2_1
X_4692_ _4693_/A _4693_/B VGND VGND VPWR VPWR _4692_/X sky130_fd_sc_hd__and2_2
X_3712_ _4282_/A _3712_/B VGND VGND VPWR VPWR _3743_/A sky130_fd_sc_hd__nand2_2
XTAP_TAPCELL_ROW_31_545 VGND VPWR sky130_fd_sc_hd__tapvpwrvgnd_1
X_6431_ _6429_/X _6430_/Y _6434_/S VGND VGND VPWR VPWR _6431_/X sky130_fd_sc_hd__mux2_1
X_3643_ _3608_/A _6029_/A2 _3609_/A _3608_/D VGND VGND VPWR VPWR _3644_/C sky130_fd_sc_hd__a22o_2
X_6362_ _6355_/X _6360_/X _6361_/X _6357_/X _5585_/B _6569_/A VGND VGND VPWR VPWR
+ _6370_/A sky130_fd_sc_hd__mux4_2
X_5313_ _5313_/A _5313_/B _5346_/A _5313_/D VGND VGND VPWR VPWR _5346_/B sky130_fd_sc_hd__nand4_2
X_3574_ _4636_/C _3574_/A2 _3573_/B _3570_/X VGND VGND VPWR VPWR _3575_/C sky130_fd_sc_hd__a31o_2
XFILLER_88_517 VGND VGND VPWR VPWR sky130_fd_sc_hd__decap_3
X_6293_ _6332_/C _6342_/A VGND VGND VPWR VPWR _6767_/A sky130_fd_sc_hd__or2_2
X_5244_ _5830_/A _5244_/B _5244_/C VGND VGND VPWR VPWR _5244_/X sky130_fd_sc_hd__or3_4
X_5175_ _5091_/Y _5092_/X _5084_/X _5089_/C VGND VGND VPWR VPWR _5175_/X sky130_fd_sc_hd__a211o_2
XFILLER_28_105 VGND VGND VPWR VPWR sky130_fd_sc_hd__decap_3
X_4126_ _4126_/A _4126_/B _4126_/C VGND VGND VPWR VPWR _4237_/A sky130_fd_sc_hd__or3_4
XFILLER_68_296 VGND VGND VPWR VPWR sky130_fd_sc_hd__decap_3
XTAP_TAPCELL_ROW_67_921 VGND VPWR sky130_fd_sc_hd__tapvpwrvgnd_1
XTAP_TAPCELL_ROW_3_248 VGND VPWR sky130_fd_sc_hd__tapvpwrvgnd_1
XTAP_TAPCELL_ROW_39_623 VGND VPWR sky130_fd_sc_hd__tapvpwrvgnd_1
XFILLER_71_406 VGND VGND VPWR VPWR sky130_fd_sc_hd__decap_3
XFILLER_83_255 VGND VGND VPWR VPWR sky130_fd_sc_hd__decap_3
X_4057_ _4057_/A _4057_/B VGND VGND VPWR VPWR _4059_/B sky130_fd_sc_hd__nand2_2
XFILLER_64_480 VGND VGND VPWR VPWR sky130_fd_sc_hd__decap_3
XFILLER_83_299 VGND VGND VPWR VPWR sky130_fd_sc_hd__decap_3
XFILLER_24_344 VGND VGND VPWR VPWR sky130_fd_sc_hd__decap_3
XFILLER_24_388 VGND VGND VPWR VPWR sky130_fd_sc_hd__decap_3
X_4959_ _5306_/A _5341_/C _5341_/D _5134_/A VGND VGND VPWR VPWR _4960_/B sky130_fd_sc_hd__a22o_2
X_6629_ _6213_/B _6717_/B _6797_/A2 _4705_/Y VGND VGND VPWR VPWR _6629_/X sky130_fd_sc_hd__o22a_2
XFILLER_3_237 VGND VGND VPWR VPWR sky130_fd_sc_hd__decap_3
XFILLER_86_35 VGND VGND VPWR VPWR sky130_fd_sc_hd__decap_3
XFILLER_86_46 VGND VGND VPWR VPWR sky130_fd_sc_hd__decap_3
XFILLER_47_414 VGND VGND VPWR VPWR sky130_fd_sc_hd__decap_3
XFILLER_59_252 VGND VGND VPWR VPWR sky130_fd_sc_hd__decap_3
XFILLER_87_561 VGND VGND VPWR VPWR sky130_fd_sc_hd__decap_3
XFILLER_19_73 VGND VGND VPWR VPWR sky130_fd_sc_hd__decap_3
XFILLER_47_447 VGND VGND VPWR VPWR sky130_fd_sc_hd__fill_1
XFILLER_59_274 VGND VGND VPWR VPWR sky130_fd_sc_hd__decap_3
XFILLER_74_200 VGND VGND VPWR VPWR sky130_fd_sc_hd__decap_3
XFILLER_74_222 VGND VGND VPWR VPWR sky130_fd_sc_hd__decap_3
XFILLER_87_594 VGND VGND VPWR VPWR sky130_fd_sc_hd__decap_3
XFILLER_47_458 VGND VGND VPWR VPWR sky130_fd_sc_hd__fill_1
XFILLER_62_417 VGND VGND VPWR VPWR sky130_fd_sc_hd__decap_3
XFILLER_74_299 VGND VGND VPWR VPWR sky130_fd_sc_hd__fill_2
XFILLER_15_333 VGND VGND VPWR VPWR sky130_fd_sc_hd__decap_3
XFILLER_42_130 VGND VGND VPWR VPWR sky130_fd_sc_hd__decap_3
XTAP_TAPCELL_ROW_73_979 VGND VPWR sky130_fd_sc_hd__tapvpwrvgnd_1
XFILLER_35_83 VGND VGND VPWR VPWR sky130_fd_sc_hd__decap_3
XFILLER_42_185 VGND VGND VPWR VPWR sky130_fd_sc_hd__decap_3
XFILLER_11_561 VGND VGND VPWR VPWR sky130_fd_sc_hd__decap_3
XFILLER_7_532 VGND VGND VPWR VPWR sky130_fd_sc_hd__decap_3
XFILLER_7_576 VGND VGND VPWR VPWR sky130_fd_sc_hd__decap_3
XTAP_TAPCELL_ROW_77_1027 VGND VPWR sky130_fd_sc_hd__tapvpwrvgnd_1
Xwire496 wire496/A VGND VGND VPWR VPWR wire496/X sky130_fd_sc_hd__buf_6
XFILLER_97_314 VGND VGND VPWR VPWR sky130_fd_sc_hd__decap_3
XFILLER_18_3 VGND VGND VPWR VPWR sky130_fd_sc_hd__decap_3
XFILLER_65_200 VGND VGND VPWR VPWR sky130_fd_sc_hd__decap_3
XFILLER_65_222 VGND VGND VPWR VPWR sky130_fd_sc_hd__fill_2
XFILLER_78_594 VGND VGND VPWR VPWR sky130_fd_sc_hd__decap_3
XFILLER_93_520 VGND VGND VPWR VPWR sky130_fd_sc_hd__decap_3
XFILLER_53_406 VGND VGND VPWR VPWR sky130_fd_sc_hd__decap_3
XFILLER_65_266 VGND VGND VPWR VPWR sky130_fd_sc_hd__decap_3
X_6980_ _6764_/A _6974_/X _6976_/X _6371_/Y _6979_/Y VGND VGND VPWR VPWR _6980_/X
+ sky130_fd_sc_hd__a221o_2
XTAP_TAPCELL_ROW_88_1145 VGND VPWR sky130_fd_sc_hd__tapvpwrvgnd_1
XTAP_TAPCELL_ROW_0_218 VGND VPWR sky130_fd_sc_hd__tapvpwrvgnd_1
XTAP_TAPCELL_ROW_0_207 VGND VPWR sky130_fd_sc_hd__tapvpwrvgnd_1
XFILLER_93_575 VGND VGND VPWR VPWR sky130_fd_sc_hd__decap_3
XFILLER_53_439 VGND VGND VPWR VPWR sky130_fd_sc_hd__decap_3
XFILLER_80_203 VGND VGND VPWR VPWR sky130_fd_sc_hd__decap_3
X_5931_ _5931_/A _5931_/B _5931_/C VGND VGND VPWR VPWR _5933_/B sky130_fd_sc_hd__and3_2
XFILLER_33_130 VGND VGND VPWR VPWR sky130_fd_sc_hd__decap_3
XFILLER_61_461 VGND VGND VPWR VPWR sky130_fd_sc_hd__fill_1
X_5862_ _5862_/A _5862_/B _5862_/C VGND VGND VPWR VPWR _5862_/Y sky130_fd_sc_hd__nand3_2
XFILLER_33_196 VGND VGND VPWR VPWR sky130_fd_sc_hd__decap_3
X_5793_ _5793_/A _5793_/B VGND VGND VPWR VPWR _5796_/B sky130_fd_sc_hd__nor2_2
X_4813_ _4813_/A _4813_/B _4813_/C VGND VGND VPWR VPWR _4816_/B sky130_fd_sc_hd__nand3_2
XTAP_TAPCELL_ROW_44_681 VGND VPWR sky130_fd_sc_hd__tapvpwrvgnd_1
XTAP_TAPCELL_ROW_16_383 VGND VPWR sky130_fd_sc_hd__tapvpwrvgnd_1
XFILLER_21_358 VGND VGND VPWR VPWR sky130_fd_sc_hd__decap_3
X_4744_ _4744_/A _4744_/B _4744_/C VGND VGND VPWR VPWR _4747_/B sky130_fd_sc_hd__nand3_4
XTAP_TAPCELL_ROW_99_1252 VGND VPWR sky130_fd_sc_hd__tapvpwrvgnd_1
X_4675_ _4675_/A _4675_/B VGND VGND VPWR VPWR _4678_/B sky130_fd_sc_hd__xnor2_2
X_6414_ _6411_/X _6545_/B _6414_/S VGND VGND VPWR VPWR _6415_/B sky130_fd_sc_hd__mux2_1
X_3626_ _3626_/A _3812_/A _3933_/B _3933_/D VGND VGND VPWR VPWR _3629_/A sky130_fd_sc_hd__and4_2
X_6345_ _6313_/A _6344_/X _6340_/X _6327_/Y VGND VGND VPWR VPWR _6345_/X sky130_fd_sc_hd__o211a_2
X_3557_ _3972_/A _3976_/B VGND VGND VPWR VPWR _3562_/A sky130_fd_sc_hd__nand2_2
X_6276_ _6276_/A _6384_/C _6182_/B VGND VGND VPWR VPWR _6276_/X sky130_fd_sc_hd__or3b_2
X_5227_ _5395_/A _5399_/B _5226_/B _5223_/X VGND VGND VPWR VPWR _5231_/A sky130_fd_sc_hd__a31oi_2
X_3488_ _5268_/C VGND VGND VPWR VPWR _6212_/A sky130_fd_sc_hd__inv_2
XFILLER_69_550 VGND VGND VPWR VPWR sky130_fd_sc_hd__fill_2
XFILLER_69_572 VGND VGND VPWR VPWR sky130_fd_sc_hd__fill_2
XFILLER_56_27 VGND VGND VPWR VPWR sky130_fd_sc_hd__fill_1
XFILLER_69_594 VGND VGND VPWR VPWR sky130_fd_sc_hd__decap_3
X_5158_ _5452_/A _5284_/B VGND VGND VPWR VPWR _5222_/A sky130_fd_sc_hd__nand2_2
XFILLER_29_458 VGND VGND VPWR VPWR sky130_fd_sc_hd__decap_3
XFILLER_84_564 VGND VGND VPWR VPWR sky130_fd_sc_hd__decap_3
X_5089_ _5089_/A _5089_/B _5089_/C _5089_/D VGND VGND VPWR VPWR _5089_/X sky130_fd_sc_hd__or4_4
X_4109_ _4109_/A _4109_/B _4109_/C VGND VGND VPWR VPWR _4225_/A sky130_fd_sc_hd__and3_2
XFILLER_44_406 VGND VGND VPWR VPWR sky130_fd_sc_hd__fill_2
XFILLER_56_277 VGND VGND VPWR VPWR sky130_fd_sc_hd__decap_3
XFILLER_56_299 VGND VGND VPWR VPWR sky130_fd_sc_hd__decap_3
XFILLER_71_225 VGND VGND VPWR VPWR sky130_fd_sc_hd__decap_3
XFILLER_71_258 VGND VGND VPWR VPWR sky130_fd_sc_hd__decap_3
XFILLER_24_141 VGND VGND VPWR VPWR sky130_fd_sc_hd__decap_3
XFILLER_24_163 VGND VGND VPWR VPWR sky130_fd_sc_hd__decap_3
XTAP_TAPCELL_ROW_70_949 VGND VPWR sky130_fd_sc_hd__tapvpwrvgnd_1
XFILLER_8_307 VGND VGND VPWR VPWR sky130_fd_sc_hd__fill_1
XFILLER_8_318 VGND VGND VPWR VPWR sky130_fd_sc_hd__decap_3
XFILLER_21_41 VGND VGND VPWR VPWR sky130_fd_sc_hd__decap_3
XFILLER_94_306 VGND VGND VPWR VPWR sky130_fd_sc_hd__fill_2
XFILLER_75_531 VGND VGND VPWR VPWR sky130_fd_sc_hd__decap_3
XFILLER_87_391 VGND VGND VPWR VPWR sky130_fd_sc_hd__fill_1
XFILLER_75_564 VGND VGND VPWR VPWR sky130_fd_sc_hd__decap_3
XFILLER_62_203 VGND VGND VPWR VPWR sky130_fd_sc_hd__decap_3
XFILLER_28_480 VGND VGND VPWR VPWR sky130_fd_sc_hd__fill_2
XFILLER_46_71 VGND VGND VPWR VPWR sky130_fd_sc_hd__fill_2
XFILLER_62_236 VGND VGND VPWR VPWR sky130_fd_sc_hd__decap_3
XFILLER_15_152 VGND VGND VPWR VPWR sky130_fd_sc_hd__decap_3
XFILLER_90_589 VGND VGND VPWR VPWR sky130_fd_sc_hd__decap_3
XFILLER_30_100 VGND VGND VPWR VPWR sky130_fd_sc_hd__decap_3
XFILLER_70_280 VGND VGND VPWR VPWR sky130_fd_sc_hd__decap_3
XTAP_TAPCELL_ROW_83_1086 VGND VPWR sky130_fd_sc_hd__tapvpwrvgnd_1
XTAP_TAPCELL_ROW_41_651 VGND VPWR sky130_fd_sc_hd__tapvpwrvgnd_1
XFILLER_30_166 VGND VGND VPWR VPWR sky130_fd_sc_hd__decap_3
XTAP_TAPCELL_ROW_13_353 VGND VPWR sky130_fd_sc_hd__tapvpwrvgnd_1
XFILLER_11_380 VGND VGND VPWR VPWR sky130_fd_sc_hd__decap_3
XFILLER_7_32 VGND VGND VPWR VPWR sky130_fd_sc_hd__decap_3
XFILLER_7_362 VGND VGND VPWR VPWR sky130_fd_sc_hd__decap_3
Xwire282 wire282/A VGND VGND VPWR VPWR _5585_/B sky130_fd_sc_hd__buf_4
X_4460_ _4600_/A _4460_/B VGND VGND VPWR VPWR _4835_/A sky130_fd_sc_hd__xnor2_2
X_4391_ _4392_/A _6378_/A _4391_/C VGND VGND VPWR VPWR _4392_/B sky130_fd_sc_hd__nand3_2
X_6130_ _6506_/A _6129_/B _5585_/Y VGND VGND VPWR VPWR _6130_/Y sky130_fd_sc_hd__o21ai_2
XFILLER_3_590 VGND VGND VPWR VPWR sky130_fd_sc_hd__decap_3
Xload_slew221 _3712_/B VGND VGND VPWR VPWR _4518_/B sky130_fd_sc_hd__buf_4
X_6061_ _6332_/C _6384_/A VGND VGND VPWR VPWR _6061_/Y sky130_fd_sc_hd__nor2_2
XFILLER_78_380 VGND VGND VPWR VPWR sky130_fd_sc_hd__fill_1
X_5012_ _5012_/A _5012_/B VGND VGND VPWR VPWR _5100_/A sky130_fd_sc_hd__xnor2_2
XFILLER_97_177 VGND VGND VPWR VPWR sky130_fd_sc_hd__decap_3
XFILLER_66_553 VGND VGND VPWR VPWR sky130_fd_sc_hd__decap_3
XFILLER_78_391 VGND VGND VPWR VPWR sky130_fd_sc_hd__decap_3
XFILLER_26_417 VGND VGND VPWR VPWR sky130_fd_sc_hd__decap_3
XFILLER_38_266 VGND VGND VPWR VPWR sky130_fd_sc_hd__decap_3
XFILLER_66_597 VGND VGND VPWR VPWR sky130_fd_sc_hd__fill_1
XFILLER_93_361 VGND VGND VPWR VPWR sky130_fd_sc_hd__decap_3
XFILLER_38_299 VGND VGND VPWR VPWR sky130_fd_sc_hd__decap_3
XFILLER_53_225 VGND VGND VPWR VPWR sky130_fd_sc_hd__decap_3
XFILLER_81_556 VGND VGND VPWR VPWR sky130_fd_sc_hd__decap_3
X_6963_ _6071_/Y _6963_/A2 _6978_/A2 _6197_/B VGND VGND VPWR VPWR _6965_/B sky130_fd_sc_hd__o22a_2
XFILLER_34_450 VGND VGND VPWR VPWR sky130_fd_sc_hd__decap_3
X_6894_ _6831_/X _6893_/X _6976_/S VGND VGND VPWR VPWR _6894_/X sky130_fd_sc_hd__mux2_1
X_5914_ _5915_/A _5915_/B VGND VGND VPWR VPWR _5914_/Y sky130_fd_sc_hd__nor2_2
XFILLER_21_111 VGND VGND VPWR VPWR sky130_fd_sc_hd__fill_1
XFILLER_34_472 VGND VGND VPWR VPWR sky130_fd_sc_hd__decap_3
XFILLER_34_483 VGND VGND VPWR VPWR sky130_fd_sc_hd__decap_3
X_5845_ _5830_/A _5830_/B _5830_/C _5830_/D VGND VGND VPWR VPWR _5846_/C sky130_fd_sc_hd__a22o_4
XFILLER_21_188 VGND VGND VPWR VPWR sky130_fd_sc_hd__decap_3
X_5776_ _5778_/A _6125_/B VGND VGND VPWR VPWR _5799_/A sky130_fd_sc_hd__nand2_2
X_4727_ _4748_/B _5321_/C _5321_/D _4749_/A VGND VGND VPWR VPWR _4728_/C sky130_fd_sc_hd__a22o_2
X_4658_ _4676_/A _4676_/B _4676_/C VGND VGND VPWR VPWR _4678_/A sky130_fd_sc_hd__o21a_2
X_3609_ _3609_/A _3644_/A VGND VGND VPWR VPWR _3611_/B sky130_fd_sc_hd__nand2_2
X_4589_ _6265_/B _4589_/B VGND VGND VPWR VPWR _4867_/A sky130_fd_sc_hd__nand2_2
XFILLER_1_538 VGND VGND VPWR VPWR sky130_fd_sc_hd__decap_3
X_6328_ _6336_/A _6353_/C VGND VGND VPWR VPWR _6384_/D sky130_fd_sc_hd__nand2_2
XFILLER_76_306 VGND VGND VPWR VPWR sky130_fd_sc_hd__fill_2
XFILLER_88_144 VGND VGND VPWR VPWR sky130_fd_sc_hd__decap_3
X_6259_ _6808_/A _6808_/B VGND VGND VPWR VPWR _6260_/B sky130_fd_sc_hd__or2_2
XFILLER_69_380 VGND VGND VPWR VPWR sky130_fd_sc_hd__decap_3
XFILLER_88_177 VGND VGND VPWR VPWR sky130_fd_sc_hd__decap_3
XFILLER_91_309 VGND VGND VPWR VPWR sky130_fd_sc_hd__fill_1
XFILLER_44_214 VGND VGND VPWR VPWR sky130_fd_sc_hd__decap_3
XFILLER_57_597 VGND VGND VPWR VPWR sky130_fd_sc_hd__fill_1
XFILLER_72_556 VGND VGND VPWR VPWR sky130_fd_sc_hd__decap_3
XFILLER_83_36 VGND VGND VPWR VPWR sky130_fd_sc_hd__fill_1
XFILLER_84_383 VGND VGND VPWR VPWR sky130_fd_sc_hd__decap_3
XFILLER_16_52 VGND VGND VPWR VPWR sky130_fd_sc_hd__decap_3
XFILLER_72_589 VGND VGND VPWR VPWR sky130_fd_sc_hd__decap_3
XFILLER_16_85 VGND VGND VPWR VPWR sky130_fd_sc_hd__fill_2
XTAP_TAPCELL_ROW_55_798 VGND VPWR sky130_fd_sc_hd__tapvpwrvgnd_1
XPHY_EDGE_ROW_17_Left_118 VGND VGND VPWR VPWR sky130_fd_sc_hd__decap_3
XPHY_EDGE_ROW_11_Right_11 VGND VGND VPWR VPWR sky130_fd_sc_hd__decap_3
XFILLER_12_144 VGND VGND VPWR VPWR sky130_fd_sc_hd__decap_3
XFILLER_40_453 VGND VGND VPWR VPWR sky130_fd_sc_hd__decap_3
XFILLER_12_188 VGND VGND VPWR VPWR sky130_fd_sc_hd__decap_3
XTAP_TAPCELL_ROW_10_323 VGND VPWR sky130_fd_sc_hd__tapvpwrvgnd_1
XFILLER_4_332 VGND VGND VPWR VPWR sky130_fd_sc_hd__decap_3
XPHY_EDGE_ROW_26_Left_127 VGND VGND VPWR VPWR sky130_fd_sc_hd__decap_3
XFILLER_79_100 VGND VGND VPWR VPWR sky130_fd_sc_hd__fill_1
XFILLER_79_111 VGND VGND VPWR VPWR sky130_fd_sc_hd__fill_1
XFILLER_79_133 VGND VGND VPWR VPWR sky130_fd_sc_hd__decap_3
XPHY_EDGE_ROW_20_Right_20 VGND VGND VPWR VPWR sky130_fd_sc_hd__decap_3
XFILLER_79_166 VGND VGND VPWR VPWR sky130_fd_sc_hd__fill_2
XFILLER_0_582 VGND VGND VPWR VPWR sky130_fd_sc_hd__decap_3
XFILLER_67_317 VGND VGND VPWR VPWR sky130_fd_sc_hd__decap_3
XFILLER_57_81 VGND VGND VPWR VPWR sky130_fd_sc_hd__decap_3
XFILLER_63_501 VGND VGND VPWR VPWR sky130_fd_sc_hd__decap_3
XTAP_TAPCELL_ROW_18_401 VGND VPWR sky130_fd_sc_hd__tapvpwrvgnd_1
XFILLER_94_169 VGND VGND VPWR VPWR sky130_fd_sc_hd__fill_2
XFILLER_75_383 VGND VGND VPWR VPWR sky130_fd_sc_hd__fill_2
XFILLER_90_331 VGND VGND VPWR VPWR sky130_fd_sc_hd__decap_3
XFILLER_50_206 VGND VGND VPWR VPWR sky130_fd_sc_hd__decap_3
X_3960_ _3960_/A _5992_/A VGND VGND VPWR VPWR _3964_/A sky130_fd_sc_hd__nand2_2
XPHY_EDGE_ROW_35_Left_136 VGND VGND VPWR VPWR sky130_fd_sc_hd__decap_3
XFILLER_16_483 VGND VGND VPWR VPWR sky130_fd_sc_hd__decap_3
XFILLER_31_420 VGND VGND VPWR VPWR sky130_fd_sc_hd__decap_3
XFILLER_50_239 VGND VGND VPWR VPWR sky130_fd_sc_hd__decap_3
X_3891_ _6008_/B _5992_/A VGND VGND VPWR VPWR _3895_/A sky130_fd_sc_hd__nand2_2
X_5630_ _5630_/A _5727_/B VGND VGND VPWR VPWR _5632_/B sky130_fd_sc_hd__nand2_2
X_5561_ _5560_/A _5560_/C _5606_/A VGND VGND VPWR VPWR _5562_/C sky130_fd_sc_hd__o21ai_2
X_5492_ _5588_/A _5490_/C _5492_/B1 _5630_/A VGND VGND VPWR VPWR _5493_/B sky130_fd_sc_hd__a22o_2
X_4512_ _4392_/B _4504_/X _4509_/A _4508_/Y VGND VGND VPWR VPWR _4513_/B sky130_fd_sc_hd__a211o_2
XTAP_TAPCELL_ROW_96_1222 VGND VPWR sky130_fd_sc_hd__tapvpwrvgnd_1
XPHY_EDGE_ROW_44_Left_145 VGND VGND VPWR VPWR sky130_fd_sc_hd__decap_3
X_4443_ _4313_/Y _4328_/X _4440_/A _4441_/X VGND VGND VPWR VPWR _4443_/Y sky130_fd_sc_hd__a211oi_2
Xfanout606 input2/X VGND VGND VPWR VPWR _4263_/A sky130_fd_sc_hd__clkbuf_2
X_4374_ _4370_/Y _4473_/A _4352_/Y _4350_/X VGND VGND VPWR VPWR _4378_/C sky130_fd_sc_hd__a211oi_4
XFILLER_58_306 VGND VGND VPWR VPWR sky130_fd_sc_hd__fill_2
Xfanout617 input16/X VGND VGND VPWR VPWR _3679_/A sky130_fd_sc_hd__clkdlybuf4s25_1
X_6113_ _6114_/A _6114_/B VGND VGND VPWR VPWR _6584_/A sky130_fd_sc_hd__nor2_2
XFILLER_98_464 VGND VGND VPWR VPWR sky130_fd_sc_hd__decap_3
XFILLER_98_453 VGND VGND VPWR VPWR sky130_fd_sc_hd__decap_3
XFILLER_58_339 VGND VGND VPWR VPWR sky130_fd_sc_hd__decap_3
XFILLER_85_125 VGND VGND VPWR VPWR sky130_fd_sc_hd__decap_3
X_6044_ _6044_/A _6044_/B VGND VGND VPWR VPWR _6045_/B sky130_fd_sc_hd__xnor2_2
XFILLER_100_447 VGND VGND VPWR VPWR sky130_fd_sc_hd__fill_1
XFILLER_100_458 VGND VGND VPWR VPWR sky130_fd_sc_hd__decap_3
XFILLER_37_29 VGND VGND VPWR VPWR sky130_fd_sc_hd__fill_1
XFILLER_39_542 VGND VGND VPWR VPWR sky130_fd_sc_hd__decap_3
XFILLER_26_203 VGND VGND VPWR VPWR sky130_fd_sc_hd__fill_2
XFILLER_73_309 VGND VGND VPWR VPWR sky130_fd_sc_hd__decap_3
XFILLER_85_169 VGND VGND VPWR VPWR sky130_fd_sc_hd__decap_3
XFILLER_54_545 VGND VGND VPWR VPWR sky130_fd_sc_hd__fill_1
XFILLER_66_383 VGND VGND VPWR VPWR sky130_fd_sc_hd__decap_3
XFILLER_81_320 VGND VGND VPWR VPWR sky130_fd_sc_hd__decap_3
XPHY_EDGE_ROW_53_Left_154 VGND VGND VPWR VPWR sky130_fd_sc_hd__decap_3
XFILLER_41_206 VGND VGND VPWR VPWR sky130_fd_sc_hd__decap_3
XFILLER_54_589 VGND VGND VPWR VPWR sky130_fd_sc_hd__decap_3
X_6946_ _6946_/A _6946_/B _6946_/C VGND VGND VPWR VPWR _6949_/A sky130_fd_sc_hd__or3_2
XFILLER_41_239 VGND VGND VPWR VPWR sky130_fd_sc_hd__decap_3
XFILLER_34_291 VGND VGND VPWR VPWR sky130_fd_sc_hd__fill_2
X_6877_ _6814_/X _6876_/X _6939_/S VGND VGND VPWR VPWR _6877_/X sky130_fd_sc_hd__mux2_1
XTAP_TAPCELL_ROW_52_768 VGND VPWR sky130_fd_sc_hd__tapvpwrvgnd_1
XFILLER_22_475 VGND VGND VPWR VPWR sky130_fd_sc_hd__fill_1
X_5828_ _5450_/Y _5829_/C1 _5828_/B1 _5827_/Y VGND VGND VPWR VPWR _5830_/C sky130_fd_sc_hd__o211ai_4
X_5759_ _5809_/A _5809_/B VGND VGND VPWR VPWR _5759_/Y sky130_fd_sc_hd__nor2_2
XPHY_EDGE_ROW_62_Left_163 VGND VGND VPWR VPWR sky130_fd_sc_hd__decap_3
XFILLER_1_302 VGND VGND VPWR VPWR sky130_fd_sc_hd__decap_3
XFILLER_49_317 VGND VGND VPWR VPWR sky130_fd_sc_hd__decap_3
XFILLER_89_486 VGND VGND VPWR VPWR sky130_fd_sc_hd__fill_1
XFILLER_76_136 VGND VGND VPWR VPWR sky130_fd_sc_hd__decap_3
XFILLER_76_147 VGND VGND VPWR VPWR sky130_fd_sc_hd__decap_3
XPHY_EDGE_ROW_71_Left_172 VGND VGND VPWR VPWR sky130_fd_sc_hd__decap_3
XFILLER_64_309 VGND VGND VPWR VPWR sky130_fd_sc_hd__decap_3
XFILLER_17_214 VGND VGND VPWR VPWR sky130_fd_sc_hd__decap_3
XFILLER_17_225 VGND VGND VPWR VPWR sky130_fd_sc_hd__decap_3
XFILLER_45_523 VGND VGND VPWR VPWR sky130_fd_sc_hd__decap_3
XFILLER_84_191 VGND VGND VPWR VPWR sky130_fd_sc_hd__decap_3
XFILLER_94_79 VGND VGND VPWR VPWR sky130_fd_sc_hd__decap_3
XFILLER_17_247 VGND VGND VPWR VPWR sky130_fd_sc_hd__decap_3
XFILLER_60_526 VGND VGND VPWR VPWR sky130_fd_sc_hd__decap_3
XFILLER_72_375 VGND VGND VPWR VPWR sky130_fd_sc_hd__decap_3
XFILLER_13_464 VGND VGND VPWR VPWR sky130_fd_sc_hd__decap_3
XTAP_TAPCELL_ROW_80_1056 VGND VPWR sky130_fd_sc_hd__tapvpwrvgnd_1
XFILLER_9_435 VGND VGND VPWR VPWR sky130_fd_sc_hd__fill_1
XFILLER_9_413 VGND VGND VPWR VPWR sky130_fd_sc_hd__decap_3
XFILLER_40_283 VGND VGND VPWR VPWR sky130_fd_sc_hd__decap_3
XPHY_EDGE_ROW_80_Left_181 VGND VGND VPWR VPWR sky130_fd_sc_hd__decap_3
XFILLER_4_22 VGND VGND VPWR VPWR sky130_fd_sc_hd__decap_3
XFILLER_99_228 VGND VGND VPWR VPWR sky130_fd_sc_hd__decap_3
XFILLER_4_44 VGND VGND VPWR VPWR sky130_fd_sc_hd__decap_3
XTAP_TAPCELL_ROW_91_1174 VGND VPWR sky130_fd_sc_hd__tapvpwrvgnd_1
XFILLER_95_423 VGND VGND VPWR VPWR sky130_fd_sc_hd__decap_3
XFILLER_0_390 VGND VGND VPWR VPWR sky130_fd_sc_hd__fill_2
XFILLER_67_136 VGND VGND VPWR VPWR sky130_fd_sc_hd__decap_3
XFILLER_67_158 VGND VGND VPWR VPWR sky130_fd_sc_hd__fill_1
X_4090_ _4090_/A _4090_/B VGND VGND VPWR VPWR _4221_/B sky130_fd_sc_hd__nor2_2
XFILLER_95_467 VGND VGND VPWR VPWR sky130_fd_sc_hd__decap_3
XFILLER_48_350 VGND VGND VPWR VPWR sky130_fd_sc_hd__fill_1
XFILLER_55_309 VGND VGND VPWR VPWR sky130_fd_sc_hd__decap_3
XFILLER_67_169 VGND VGND VPWR VPWR sky130_fd_sc_hd__decap_3
XFILLER_82_117 VGND VGND VPWR VPWR sky130_fd_sc_hd__decap_3
XFILLER_36_545 VGND VGND VPWR VPWR sky130_fd_sc_hd__decap_3
XFILLER_36_567 VGND VGND VPWR VPWR sky130_fd_sc_hd__decap_3
XFILLER_75_191 VGND VGND VPWR VPWR sky130_fd_sc_hd__decap_3
X_6800_ _6299_/X _6324_/X _6976_/S VGND VGND VPWR VPWR _6800_/X sky130_fd_sc_hd__mux2_1
XFILLER_23_228 VGND VGND VPWR VPWR sky130_fd_sc_hd__decap_3
XFILLER_36_589 VGND VGND VPWR VPWR sky130_fd_sc_hd__decap_3
XFILLER_51_537 VGND VGND VPWR VPWR sky130_fd_sc_hd__decap_3
X_4992_ _4806_/A _4806_/B _4806_/C VGND VGND VPWR VPWR _4993_/C sky130_fd_sc_hd__a21o_2
XFILLER_16_291 VGND VGND VPWR VPWR sky130_fd_sc_hd__decap_3
XFILLER_51_559 VGND VGND VPWR VPWR sky130_fd_sc_hd__fill_1
X_6731_ _6731_/A _6731_/B VGND VGND VPWR VPWR _6965_/A sky130_fd_sc_hd__nand2_2
X_3943_ _3834_/D _3941_/X _3942_/X VGND VGND VPWR VPWR _3945_/A sky130_fd_sc_hd__a21bo_2
X_6662_ _6378_/B _6717_/B _6927_/B1 _4389_/Y VGND VGND VPWR VPWR _6662_/X sky130_fd_sc_hd__o22a_2
X_3874_ _4176_/A _5953_/A2 _3509_/B _3507_/X VGND VGND VPWR VPWR _3876_/B sky130_fd_sc_hd__a31o_2
X_5613_ _5500_/X _5502_/X _5611_/A _5612_/X VGND VGND VPWR VPWR _5613_/X sky130_fd_sc_hd__o211a_2
XTAP_TAPCELL_ROW_100_1270 VGND VPWR sky130_fd_sc_hd__tapvpwrvgnd_1
X_6593_ _6307_/X _6372_/B _6392_/Y _6867_/B VGND VGND VPWR VPWR _6594_/C sky130_fd_sc_hd__o2bb2a_2
XTAP_TAPCELL_ROW_100_1281 VGND VPWR sky130_fd_sc_hd__tapvpwrvgnd_1
X_5544_ _5547_/A _5576_/D VGND VGND VPWR VPWR _5577_/A sky130_fd_sc_hd__nand2_2
X_5475_ _5475_/A _5475_/B VGND VGND VPWR VPWR _5486_/B sky130_fd_sc_hd__xnor2_2
X_4426_ _4900_/A _4568_/B VGND VGND VPWR VPWR _4428_/B sky130_fd_sc_hd__and2_2
Xfanout403 input39/X VGND VGND VPWR VPWR _4925_/D sky130_fd_sc_hd__clkdlybuf4s25_1
XFILLER_48_39 VGND VGND VPWR VPWR sky130_fd_sc_hd__decap_3
XFILLER_86_401 VGND VGND VPWR VPWR sky130_fd_sc_hd__decap_3
Xfanout425 _6144_/B VGND VGND VPWR VPWR _4944_/D sky130_fd_sc_hd__buf_4
Xfanout436 input35/X VGND VGND VPWR VPWR _4608_/B sky130_fd_sc_hd__clkdlybuf4s25_1
Xfanout447 _6492_/S0 VGND VGND VPWR VPWR _5487_/B sky130_fd_sc_hd__clkdlybuf4s25_1
X_4357_ _4354_/X _4357_/B VGND VGND VPWR VPWR _4461_/B sky130_fd_sc_hd__and2b_2
XFILLER_100_233 VGND VGND VPWR VPWR sky130_fd_sc_hd__decap_3
XFILLER_58_125 VGND VGND VPWR VPWR sky130_fd_sc_hd__decap_3
XFILLER_58_147 VGND VGND VPWR VPWR sky130_fd_sc_hd__fill_2
X_4288_ _4272_/X wire118/X _4172_/X _4260_/Y VGND VGND VPWR VPWR _4309_/A sky130_fd_sc_hd__o211ai_2
XFILLER_98_294 VGND VGND VPWR VPWR sky130_fd_sc_hd__decap_3
XFILLER_100_277 VGND VGND VPWR VPWR sky130_fd_sc_hd__decap_3
XFILLER_46_309 VGND VGND VPWR VPWR sky130_fd_sc_hd__decap_3
XFILLER_58_158 VGND VGND VPWR VPWR sky130_fd_sc_hd__decap_3
XFILLER_86_467 VGND VGND VPWR VPWR sky130_fd_sc_hd__fill_2
X_6027_ _6027_/A _6027_/B VGND VGND VPWR VPWR _6032_/A sky130_fd_sc_hd__xnor2_2
XTAP_TAPCELL_ROW_57_816 VGND VPWR sky130_fd_sc_hd__tapvpwrvgnd_1
XTAP_TAPCELL_ROW_29_518 VGND VPWR sky130_fd_sc_hd__tapvpwrvgnd_1
XFILLER_100_299 VGND VGND VPWR VPWR sky130_fd_sc_hd__decap_3
XFILLER_39_383 VGND VGND VPWR VPWR sky130_fd_sc_hd__fill_1
XFILLER_66_180 VGND VGND VPWR VPWR sky130_fd_sc_hd__fill_1
XFILLER_73_128 VGND VGND VPWR VPWR sky130_fd_sc_hd__decap_3
XFILLER_27_578 VGND VGND VPWR VPWR sky130_fd_sc_hd__decap_3
XFILLER_64_38 VGND VGND VPWR VPWR sky130_fd_sc_hd__decap_3
XFILLER_14_206 VGND VGND VPWR VPWR sky130_fd_sc_hd__fill_1
XFILLER_14_217 VGND VGND VPWR VPWR sky130_fd_sc_hd__decap_3
XFILLER_81_161 VGND VGND VPWR VPWR sky130_fd_sc_hd__decap_3
XFILLER_81_172 VGND VGND VPWR VPWR sky130_fd_sc_hd__decap_3
X_6929_ _6929_/A _6929_/B VGND VGND VPWR VPWR _6930_/C sky130_fd_sc_hd__and2_2
XFILLER_22_250 VGND VGND VPWR VPWR sky130_fd_sc_hd__fill_2
XFILLER_80_37 VGND VGND VPWR VPWR sky130_fd_sc_hd__decap_3
XFILLER_13_31 VGND VGND VPWR VPWR sky130_fd_sc_hd__decap_3
XFILLER_22_272 VGND VGND VPWR VPWR sky130_fd_sc_hd__decap_3
XFILLER_89_24 VGND VGND VPWR VPWR sky130_fd_sc_hd__fill_1
XFILLER_49_103 VGND VGND VPWR VPWR sky130_fd_sc_hd__decap_3
XFILLER_89_261 VGND VGND VPWR VPWR sky130_fd_sc_hd__decap_3
XFILLER_1_198 VGND VGND VPWR VPWR sky130_fd_sc_hd__decap_3
XFILLER_49_136 VGND VGND VPWR VPWR sky130_fd_sc_hd__decap_3
XFILLER_77_445 VGND VGND VPWR VPWR sky130_fd_sc_hd__decap_3
XFILLER_49_169 VGND VGND VPWR VPWR sky130_fd_sc_hd__decap_3
XFILLER_92_415 VGND VGND VPWR VPWR sky130_fd_sc_hd__decap_3
XFILLER_18_512 VGND VGND VPWR VPWR sky130_fd_sc_hd__decap_3
XFILLER_92_459 VGND VGND VPWR VPWR sky130_fd_sc_hd__fill_1
XFILLER_45_353 VGND VGND VPWR VPWR sky130_fd_sc_hd__fill_2
XFILLER_18_589 VGND VGND VPWR VPWR sky130_fd_sc_hd__fill_1
XFILLER_33_537 VGND VGND VPWR VPWR sky130_fd_sc_hd__decap_3
XFILLER_60_312 VGND VGND VPWR VPWR sky130_fd_sc_hd__decap_3
XFILLER_54_71 VGND VGND VPWR VPWR sky130_fd_sc_hd__decap_3
XFILLER_54_82 VGND VGND VPWR VPWR sky130_fd_sc_hd__fill_2
XFILLER_60_345 VGND VGND VPWR VPWR sky130_fd_sc_hd__decap_3
XFILLER_72_183 VGND VGND VPWR VPWR sky130_fd_sc_hd__decap_3
XFILLER_13_272 VGND VGND VPWR VPWR sky130_fd_sc_hd__fill_1
X_3590_ _3590_/A _3590_/B VGND VGND VPWR VPWR _3602_/A sky130_fd_sc_hd__or2_2
XFILLER_9_287 VGND VGND VPWR VPWR sky130_fd_sc_hd__decap_3
X_5260_ _6839_/A _6839_/B VGND VGND VPWR VPWR _5260_/Y sky130_fd_sc_hd__nor2_2
X_4211_ _4593_/A _4593_/B _4334_/C _4211_/D VGND VGND VPWR VPWR _4214_/A sky130_fd_sc_hd__and4_2
XFILLER_68_412 VGND VGND VPWR VPWR sky130_fd_sc_hd__decap_3
X_5191_ _5341_/A _5304_/B _5191_/C VGND VGND VPWR VPWR _5292_/A sky130_fd_sc_hd__and3_2
XFILLER_68_434 VGND VGND VPWR VPWR sky130_fd_sc_hd__decap_3
X_4142_ _4077_/C _4141_/X _4139_/C _4114_/Y VGND VGND VPWR VPWR _4142_/X sky130_fd_sc_hd__a211o_2
XFILLER_95_231 VGND VGND VPWR VPWR sky130_fd_sc_hd__decap_3
XFILLER_28_309 VGND VGND VPWR VPWR sky130_fd_sc_hd__decap_3
XFILLER_83_415 VGND VGND VPWR VPWR sky130_fd_sc_hd__decap_3
X_4073_ _3635_/Y _3636_/X _3653_/Y _3675_/Y VGND VGND VPWR VPWR _4075_/B sky130_fd_sc_hd__o211ai_2
XFILLER_95_275 VGND VGND VPWR VPWR sky130_fd_sc_hd__decap_3
XFILLER_24_559 VGND VGND VPWR VPWR sky130_fd_sc_hd__fill_2
XFILLER_36_397 VGND VGND VPWR VPWR sky130_fd_sc_hd__decap_3
X_4975_ _4762_/X _4973_/Y _4972_/Y _4975_/C1 VGND VGND VPWR VPWR _4991_/B sky130_fd_sc_hd__a211o_4
XFILLER_51_389 VGND VGND VPWR VPWR sky130_fd_sc_hd__decap_3
X_6714_ _6638_/A _6710_/X _6713_/X VGND VGND VPWR VPWR _6714_/Y sky130_fd_sc_hd__a21oi_2
X_3926_ _3926_/A _3926_/B VGND VGND VPWR VPWR _3928_/B sky130_fd_sc_hd__xnor2_2
XTAP_TAPCELL_ROW_62_863 VGND VPWR sky130_fd_sc_hd__tapvpwrvgnd_1
XTAP_TAPCELL_ROW_34_576 VGND VPWR sky130_fd_sc_hd__tapvpwrvgnd_1
XFILLER_32_581 VGND VGND VPWR VPWR sky130_fd_sc_hd__fill_2
XFILLER_32_592 VGND VGND VPWR VPWR sky130_fd_sc_hd__decap_3
X_6645_ _6108_/B _6717_/B _6927_/B1 _6141_/A VGND VGND VPWR VPWR _6645_/X sky130_fd_sc_hd__o22a_2
X_3857_ _3857_/A _3857_/B VGND VGND VPWR VPWR _3858_/B sky130_fd_sc_hd__nor2_2
X_6576_ _6731_/B _6571_/X _6575_/X _6372_/B _6573_/Y VGND VGND VPWR VPWR _6580_/A
+ sky130_fd_sc_hd__a221o_2
X_3788_ _3788_/A _3788_/B VGND VGND VPWR VPWR _3789_/B sky130_fd_sc_hd__nor2_2
XFILLER_3_408 VGND VGND VPWR VPWR sky130_fd_sc_hd__fill_1
X_5527_ _5527_/A _5527_/B VGND VGND VPWR VPWR _5540_/A sky130_fd_sc_hd__xnor2_2
XFILLER_1_9 VGND VGND VPWR VPWR sky130_fd_sc_hd__decap_3
XFILLER_59_49 VGND VGND VPWR VPWR sky130_fd_sc_hd__decap_3
X_5458_ _5458_/A _5458_/B _5458_/C VGND VGND VPWR VPWR _5458_/X sky130_fd_sc_hd__and3_4
XFILLER_59_401 VGND VGND VPWR VPWR sky130_fd_sc_hd__fill_1
Xfanout211 _6016_/C VGND VGND VPWR VPWR _6109_/B sky130_fd_sc_hd__buf_6
Xfanout222 _6014_/C VGND VGND VPWR VPWR _4659_/B sky130_fd_sc_hd__clkbuf_2
X_5389_ _5483_/A _5388_/B _5381_/X VGND VGND VPWR VPWR _5475_/A sky130_fd_sc_hd__a21oi_2
X_4409_ _4409_/A _4409_/B _4409_/C VGND VGND VPWR VPWR _4523_/A sky130_fd_sc_hd__or3_4
XFILLER_99_581 VGND VGND VPWR VPWR sky130_fd_sc_hd__decap_3
XFILLER_59_434 VGND VGND VPWR VPWR sky130_fd_sc_hd__decap_3
XFILLER_59_445 VGND VGND VPWR VPWR sky130_fd_sc_hd__decap_3
XFILLER_86_231 VGND VGND VPWR VPWR sky130_fd_sc_hd__decap_3
Xfanout233 input62/X VGND VGND VPWR VPWR _3851_/B sky130_fd_sc_hd__buf_4
Xfanout255 input6/X VGND VGND VPWR VPWR _5286_/A sky130_fd_sc_hd__buf_6
XFILLER_46_106 VGND VGND VPWR VPWR sky130_fd_sc_hd__decap_3
XFILLER_59_467 VGND VGND VPWR VPWR sky130_fd_sc_hd__fill_1
XFILLER_59_489 VGND VGND VPWR VPWR sky130_fd_sc_hd__decap_3
Xfanout266 input59/X VGND VGND VPWR VPWR _6945_/B1 sky130_fd_sc_hd__buf_6
Xfanout277 input58/X VGND VGND VPWR VPWR _5492_/B1 sky130_fd_sc_hd__dlygate4sd1_1
XTAP_TAPCELL_ROW_6_279 VGND VPWR sky130_fd_sc_hd__tapvpwrvgnd_1
XFILLER_86_286 VGND VGND VPWR VPWR sky130_fd_sc_hd__decap_3
XFILLER_39_180 VGND VGND VPWR VPWR sky130_fd_sc_hd__decap_3
XFILLER_27_386 VGND VGND VPWR VPWR sky130_fd_sc_hd__decap_3
XFILLER_42_312 VGND VGND VPWR VPWR sky130_fd_sc_hd__decap_3
XFILLER_54_150 VGND VGND VPWR VPWR sky130_fd_sc_hd__fill_1
XFILLER_61_109 VGND VGND VPWR VPWR sky130_fd_sc_hd__decap_3
XFILLER_30_529 VGND VGND VPWR VPWR sky130_fd_sc_hd__decap_3
XFILLER_42_356 VGND VGND VPWR VPWR sky130_fd_sc_hd__decap_3
XFILLER_24_74 VGND VGND VPWR VPWR sky130_fd_sc_hd__decap_3
XFILLER_10_220 VGND VGND VPWR VPWR sky130_fd_sc_hd__fill_1
XFILLER_10_253 VGND VGND VPWR VPWR sky130_fd_sc_hd__decap_3
Xload_slew628 _3720_/A VGND VGND VPWR VPWR _6083_/B sky130_fd_sc_hd__clkbuf_4
XFILLER_2_496 VGND VGND VPWR VPWR sky130_fd_sc_hd__fill_1
Xload_slew639 _5321_/A VGND VGND VPWR VPWR _4925_/A sky130_fd_sc_hd__buf_6
XFILLER_1_12 VGND VGND VPWR VPWR sky130_fd_sc_hd__fill_1
XFILLER_1_23 VGND VGND VPWR VPWR sky130_fd_sc_hd__decap_3
XFILLER_77_242 VGND VGND VPWR VPWR sky130_fd_sc_hd__decap_3
XFILLER_77_275 VGND VGND VPWR VPWR sky130_fd_sc_hd__decap_3
XFILLER_92_223 VGND VGND VPWR VPWR sky130_fd_sc_hd__decap_3
XFILLER_18_320 VGND VGND VPWR VPWR sky130_fd_sc_hd__fill_2
XFILLER_80_407 VGND VGND VPWR VPWR sky130_fd_sc_hd__decap_3
XFILLER_92_256 VGND VGND VPWR VPWR sky130_fd_sc_hd__decap_3
XFILLER_18_386 VGND VGND VPWR VPWR sky130_fd_sc_hd__decap_3
XFILLER_45_172 VGND VGND VPWR VPWR sky130_fd_sc_hd__decap_3
XFILLER_73_470 VGND VGND VPWR VPWR sky130_fd_sc_hd__decap_3
XFILLER_60_164 VGND VGND VPWR VPWR sky130_fd_sc_hd__decap_3
X_4760_ _4760_/A _4760_/B _4760_/C VGND VGND VPWR VPWR _4956_/A sky130_fd_sc_hd__nand3_2
X_4691_ _4691_/A _4691_/B VGND VGND VPWR VPWR _4693_/B sky130_fd_sc_hd__xnor2_2
X_3711_ _4406_/B _4280_/B _4517_/C _4517_/D VGND VGND VPWR VPWR _3711_/X sky130_fd_sc_hd__and4_2
XTAP_TAPCELL_ROW_31_546 VGND VPWR sky130_fd_sc_hd__tapvpwrvgnd_1
X_6430_ _6211_/A _6435_/S _5236_/A VGND VGND VPWR VPWR _6430_/Y sky130_fd_sc_hd__o21ai_2
X_3642_ _4607_/B _3639_/B _3641_/B _3638_/X VGND VGND VPWR VPWR _3644_/B sky130_fd_sc_hd__a31o_2
X_6361_ _6373_/A _6126_/A _6552_/A3 _6552_/A2 _6439_/B _6126_/B VGND VGND VPWR VPWR
+ _6361_/X sky130_fd_sc_hd__mux4_2
X_5312_ _5311_/A _5311_/C _5311_/D _5312_/B2 VGND VGND VPWR VPWR _5313_/D sky130_fd_sc_hd__a22o_2
X_3573_ _3570_/X _3573_/B VGND VGND VPWR VPWR _4095_/B sky130_fd_sc_hd__and2b_2
XPHY_EDGE_ROW_49_Right_49 VGND VGND VPWR VPWR sky130_fd_sc_hd__decap_3
X_6292_ _6332_/B _6332_/A VGND VGND VPWR VPWR _6342_/A sky130_fd_sc_hd__nand2b_2
XFILLER_88_529 VGND VGND VPWR VPWR sky130_fd_sc_hd__decap_3
X_5243_ _5164_/B _5164_/A _5164_/C VGND VGND VPWR VPWR _5244_/C sky130_fd_sc_hd__a21oi_2
XFILLER_68_231 VGND VGND VPWR VPWR sky130_fd_sc_hd__decap_3
X_5174_ _5253_/B1 _5170_/B _5172_/X _5173_/Y VGND VGND VPWR VPWR _5174_/Y sky130_fd_sc_hd__a211oi_2
XFILLER_68_264 VGND VGND VPWR VPWR sky130_fd_sc_hd__decap_3
X_4125_ _4607_/B _4361_/C _4361_/D _4505_/B VGND VGND VPWR VPWR _4126_/C sky130_fd_sc_hd__a22oi_2
XFILLER_28_117 VGND VGND VPWR VPWR sky130_fd_sc_hd__fill_1
XFILLER_56_426 VGND VGND VPWR VPWR sky130_fd_sc_hd__fill_1
XTAP_TAPCELL_ROW_67_922 VGND VPWR sky130_fd_sc_hd__tapvpwrvgnd_1
XTAP_TAPCELL_ROW_3_249 VGND VPWR sky130_fd_sc_hd__tapvpwrvgnd_1
XTAP_TAPCELL_ROW_39_624 VGND VPWR sky130_fd_sc_hd__tapvpwrvgnd_1
XFILLER_83_234 VGND VGND VPWR VPWR sky130_fd_sc_hd__decap_3
XFILLER_83_267 VGND VGND VPWR VPWR sky130_fd_sc_hd__decap_3
X_4056_ _4056_/A _4056_/B _4056_/C _4055_/Y VGND VGND VPWR VPWR _4057_/B sky130_fd_sc_hd__or4b_2
XPHY_EDGE_ROW_58_Right_58 VGND VGND VPWR VPWR sky130_fd_sc_hd__decap_3
XFILLER_36_150 VGND VGND VPWR VPWR sky130_fd_sc_hd__fill_2
XFILLER_71_418 VGND VGND VPWR VPWR sky130_fd_sc_hd__decap_3
XFILLER_24_312 VGND VGND VPWR VPWR sky130_fd_sc_hd__decap_3
XFILLER_36_172 VGND VGND VPWR VPWR sky130_fd_sc_hd__decap_3
XFILLER_64_492 VGND VGND VPWR VPWR sky130_fd_sc_hd__fill_1
XFILLER_12_507 VGND VGND VPWR VPWR sky130_fd_sc_hd__decap_3
XFILLER_51_131 VGND VGND VPWR VPWR sky130_fd_sc_hd__fill_1
XFILLER_51_175 VGND VGND VPWR VPWR sky130_fd_sc_hd__fill_1
XFILLER_51_186 VGND VGND VPWR VPWR sky130_fd_sc_hd__decap_3
XFILLER_61_17 VGND VGND VPWR VPWR sky130_fd_sc_hd__decap_3
X_4958_ _4958_/A _5203_/D VGND VGND VPWR VPWR _6138_/A sky130_fd_sc_hd__nand2_2
X_4889_ _4889_/A _4889_/B _4889_/C VGND VGND VPWR VPWR _5885_/B sky130_fd_sc_hd__and3_4
X_3909_ _3972_/A _3977_/A _3977_/B _3909_/D VGND VGND VPWR VPWR _3909_/X sky130_fd_sc_hd__and4_2
XFILLER_20_562 VGND VGND VPWR VPWR sky130_fd_sc_hd__decap_3
X_6628_ _6897_/S _6896_/A _6624_/X VGND VGND VPWR VPWR _6628_/X sky130_fd_sc_hd__o21a_2
XPHY_EDGE_ROW_67_Right_67 VGND VGND VPWR VPWR sky130_fd_sc_hd__decap_3
X_6559_ _6731_/B _6557_/X _6558_/X _6586_/A VGND VGND VPWR VPWR _6559_/X sky130_fd_sc_hd__a22o_2
XFILLER_79_518 VGND VGND VPWR VPWR sky130_fd_sc_hd__decap_3
XFILLER_10_98 VGND VGND VPWR VPWR sky130_fd_sc_hd__fill_2
XFILLER_59_220 VGND VGND VPWR VPWR sky130_fd_sc_hd__decap_3
XFILLER_59_231 VGND VGND VPWR VPWR sky130_fd_sc_hd__decap_3
XFILLER_87_540 VGND VGND VPWR VPWR sky130_fd_sc_hd__decap_3
XFILLER_86_69 VGND VGND VPWR VPWR sky130_fd_sc_hd__fill_2
XFILLER_19_117 VGND VGND VPWR VPWR sky130_fd_sc_hd__decap_3
XFILLER_47_426 VGND VGND VPWR VPWR sky130_fd_sc_hd__decap_3
XFILLER_74_212 VGND VGND VPWR VPWR sky130_fd_sc_hd__fill_2
XPHY_EDGE_ROW_76_Right_76 VGND VGND VPWR VPWR sky130_fd_sc_hd__decap_3
XFILLER_19_85 VGND VGND VPWR VPWR sky130_fd_sc_hd__decap_3
XFILLER_19_96 VGND VGND VPWR VPWR sky130_fd_sc_hd__fill_2
XFILLER_74_234 VGND VGND VPWR VPWR sky130_fd_sc_hd__decap_3
XFILLER_74_256 VGND VGND VPWR VPWR sky130_fd_sc_hd__fill_1
XFILLER_74_278 VGND VGND VPWR VPWR sky130_fd_sc_hd__decap_3
XFILLER_27_172 VGND VGND VPWR VPWR sky130_fd_sc_hd__decap_3
XFILLER_27_194 VGND VGND VPWR VPWR sky130_fd_sc_hd__decap_3
XFILLER_15_367 VGND VGND VPWR VPWR sky130_fd_sc_hd__decap_3
XFILLER_35_62 VGND VGND VPWR VPWR sky130_fd_sc_hd__decap_3
XFILLER_30_337 VGND VGND VPWR VPWR sky130_fd_sc_hd__decap_3
XFILLER_35_95 VGND VGND VPWR VPWR sky130_fd_sc_hd__decap_3
XFILLER_70_473 VGND VGND VPWR VPWR sky130_fd_sc_hd__decap_3
XFILLER_11_551 VGND VGND VPWR VPWR sky130_fd_sc_hd__fill_1
XPHY_EDGE_ROW_85_Right_85 VGND VGND VPWR VPWR sky130_fd_sc_hd__decap_3
XFILLER_11_595 VGND VGND VPWR VPWR sky130_fd_sc_hd__decap_3
Xwire453 _3765_/B VGND VGND VPWR VPWR _6319_/S sky130_fd_sc_hd__clkbuf_4
XTAP_TAPCELL_ROW_77_1028 VGND VPWR sky130_fd_sc_hd__tapvpwrvgnd_1
Xwire486 _5361_/B VGND VGND VPWR VPWR _4748_/B sky130_fd_sc_hd__buf_6
XFILLER_32_6 VGND VGND VPWR VPWR sky130_fd_sc_hd__decap_3
Xload_slew469 _6397_/S VGND VGND VPWR VPWR _6395_/S sky130_fd_sc_hd__clkbuf_4
Xload_slew458 _6432_/S VGND VGND VPWR VPWR _6401_/S sky130_fd_sc_hd__buf_4
XPHY_EDGE_ROW_94_Right_94 VGND VGND VPWR VPWR sky130_fd_sc_hd__decap_3
XFILLER_65_212 VGND VGND VPWR VPWR sky130_fd_sc_hd__fill_1
XFILLER_93_532 VGND VGND VPWR VPWR sky130_fd_sc_hd__decap_3
XFILLER_65_245 VGND VGND VPWR VPWR sky130_fd_sc_hd__decap_3
XTAP_TAPCELL_ROW_88_1146 VGND VPWR sky130_fd_sc_hd__tapvpwrvgnd_1
XTAP_TAPCELL_ROW_0_208 VGND VPWR sky130_fd_sc_hd__tapvpwrvgnd_1
XFILLER_25_109 VGND VGND VPWR VPWR sky130_fd_sc_hd__decap_3
XFILLER_53_418 VGND VGND VPWR VPWR sky130_fd_sc_hd__decap_3
XFILLER_65_278 VGND VGND VPWR VPWR sky130_fd_sc_hd__fill_2
XFILLER_65_289 VGND VGND VPWR VPWR sky130_fd_sc_hd__decap_3
XFILLER_80_215 VGND VGND VPWR VPWR sky130_fd_sc_hd__decap_3
X_5930_ _5930_/A _5930_/B VGND VGND VPWR VPWR _5930_/X sky130_fd_sc_hd__and2_2
XTAP_TAPCELL_ROW_0_219 VGND VPWR sky130_fd_sc_hd__tapvpwrvgnd_1
XFILLER_33_142 VGND VGND VPWR VPWR sky130_fd_sc_hd__fill_2
XFILLER_33_153 VGND VGND VPWR VPWR sky130_fd_sc_hd__decap_3
XFILLER_80_259 VGND VGND VPWR VPWR sky130_fd_sc_hd__fill_2
X_5861_ _5848_/Y _5858_/X _5466_/B _5466_/Y VGND VGND VPWR VPWR _5862_/C sky130_fd_sc_hd__o211ai_2
XFILLER_21_337 VGND VGND VPWR VPWR sky130_fd_sc_hd__decap_3
XFILLER_33_175 VGND VGND VPWR VPWR sky130_fd_sc_hd__decap_3
X_5792_ _5792_/A _5792_/B VGND VGND VPWR VPWR _5793_/B sky130_fd_sc_hd__and2_2
X_4812_ _4811_/A _4811_/C _4811_/B VGND VGND VPWR VPWR _4813_/C sky130_fd_sc_hd__a21o_2
XTAP_TAPCELL_ROW_44_682 VGND VPWR sky130_fd_sc_hd__tapvpwrvgnd_1
XTAP_TAPCELL_ROW_16_384 VGND VPWR sky130_fd_sc_hd__tapvpwrvgnd_1
X_4743_ _4764_/B _4742_/C _4742_/A VGND VGND VPWR VPWR _4744_/C sky130_fd_sc_hd__a21o_2
XTAP_TAPCELL_ROW_99_1253 VGND VPWR sky130_fd_sc_hd__tapvpwrvgnd_1
X_6413_ _3941_/C _6016_/D input16/X _6879_/B2 _6405_/S _3868_/B VGND VGND VPWR VPWR
+ _6545_/B sky130_fd_sc_hd__mux4_2
X_4674_ _4672_/X _4674_/B VGND VGND VPWR VPWR _4675_/B sky130_fd_sc_hd__and2b_2
X_3625_ _3625_/A _3831_/B VGND VGND VPWR VPWR _3631_/A sky130_fd_sc_hd__nor2_2
X_6344_ _6625_/A _6589_/B _6589_/C _6368_/B VGND VGND VPWR VPWR _6344_/X sky130_fd_sc_hd__or4_2
X_3556_ _3555_/A _3555_/B _3555_/C VGND VGND VPWR VPWR _3565_/B sky130_fd_sc_hd__a21o_2
XFILLER_88_315 VGND VGND VPWR VPWR sky130_fd_sc_hd__decap_3
X_6275_ _6178_/A _6275_/B VGND VGND VPWR VPWR _6931_/B sky130_fd_sc_hd__and2b_2
XFILLER_88_359 VGND VGND VPWR VPWR sky130_fd_sc_hd__decap_3
X_5226_ _5223_/X _5226_/B VGND VGND VPWR VPWR _5270_/B sky130_fd_sc_hd__and2b_2
X_3487_ _6264_/A VGND VGND VPWR VPWR _6265_/A sky130_fd_sc_hd__inv_2
XFILLER_29_404 VGND VGND VPWR VPWR sky130_fd_sc_hd__fill_2
XFILLER_84_521 VGND VGND VPWR VPWR sky130_fd_sc_hd__decap_3
X_5157_ _5159_/A _5159_/B VGND VGND VPWR VPWR _5157_/X sky130_fd_sc_hd__and2b_2
XFILLER_56_245 VGND VGND VPWR VPWR sky130_fd_sc_hd__decap_3
XFILLER_56_256 VGND VGND VPWR VPWR sky130_fd_sc_hd__decap_3
X_5088_ _5089_/A _5089_/B _5089_/C _5089_/D VGND VGND VPWR VPWR _5088_/Y sky130_fd_sc_hd__nor4_2
X_4108_ _4108_/A _4108_/B VGND VGND VPWR VPWR _4109_/C sky130_fd_sc_hd__and2_2
XFILLER_16_109 VGND VGND VPWR VPWR sky130_fd_sc_hd__decap_3
XFILLER_71_204 VGND VGND VPWR VPWR sky130_fd_sc_hd__decap_3
X_4039_ _4039_/A _4039_/B VGND VGND VPWR VPWR _4040_/B sky130_fd_sc_hd__xnor2_2
XFILLER_37_481 VGND VGND VPWR VPWR sky130_fd_sc_hd__fill_1
XFILLER_71_237 VGND VGND VPWR VPWR sky130_fd_sc_hd__decap_3
XFILLER_72_38 VGND VGND VPWR VPWR sky130_fd_sc_hd__fill_1
XFILLER_52_495 VGND VGND VPWR VPWR sky130_fd_sc_hd__decap_3
XFILLER_4_525 VGND VGND VPWR VPWR sky130_fd_sc_hd__decap_3
XFILLER_4_536 VGND VGND VPWR VPWR sky130_fd_sc_hd__fill_2
XFILLER_79_326 VGND VGND VPWR VPWR sky130_fd_sc_hd__decap_3
XFILLER_79_337 VGND VGND VPWR VPWR sky130_fd_sc_hd__decap_3
XFILLER_97_57 VGND VGND VPWR VPWR sky130_fd_sc_hd__fill_2
XFILLER_87_370 VGND VGND VPWR VPWR sky130_fd_sc_hd__decap_3
XFILLER_94_318 VGND VGND VPWR VPWR sky130_fd_sc_hd__decap_3
XFILLER_47_234 VGND VGND VPWR VPWR sky130_fd_sc_hd__decap_3
XFILLER_75_543 VGND VGND VPWR VPWR sky130_fd_sc_hd__decap_3
XFILLER_35_418 VGND VGND VPWR VPWR sky130_fd_sc_hd__decap_3
XFILLER_62_215 VGND VGND VPWR VPWR sky130_fd_sc_hd__decap_3
XFILLER_75_576 VGND VGND VPWR VPWR sky130_fd_sc_hd__decap_3
XFILLER_75_587 VGND VGND VPWR VPWR sky130_fd_sc_hd__decap_3
XFILLER_90_502 VGND VGND VPWR VPWR sky130_fd_sc_hd__decap_3
XFILLER_62_248 VGND VGND VPWR VPWR sky130_fd_sc_hd__decap_3
XFILLER_62_259 VGND VGND VPWR VPWR sky130_fd_sc_hd__decap_3
XFILLER_15_164 VGND VGND VPWR VPWR sky130_fd_sc_hd__decap_3
XFILLER_43_484 VGND VGND VPWR VPWR sky130_fd_sc_hd__fill_2
XTAP_TAPCELL_ROW_83_1087 VGND VPWR sky130_fd_sc_hd__tapvpwrvgnd_1
XTAP_TAPCELL_ROW_41_652 VGND VPWR sky130_fd_sc_hd__tapvpwrvgnd_1
XTAP_TAPCELL_ROW_13_354 VGND VPWR sky130_fd_sc_hd__tapvpwrvgnd_1
XFILLER_7_66 VGND VGND VPWR VPWR sky130_fd_sc_hd__decap_3
XFILLER_7_99 VGND VGND VPWR VPWR sky130_fd_sc_hd__decap_3
X_4390_ _4505_/B _4387_/C _4387_/D _4387_/B VGND VGND VPWR VPWR _4391_/C sky130_fd_sc_hd__a22o_2
Xload_slew200 _4525_/B2 VGND VGND VPWR VPWR _4524_/B sky130_fd_sc_hd__clkbuf_4
Xload_slew244 _5383_/B VGND VGND VPWR VPWR _5313_/B sky130_fd_sc_hd__buf_6
X_6060_ _6332_/A _6332_/B VGND VGND VPWR VPWR _6384_/A sky130_fd_sc_hd__nand2b_2
XFILLER_38_212 VGND VGND VPWR VPWR sky130_fd_sc_hd__decap_3
XFILLER_85_329 VGND VGND VPWR VPWR sky130_fd_sc_hd__decap_3
XFILLER_87_90 VGND VGND VPWR VPWR sky130_fd_sc_hd__decap_3
Xload_slew288 _6462_/S VGND VGND VPWR VPWR _6625_/A sky130_fd_sc_hd__clkbuf_4
X_5011_ _5009_/Y _5011_/B VGND VGND VPWR VPWR _5011_/Y sky130_fd_sc_hd__nand2b_4
XFILLER_38_223 VGND VGND VPWR VPWR sky130_fd_sc_hd__fill_1
XFILLER_93_340 VGND VGND VPWR VPWR sky130_fd_sc_hd__decap_3
XTAP_TAPCELL_ROW_49_730 VGND VPWR sky130_fd_sc_hd__tapvpwrvgnd_1
XFILLER_53_204 VGND VGND VPWR VPWR sky130_fd_sc_hd__fill_2
XFILLER_66_565 VGND VGND VPWR VPWR sky130_fd_sc_hd__decap_3
XFILLER_66_587 VGND VGND VPWR VPWR sky130_fd_sc_hd__fill_1
XFILLER_93_373 VGND VGND VPWR VPWR sky130_fd_sc_hd__decap_3
XFILLER_19_492 VGND VGND VPWR VPWR sky130_fd_sc_hd__fill_2
XFILLER_81_524 VGND VGND VPWR VPWR sky130_fd_sc_hd__fill_1
XFILLER_93_384 VGND VGND VPWR VPWR sky130_fd_sc_hd__decap_3
X_6962_ _6699_/X _6960_/Y _6961_/Y _6693_/Y _6363_/A VGND VGND VPWR VPWR _6962_/X
+ sky130_fd_sc_hd__a32o_2
X_6893_ _6309_/Y _6319_/X _6893_/S VGND VGND VPWR VPWR _6893_/X sky130_fd_sc_hd__mux2_1
X_5913_ _5913_/A _5913_/B VGND VGND VPWR VPWR _5915_/B sky130_fd_sc_hd__nor2_2
XFILLER_34_462 VGND VGND VPWR VPWR sky130_fd_sc_hd__decap_3
X_5844_ _5844_/A1 _5840_/C _5840_/B VGND VGND VPWR VPWR _5844_/Y sky130_fd_sc_hd__o21ai_2
XFILLER_61_281 VGND VGND VPWR VPWR sky130_fd_sc_hd__decap_3
XFILLER_21_156 VGND VGND VPWR VPWR sky130_fd_sc_hd__fill_2
XFILLER_21_167 VGND VGND VPWR VPWR sky130_fd_sc_hd__fill_1
X_5775_ _5775_/A _5775_/B VGND VGND VPWR VPWR _5780_/A sky130_fd_sc_hd__nor2_2
X_4726_ _4748_/B _4749_/A _5321_/C _5321_/D VGND VGND VPWR VPWR _4728_/B sky130_fd_sc_hd__nand4_2
X_4657_ _4657_/A _4657_/B VGND VGND VPWR VPWR _4676_/C sky130_fd_sc_hd__xnor2_2
X_3608_ _3608_/A _4362_/B _3609_/A _3608_/D VGND VGND VPWR VPWR _3644_/A sky130_fd_sc_hd__nand4_2
X_6327_ _6294_/Y _6308_/X _6326_/X VGND VGND VPWR VPWR _6327_/Y sky130_fd_sc_hd__o21ai_2
X_4588_ _4590_/A _4590_/B VGND VGND VPWR VPWR _4588_/Y sky130_fd_sc_hd__nand2_2
X_3539_ _3955_/A _3996_/B _3961_/C _3961_/D VGND VGND VPWR VPWR _3542_/A sky130_fd_sc_hd__and4_2
XFILLER_67_38 VGND VGND VPWR VPWR sky130_fd_sc_hd__decap_3
XFILLER_88_156 VGND VGND VPWR VPWR sky130_fd_sc_hd__decap_3
X_6258_ _6258_/A _6794_/A VGND VGND VPWR VPWR _6808_/B sky130_fd_sc_hd__nor2_2
XFILLER_76_318 VGND VGND VPWR VPWR sky130_fd_sc_hd__decap_3
XFILLER_88_189 VGND VGND VPWR VPWR sky130_fd_sc_hd__decap_3
X_6189_ _6902_/A _6904_/B VGND VGND VPWR VPWR _6890_/A sky130_fd_sc_hd__or2_2
X_5209_ _5209_/A _5313_/A _5311_/C _5311_/D VGND VGND VPWR VPWR _5212_/A sky130_fd_sc_hd__nand4_2
XFILLER_29_267 VGND VGND VPWR VPWR sky130_fd_sc_hd__decap_3
XFILLER_16_42 VGND VGND VPWR VPWR sky130_fd_sc_hd__decap_3
XFILLER_16_64 VGND VGND VPWR VPWR sky130_fd_sc_hd__decap_3
XFILLER_25_462 VGND VGND VPWR VPWR sky130_fd_sc_hd__decap_3
XTAP_TAPCELL_ROW_55_799 VGND VPWR sky130_fd_sc_hd__tapvpwrvgnd_1
XFILLER_12_123 VGND VGND VPWR VPWR sky130_fd_sc_hd__decap_3
XFILLER_40_421 VGND VGND VPWR VPWR sky130_fd_sc_hd__fill_1
XFILLER_12_156 VGND VGND VPWR VPWR sky130_fd_sc_hd__decap_3
XTAP_TAPCELL_ROW_10_324 VGND VPWR sky130_fd_sc_hd__tapvpwrvgnd_1
XFILLER_32_85 VGND VGND VPWR VPWR sky130_fd_sc_hd__fill_2
XFILLER_4_399 VGND VGND VPWR VPWR sky130_fd_sc_hd__decap_3
XFILLER_0_561 VGND VGND VPWR VPWR sky130_fd_sc_hd__decap_3
XFILLER_48_510 VGND VGND VPWR VPWR sky130_fd_sc_hd__fill_2
XFILLER_67_329 VGND VGND VPWR VPWR sky130_fd_sc_hd__decap_3
XFILLER_94_104 VGND VGND VPWR VPWR sky130_fd_sc_hd__fill_2
XFILLER_57_60 VGND VGND VPWR VPWR sky130_fd_sc_hd__decap_3
XFILLER_94_148 VGND VGND VPWR VPWR sky130_fd_sc_hd__fill_1
XFILLER_63_513 VGND VGND VPWR VPWR sky130_fd_sc_hd__decap_3
XFILLER_75_362 VGND VGND VPWR VPWR sky130_fd_sc_hd__decap_3
XTAP_TAPCELL_ROW_85_1105 VGND VPWR sky130_fd_sc_hd__tapvpwrvgnd_1
XTAP_TAPCELL_ROW_46_700 VGND VPWR sky130_fd_sc_hd__tapvpwrvgnd_1
XFILLER_35_215 VGND VGND VPWR VPWR sky130_fd_sc_hd__decap_3
XTAP_TAPCELL_ROW_18_402 VGND VPWR sky130_fd_sc_hd__tapvpwrvgnd_1
XFILLER_63_557 VGND VGND VPWR VPWR sky130_fd_sc_hd__decap_3
XFILLER_90_343 VGND VGND VPWR VPWR sky130_fd_sc_hd__decap_3
XFILLER_90_365 VGND VGND VPWR VPWR sky130_fd_sc_hd__decap_3
XFILLER_16_473 VGND VGND VPWR VPWR sky130_fd_sc_hd__decap_3
XFILLER_50_218 VGND VGND VPWR VPWR sky130_fd_sc_hd__decap_3
XFILLER_16_495 VGND VGND VPWR VPWR sky130_fd_sc_hd__decap_3
XFILLER_31_443 VGND VGND VPWR VPWR sky130_fd_sc_hd__decap_3
XFILLER_43_281 VGND VGND VPWR VPWR sky130_fd_sc_hd__fill_1
X_3890_ _3955_/A _3996_/B _6175_/A _6178_/A VGND VGND VPWR VPWR _4046_/A sky130_fd_sc_hd__nand4_2
XTAP_TAPCELL_ROW_26_490 VGND VPWR sky130_fd_sc_hd__tapvpwrvgnd_1
XFILLER_31_498 VGND VGND VPWR VPWR sky130_fd_sc_hd__decap_3
X_5560_ _5560_/A _5606_/A _5560_/C VGND VGND VPWR VPWR _5562_/B sky130_fd_sc_hd__or3_4
X_5491_ _5659_/A _5491_/B VGND VGND VPWR VPWR _5534_/A sky130_fd_sc_hd__nand2_2
X_4511_ _4511_/A _4511_/B VGND VGND VPWR VPWR _4844_/A sky130_fd_sc_hd__xnor2_2
XTAP_TAPCELL_ROW_96_1223 VGND VPWR sky130_fd_sc_hd__tapvpwrvgnd_1
X_4442_ _4440_/A _4441_/X _4313_/Y _4328_/X VGND VGND VPWR VPWR _4445_/A sky130_fd_sc_hd__o211a_2
X_4373_ _4373_/A _4373_/B _4373_/C VGND VGND VPWR VPWR _4473_/A sky130_fd_sc_hd__or3_4
XFILLER_98_410 VGND VGND VPWR VPWR sky130_fd_sc_hd__decap_3
Xfanout629 _6016_/B VGND VGND VPWR VPWR _3680_/A sky130_fd_sc_hd__clkdlybuf4s25_1
X_6112_ _6214_/B _6112_/B VGND VGND VPWR VPWR _6114_/B sky130_fd_sc_hd__nor2_2
XFILLER_100_415 VGND VGND VPWR VPWR sky130_fd_sc_hd__fill_2
XFILLER_58_318 VGND VGND VPWR VPWR sky130_fd_sc_hd__decap_3
X_6043_ _6043_/A _6043_/B VGND VGND VPWR VPWR _6050_/A sky130_fd_sc_hd__xnor2_2
XFILLER_85_148 VGND VGND VPWR VPWR sky130_fd_sc_hd__decap_3
XFILLER_26_226 VGND VGND VPWR VPWR sky130_fd_sc_hd__decap_3
XFILLER_66_395 VGND VGND VPWR VPWR sky130_fd_sc_hd__decap_3
XFILLER_93_181 VGND VGND VPWR VPWR sky130_fd_sc_hd__decap_3
XFILLER_54_568 VGND VGND VPWR VPWR sky130_fd_sc_hd__decap_3
XFILLER_81_343 VGND VGND VPWR VPWR sky130_fd_sc_hd__decap_3
XFILLER_81_365 VGND VGND VPWR VPWR sky130_fd_sc_hd__decap_3
X_6945_ _6680_/X _6770_/A _6945_/B1 _6675_/X VGND VGND VPWR VPWR _6946_/C sky130_fd_sc_hd__a2bb2o_2
XFILLER_22_421 VGND VGND VPWR VPWR sky130_fd_sc_hd__decap_3
X_6876_ _6182_/B input16/X input15/X _3941_/C _6402_/S _6876_/S1 VGND VGND VPWR VPWR
+ _6876_/X sky130_fd_sc_hd__mux4_2
XTAP_TAPCELL_ROW_52_758 VGND VPWR sky130_fd_sc_hd__tapvpwrvgnd_1
X_5827_ _5827_/A1 _5826_/C _5826_/A VGND VGND VPWR VPWR _5827_/Y sky130_fd_sc_hd__o21ai_2
X_5758_ _5760_/A _5760_/B VGND VGND VPWR VPWR _5809_/B sky130_fd_sc_hd__nand2_2
XFILLER_5_108 VGND VGND VPWR VPWR sky130_fd_sc_hd__decap_3
X_4709_ _4709_/A _4709_/B VGND VGND VPWR VPWR _4923_/B sky130_fd_sc_hd__xnor2_2
X_5689_ _5683_/Y _5686_/Y _5649_/Y _5653_/X VGND VGND VPWR VPWR _6650_/B sky130_fd_sc_hd__a211oi_2
XFILLER_78_15 VGND VGND VPWR VPWR sky130_fd_sc_hd__fill_1
XFILLER_89_465 VGND VGND VPWR VPWR sky130_fd_sc_hd__decap_3
XFILLER_49_329 VGND VGND VPWR VPWR sky130_fd_sc_hd__decap_3
XFILLER_76_115 VGND VGND VPWR VPWR sky130_fd_sc_hd__decap_3
XFILLER_89_498 VGND VGND VPWR VPWR sky130_fd_sc_hd__fill_1
XFILLER_57_340 VGND VGND VPWR VPWR sky130_fd_sc_hd__decap_3
XFILLER_76_159 VGND VGND VPWR VPWR sky130_fd_sc_hd__decap_3
XFILLER_45_535 VGND VGND VPWR VPWR sky130_fd_sc_hd__fill_1
XFILLER_57_373 VGND VGND VPWR VPWR sky130_fd_sc_hd__decap_3
XFILLER_17_259 VGND VGND VPWR VPWR sky130_fd_sc_hd__fill_2
XFILLER_27_85 VGND VGND VPWR VPWR sky130_fd_sc_hd__fill_1
XFILLER_60_505 VGND VGND VPWR VPWR sky130_fd_sc_hd__decap_3
XFILLER_72_365 VGND VGND VPWR VPWR sky130_fd_sc_hd__decap_3
XFILLER_32_207 VGND VGND VPWR VPWR sky130_fd_sc_hd__decap_3
XFILLER_25_281 VGND VGND VPWR VPWR sky130_fd_sc_hd__decap_3
XFILLER_40_240 VGND VGND VPWR VPWR sky130_fd_sc_hd__decap_3
XFILLER_40_262 VGND VGND VPWR VPWR sky130_fd_sc_hd__decap_3
XTAP_TAPCELL_ROW_80_1057 VGND VPWR sky130_fd_sc_hd__tapvpwrvgnd_1
XFILLER_40_295 VGND VGND VPWR VPWR sky130_fd_sc_hd__decap_3
XTAP_TAPCELL_ROW_23_460 VGND VPWR sky130_fd_sc_hd__tapvpwrvgnd_1
XFILLER_9_458 VGND VGND VPWR VPWR sky130_fd_sc_hd__decap_3
XFILLER_9_447 VGND VGND VPWR VPWR sky130_fd_sc_hd__fill_1
XFILLER_64_9 VGND VGND VPWR VPWR sky130_fd_sc_hd__fill_1
XFILLER_4_141 VGND VGND VPWR VPWR sky130_fd_sc_hd__fill_2
XFILLER_99_207 VGND VGND VPWR VPWR sky130_fd_sc_hd__fill_2
XFILLER_4_152 VGND VGND VPWR VPWR sky130_fd_sc_hd__fill_2
XFILLER_4_78 VGND VGND VPWR VPWR sky130_fd_sc_hd__decap_3
XFILLER_68_70 VGND VGND VPWR VPWR sky130_fd_sc_hd__decap_3
XTAP_TAPCELL_ROW_91_1175 VGND VPWR sky130_fd_sc_hd__tapvpwrvgnd_1
XFILLER_95_402 VGND VGND VPWR VPWR sky130_fd_sc_hd__decap_3
XFILLER_67_148 VGND VGND VPWR VPWR sky130_fd_sc_hd__fill_2
XFILLER_95_435 VGND VGND VPWR VPWR sky130_fd_sc_hd__decap_3
XFILLER_48_340 VGND VGND VPWR VPWR sky130_fd_sc_hd__decap_3
XFILLER_36_513 VGND VGND VPWR VPWR sky130_fd_sc_hd__fill_2
XFILLER_48_373 VGND VGND VPWR VPWR sky130_fd_sc_hd__decap_3
XFILLER_75_181 VGND VGND VPWR VPWR sky130_fd_sc_hd__decap_3
XFILLER_51_505 VGND VGND VPWR VPWR sky130_fd_sc_hd__decap_3
XFILLER_63_343 VGND VGND VPWR VPWR sky130_fd_sc_hd__decap_3
XFILLER_84_80 VGND VGND VPWR VPWR sky130_fd_sc_hd__decap_3
XFILLER_63_376 VGND VGND VPWR VPWR sky130_fd_sc_hd__decap_3
XFILLER_90_151 VGND VGND VPWR VPWR sky130_fd_sc_hd__decap_3
X_6730_ _6730_/A _6730_/B VGND VGND VPWR VPWR _6898_/B sky130_fd_sc_hd__nor2_2
X_4991_ _4991_/A _4991_/B _4991_/C VGND VGND VPWR VPWR _5084_/A sky130_fd_sc_hd__nand3_2
XFILLER_90_195 VGND VGND VPWR VPWR sky130_fd_sc_hd__fill_1
X_3942_ _3941_/A _3941_/B _3941_/C _3834_/D VGND VGND VPWR VPWR _3942_/X sky130_fd_sc_hd__a22o_2
XFILLER_31_262 VGND VGND VPWR VPWR sky130_fd_sc_hd__decap_3
X_6661_ _6929_/B _6660_/X _6363_/A _6657_/X VGND VGND VPWR VPWR _6661_/X sky130_fd_sc_hd__a2bb2o_2
X_3873_ _3873_/A _3873_/B VGND VGND VPWR VPWR _3876_/A sky130_fd_sc_hd__xnor2_2
X_6592_ _6391_/Y _6862_/B _6591_/X _6532_/Y VGND VGND VPWR VPWR _6594_/B sky130_fd_sc_hd__o211a_2
X_5612_ _5562_/Y _5609_/X _5608_/Y _5608_/A VGND VGND VPWR VPWR _5612_/X sky130_fd_sc_hd__a211o_2
X_5543_ _5543_/A _5777_/A _6215_/B _5576_/C VGND VGND VPWR VPWR _5579_/A sky130_fd_sc_hd__and4_2
XTAP_TAPCELL_ROW_100_1282 VGND VPWR sky130_fd_sc_hd__tapvpwrvgnd_1
XTAP_TAPCELL_ROW_100_1271 VGND VPWR sky130_fd_sc_hd__tapvpwrvgnd_1
X_5474_ _5414_/A _5414_/B _5474_/B1 VGND VGND VPWR VPWR _5474_/Y sky130_fd_sc_hd__a21oi_2
X_4425_ _4425_/A _4425_/B _4425_/C VGND VGND VPWR VPWR _4428_/A sky130_fd_sc_hd__or3_2
X_4356_ _4592_/A _4593_/C _4593_/D _4476_/A VGND VGND VPWR VPWR _4357_/B sky130_fd_sc_hd__a22o_2
XFILLER_58_104 VGND VGND VPWR VPWR sky130_fd_sc_hd__decap_3
XFILLER_86_413 VGND VGND VPWR VPWR sky130_fd_sc_hd__decap_3
XFILLER_86_424 VGND VGND VPWR VPWR sky130_fd_sc_hd__decap_3
Xfanout426 input36/X VGND VGND VPWR VPWR _6144_/B sky130_fd_sc_hd__buf_6
XFILLER_98_262 VGND VGND VPWR VPWR sky130_fd_sc_hd__decap_3
XFILLER_100_223 VGND VGND VPWR VPWR sky130_fd_sc_hd__fill_1
XFILLER_58_137 VGND VGND VPWR VPWR sky130_fd_sc_hd__decap_3
Xfanout459 _6474_/S VGND VGND VPWR VPWR _6220_/B sky130_fd_sc_hd__clkdlybuf4s25_1
X_4287_ _4285_/A _4397_/A _4286_/Y _4272_/X VGND VGND VPWR VPWR _4287_/Y sky130_fd_sc_hd__a211oi_2
XFILLER_100_245 VGND VGND VPWR VPWR sky130_fd_sc_hd__decap_3
XFILLER_100_256 VGND VGND VPWR VPWR sky130_fd_sc_hd__decap_3
XFILLER_27_502 VGND VGND VPWR VPWR sky130_fd_sc_hd__fill_2
XFILLER_39_351 VGND VGND VPWR VPWR sky130_fd_sc_hd__decap_3
X_6026_ _6026_/A _6026_/B VGND VGND VPWR VPWR _6027_/B sky130_fd_sc_hd__xnor2_2
XTAP_TAPCELL_ROW_57_817 VGND VPWR sky130_fd_sc_hd__tapvpwrvgnd_1
XTAP_TAPCELL_ROW_29_519 VGND VPWR sky130_fd_sc_hd__tapvpwrvgnd_1
XFILLER_27_524 VGND VGND VPWR VPWR sky130_fd_sc_hd__decap_3
XFILLER_54_343 VGND VGND VPWR VPWR sky130_fd_sc_hd__decap_3
XFILLER_54_376 VGND VGND VPWR VPWR sky130_fd_sc_hd__decap_3
XFILLER_42_549 VGND VGND VPWR VPWR sky130_fd_sc_hd__fill_1
XFILLER_81_184 VGND VGND VPWR VPWR sky130_fd_sc_hd__decap_3
X_6928_ _6175_/B _6928_/A2 _6928_/B1 _6931_/A _6927_/X VGND VGND VPWR VPWR _6930_/B
+ sky130_fd_sc_hd__o221ai_2
XFILLER_80_27 VGND VGND VPWR VPWR sky130_fd_sc_hd__fill_1
X_6859_ _6168_/X _6860_/A _6858_/Y VGND VGND VPWR VPWR _6859_/Y sky130_fd_sc_hd__a21oi_2
XFILLER_10_424 VGND VGND VPWR VPWR sky130_fd_sc_hd__decap_3
XFILLER_6_406 VGND VGND VPWR VPWR sky130_fd_sc_hd__decap_3
XTAP_TAPCELL_ROW_20_430 VGND VPWR sky130_fd_sc_hd__tapvpwrvgnd_1
XFILLER_13_98 VGND VGND VPWR VPWR sky130_fd_sc_hd__decap_3
XFILLER_1_100 VGND VGND VPWR VPWR sky130_fd_sc_hd__decap_3
XFILLER_1_133 VGND VGND VPWR VPWR sky130_fd_sc_hd__fill_1
XFILLER_89_240 VGND VGND VPWR VPWR sky130_fd_sc_hd__decap_3
XFILLER_8_3 VGND VGND VPWR VPWR sky130_fd_sc_hd__decap_3
XFILLER_77_402 VGND VGND VPWR VPWR sky130_fd_sc_hd__decap_3
XFILLER_89_284 VGND VGND VPWR VPWR sky130_fd_sc_hd__decap_3
XFILLER_18_524 VGND VGND VPWR VPWR sky130_fd_sc_hd__decap_3
XFILLER_92_427 VGND VGND VPWR VPWR sky130_fd_sc_hd__fill_2
XFILLER_92_449 VGND VGND VPWR VPWR sky130_fd_sc_hd__fill_2
XFILLER_57_181 VGND VGND VPWR VPWR sky130_fd_sc_hd__decap_3
XFILLER_33_505 VGND VGND VPWR VPWR sky130_fd_sc_hd__fill_1
XFILLER_45_365 VGND VGND VPWR VPWR sky130_fd_sc_hd__decap_3
XFILLER_72_162 VGND VGND VPWR VPWR sky130_fd_sc_hd__decap_3
XFILLER_60_324 VGND VGND VPWR VPWR sky130_fd_sc_hd__decap_3
XFILLER_13_240 VGND VGND VPWR VPWR sky130_fd_sc_hd__fill_1
XFILLER_54_94 VGND VGND VPWR VPWR sky130_fd_sc_hd__decap_3
XFILLER_60_368 VGND VGND VPWR VPWR sky130_fd_sc_hd__fill_1
XFILLER_13_284 VGND VGND VPWR VPWR sky130_fd_sc_hd__decap_3
XFILLER_41_571 VGND VGND VPWR VPWR sky130_fd_sc_hd__fill_2
XFILLER_13_295 VGND VGND VPWR VPWR sky130_fd_sc_hd__fill_1
XFILLER_9_277 VGND VGND VPWR VPWR sky130_fd_sc_hd__decap_3
XFILLER_9_255 VGND VGND VPWR VPWR sky130_fd_sc_hd__decap_3
XFILLER_62_6 VGND VGND VPWR VPWR sky130_fd_sc_hd__decap_3
XFILLER_9_299 VGND VGND VPWR VPWR sky130_fd_sc_hd__decap_3
XFILLER_79_80 VGND VGND VPWR VPWR sky130_fd_sc_hd__fill_1
X_4210_ _4210_/A _4210_/B VGND VGND VPWR VPWR _4217_/B sky130_fd_sc_hd__xnor2_2
X_5190_ _5188_/X _5190_/B VGND VGND VPWR VPWR _5191_/C sky130_fd_sc_hd__and2b_2
XFILLER_68_424 VGND VGND VPWR VPWR sky130_fd_sc_hd__decap_3
X_4141_ _4077_/B _3782_/B _3782_/C VGND VGND VPWR VPWR _4141_/X sky130_fd_sc_hd__a21o_2
XFILLER_95_221 VGND VGND VPWR VPWR sky130_fd_sc_hd__decap_3
X_4072_ _4072_/A _4072_/B _4074_/B VGND VGND VPWR VPWR _4072_/X sky130_fd_sc_hd__and3_2
XFILLER_95_243 VGND VGND VPWR VPWR sky130_fd_sc_hd__decap_3
XFILLER_83_427 VGND VGND VPWR VPWR sky130_fd_sc_hd__decap_3
XFILLER_83_449 VGND VGND VPWR VPWR sky130_fd_sc_hd__decap_3
XFILLER_76_490 VGND VGND VPWR VPWR sky130_fd_sc_hd__fill_2
XFILLER_24_527 VGND VGND VPWR VPWR sky130_fd_sc_hd__decap_3
XFILLER_36_376 VGND VGND VPWR VPWR sky130_fd_sc_hd__decap_3
XFILLER_63_140 VGND VGND VPWR VPWR sky130_fd_sc_hd__fill_1
XFILLER_91_471 VGND VGND VPWR VPWR sky130_fd_sc_hd__decap_3
XFILLER_51_335 VGND VGND VPWR VPWR sky130_fd_sc_hd__fill_1
X_4974_ _4975_/C1 _4972_/Y _4973_/Y _4974_/C1 VGND VGND VPWR VPWR _4991_/A sky130_fd_sc_hd__o211ai_4
XFILLER_51_357 VGND VGND VPWR VPWR sky130_fd_sc_hd__decap_3
X_6713_ _6303_/Y _6575_/X _6712_/X _6960_/A VGND VGND VPWR VPWR _6713_/X sky130_fd_sc_hd__a22o_2
X_3925_ _3925_/A _6153_/A VGND VGND VPWR VPWR _3926_/B sky130_fd_sc_hd__xor2_2
XTAP_TAPCELL_ROW_62_864 VGND VPWR sky130_fd_sc_hd__tapvpwrvgnd_1
X_6644_ _6392_/Y _6638_/Y _6641_/Y _6643_/Y _6392_/A VGND VGND VPWR VPWR _6647_/A
+ sky130_fd_sc_hd__a32o_2
XTAP_TAPCELL_ROW_34_577 VGND VPWR sky130_fd_sc_hd__tapvpwrvgnd_1
X_3856_ _3857_/A _3857_/B VGND VGND VPWR VPWR _3858_/A sky130_fd_sc_hd__and2_2
X_6575_ _6476_/Y _6574_/X _6783_/S VGND VGND VPWR VPWR _6575_/X sky130_fd_sc_hd__mux2_1
X_3787_ _3990_/A _3961_/C _3961_/D _3991_/B VGND VGND VPWR VPWR _3788_/B sky130_fd_sc_hd__a22oi_2
X_5526_ _5526_/A _5582_/B VGND VGND VPWR VPWR _5542_/A sky130_fd_sc_hd__nand2_2
X_5457_ _5457_/A _5457_/B VGND VGND VPWR VPWR _5458_/C sky130_fd_sc_hd__xnor2_2
X_4408_ _4524_/B _4406_/C _4406_/D _4406_/B VGND VGND VPWR VPWR _4409_/C sky130_fd_sc_hd__a22oi_2
Xfanout201 input7/X VGND VGND VPWR VPWR _3748_/A sky130_fd_sc_hd__buf_6
Xfanout212 _4662_/D VGND VGND VPWR VPWR _4517_/D sky130_fd_sc_hd__dlymetal6s4s_1
Xfanout223 input63/X VGND VGND VPWR VPWR _3944_/B sky130_fd_sc_hd__clkdlybuf4s25_1
X_5388_ _5381_/X _5388_/B VGND VGND VPWR VPWR _5483_/B sky130_fd_sc_hd__nand2b_2
Xfanout234 _5382_/D VGND VGND VPWR VPWR _5311_/D sky130_fd_sc_hd__buf_6
Xfanout245 _5576_/D VGND VGND VPWR VPWR _4757_/B sky130_fd_sc_hd__buf_6
X_4339_ _4341_/A _4341_/B VGND VGND VPWR VPWR _4339_/X sky130_fd_sc_hd__and2_2
XFILLER_86_265 VGND VGND VPWR VPWR sky130_fd_sc_hd__decap_3
Xfanout289 _6313_/B VGND VGND VPWR VPWR _6678_/A sky130_fd_sc_hd__clkdlybuf4s25_1
XFILLER_74_416 VGND VGND VPWR VPWR sky130_fd_sc_hd__decap_3
XFILLER_74_427 VGND VGND VPWR VPWR sky130_fd_sc_hd__decap_3
XFILLER_74_449 VGND VGND VPWR VPWR sky130_fd_sc_hd__decap_3
XFILLER_86_298 VGND VGND VPWR VPWR sky130_fd_sc_hd__fill_1
X_6009_ _6009_/A _6009_/B VGND VGND VPWR VPWR _6010_/B sky130_fd_sc_hd__xnor2_2
XFILLER_27_332 VGND VGND VPWR VPWR sky130_fd_sc_hd__decap_3
XFILLER_27_343 VGND VGND VPWR VPWR sky130_fd_sc_hd__decap_3
XFILLER_39_192 VGND VGND VPWR VPWR sky130_fd_sc_hd__decap_3
XFILLER_15_527 VGND VGND VPWR VPWR sky130_fd_sc_hd__fill_2
XFILLER_15_538 VGND VGND VPWR VPWR sky130_fd_sc_hd__decap_3
XFILLER_42_335 VGND VGND VPWR VPWR sky130_fd_sc_hd__decap_3
XFILLER_30_508 VGND VGND VPWR VPWR sky130_fd_sc_hd__decap_3
XFILLER_24_64 VGND VGND VPWR VPWR sky130_fd_sc_hd__fill_1
XFILLER_6_203 VGND VGND VPWR VPWR sky130_fd_sc_hd__decap_3
Xload_slew618 _3679_/A VGND VGND VPWR VPWR _6014_/D sky130_fd_sc_hd__clkbuf_4
Xload_slew607 _4263_/A VGND VGND VPWR VPWR _5981_/D sky130_fd_sc_hd__buf_4
XFILLER_49_50 VGND VGND VPWR VPWR sky130_fd_sc_hd__decap_3
XFILLER_77_221 VGND VGND VPWR VPWR sky130_fd_sc_hd__decap_3
XFILLER_49_83 VGND VGND VPWR VPWR sky130_fd_sc_hd__fill_2
XFILLER_49_94 VGND VGND VPWR VPWR sky130_fd_sc_hd__decap_3
XFILLER_65_405 VGND VGND VPWR VPWR sky130_fd_sc_hd__fill_1
XFILLER_77_254 VGND VGND VPWR VPWR sky130_fd_sc_hd__decap_3
XFILLER_1_46 VGND VGND VPWR VPWR sky130_fd_sc_hd__fill_2
XFILLER_77_287 VGND VGND VPWR VPWR sky130_fd_sc_hd__decap_3
XFILLER_65_449 VGND VGND VPWR VPWR sky130_fd_sc_hd__decap_3
XFILLER_92_235 VGND VGND VPWR VPWR sky130_fd_sc_hd__decap_3
XFILLER_18_365 VGND VGND VPWR VPWR sky130_fd_sc_hd__decap_3
XFILLER_45_140 VGND VGND VPWR VPWR sky130_fd_sc_hd__decap_3
XFILLER_65_82 VGND VGND VPWR VPWR sky130_fd_sc_hd__decap_3
XFILLER_92_268 VGND VGND VPWR VPWR sky130_fd_sc_hd__decap_3
XFILLER_18_398 VGND VGND VPWR VPWR sky130_fd_sc_hd__decap_3
XFILLER_45_184 VGND VGND VPWR VPWR sky130_fd_sc_hd__fill_1
XFILLER_73_482 VGND VGND VPWR VPWR sky130_fd_sc_hd__decap_3
XFILLER_60_176 VGND VGND VPWR VPWR sky130_fd_sc_hd__decap_3
XFILLER_81_70 VGND VGND VPWR VPWR sky130_fd_sc_hd__decap_3
X_3710_ _3724_/A _3724_/B _3724_/C VGND VGND VPWR VPWR _3710_/Y sky130_fd_sc_hd__o21ai_2
XFILLER_41_390 VGND VGND VPWR VPWR sky130_fd_sc_hd__fill_2
X_4690_ _4924_/A _4924_/B VGND VGND VPWR VPWR _4693_/A sky130_fd_sc_hd__and2b_2
XTAP_TAPCELL_ROW_31_547 VGND VPWR sky130_fd_sc_hd__tapvpwrvgnd_1
X_3641_ _3638_/X _3641_/B VGND VGND VPWR VPWR _4102_/B sky130_fd_sc_hd__and2b_2
X_6360_ _6358_/Y _6359_/X _6478_/S VGND VGND VPWR VPWR _6360_/X sky130_fd_sc_hd__mux2_1
X_3572_ _4634_/A _6264_/A _6083_/A _4634_/B VGND VGND VPWR VPWR _3573_/B sky130_fd_sc_hd__a22o_2
X_5311_ _5311_/A _5311_/B _5311_/C _5311_/D VGND VGND VPWR VPWR _5346_/A sky130_fd_sc_hd__nand4_2
X_6291_ _6291_/A _6291_/B VGND VGND VPWR VPWR _6291_/Y sky130_fd_sc_hd__nand2_2
X_5242_ _5242_/A _5443_/A _5242_/C VGND VGND VPWR VPWR _5830_/A sky130_fd_sc_hd__or3_4
X_5173_ _5089_/X _5171_/Y _5250_/A _5112_/Y VGND VGND VPWR VPWR _5173_/Y sky130_fd_sc_hd__a211oi_2
XFILLER_68_243 VGND VGND VPWR VPWR sky130_fd_sc_hd__decap_3
X_4124_ _4387_/B _4362_/B VGND VGND VPWR VPWR _4126_/B sky130_fd_sc_hd__nand2_2
XFILLER_96_563 VGND VGND VPWR VPWR sky130_fd_sc_hd__fill_1
XFILLER_68_287 VGND VGND VPWR VPWR sky130_fd_sc_hd__decap_3
Xinput1 A[0] VGND VGND VPWR VPWR input1/X sky130_fd_sc_hd__clkbuf_2
XTAP_TAPCELL_ROW_67_923 VGND VPWR sky130_fd_sc_hd__tapvpwrvgnd_1
XTAP_TAPCELL_ROW_39_625 VGND VPWR sky130_fd_sc_hd__tapvpwrvgnd_1
XFILLER_83_246 VGND VGND VPWR VPWR sky130_fd_sc_hd__decap_3
X_4055_ _4055_/A _4055_/B _4072_/A VGND VGND VPWR VPWR _4055_/Y sky130_fd_sc_hd__nand3_2
XFILLER_24_302 VGND VGND VPWR VPWR sky130_fd_sc_hd__decap_3
XFILLER_64_471 VGND VGND VPWR VPWR sky130_fd_sc_hd__decap_3
XFILLER_83_279 VGND VGND VPWR VPWR sky130_fd_sc_hd__fill_1
XFILLER_24_335 VGND VGND VPWR VPWR sky130_fd_sc_hd__decap_3
XFILLER_36_184 VGND VGND VPWR VPWR sky130_fd_sc_hd__decap_3
XFILLER_24_368 VGND VGND VPWR VPWR sky130_fd_sc_hd__decap_3
XFILLER_51_154 VGND VGND VPWR VPWR sky130_fd_sc_hd__decap_3
X_4957_ _5046_/B _5134_/A _5341_/C _5341_/D VGND VGND VPWR VPWR _4957_/X sky130_fd_sc_hd__and4_2
X_4888_ _4888_/A _4888_/B VGND VGND VPWR VPWR _4889_/C sky130_fd_sc_hd__and2_2
X_3908_ _5983_/B _3976_/B VGND VGND VPWR VPWR _3912_/A sky130_fd_sc_hd__nand2_2
X_6627_ _6423_/X _6626_/X _6657_/B VGND VGND VPWR VPWR _6896_/A sky130_fd_sc_hd__a21bo_2
X_3839_ _3840_/A _3840_/B VGND VGND VPWR VPWR _3861_/B sky130_fd_sc_hd__and2_2
X_6558_ _6411_/X _6428_/X _6431_/X _6434_/X _6589_/A _6493_/A VGND VGND VPWR VPWR
+ _6558_/X sky130_fd_sc_hd__mux4_2
X_6489_ _6014_/D _6879_/B2 _6187_/B _4290_/A _6319_/S _3868_/B VGND VGND VPWR VPWR
+ _6489_/X sky130_fd_sc_hd__mux4_2
X_5509_ _5441_/B _5417_/C _5417_/A VGND VGND VPWR VPWR _5511_/C sky130_fd_sc_hd__a21oi_2
XFILLER_79_508 VGND VGND VPWR VPWR sky130_fd_sc_hd__fill_2
XFILLER_59_243 VGND VGND VPWR VPWR sky130_fd_sc_hd__decap_3
XFILLER_87_552 VGND VGND VPWR VPWR sky130_fd_sc_hd__decap_3
XFILLER_59_287 VGND VGND VPWR VPWR sky130_fd_sc_hd__decap_3
XFILLER_87_585 VGND VGND VPWR VPWR sky130_fd_sc_hd__decap_3
XFILLER_47_449 VGND VGND VPWR VPWR sky130_fd_sc_hd__decap_3
XFILLER_15_324 VGND VGND VPWR VPWR sky130_fd_sc_hd__decap_3
XFILLER_35_41 VGND VGND VPWR VPWR sky130_fd_sc_hd__decap_3
XFILLER_82_290 VGND VGND VPWR VPWR sky130_fd_sc_hd__decap_3
XFILLER_35_74 VGND VGND VPWR VPWR sky130_fd_sc_hd__decap_3
XFILLER_15_379 VGND VGND VPWR VPWR sky130_fd_sc_hd__fill_1
XFILLER_30_327 VGND VGND VPWR VPWR sky130_fd_sc_hd__decap_3
XFILLER_70_485 VGND VGND VPWR VPWR sky130_fd_sc_hd__fill_1
XFILLER_23_390 VGND VGND VPWR VPWR sky130_fd_sc_hd__fill_2
XFILLER_7_501 VGND VGND VPWR VPWR sky130_fd_sc_hd__decap_3
XFILLER_7_523 VGND VGND VPWR VPWR sky130_fd_sc_hd__decap_3
XFILLER_51_95 VGND VGND VPWR VPWR sky130_fd_sc_hd__decap_3
XFILLER_7_545 VGND VGND VPWR VPWR sky130_fd_sc_hd__fill_1
XFILLER_7_556 VGND VGND VPWR VPWR sky130_fd_sc_hd__decap_3
XFILLER_7_567 VGND VGND VPWR VPWR sky130_fd_sc_hd__decap_3
XTAP_TAPCELL_ROW_77_1029 VGND VPWR sky130_fd_sc_hd__tapvpwrvgnd_1
Xload_slew404 _4925_/D VGND VGND VPWR VPWR _4685_/D sky130_fd_sc_hd__buf_2
XFILLER_97_305 VGND VGND VPWR VPWR sky130_fd_sc_hd__decap_3
XFILLER_2_272 VGND VGND VPWR VPWR sky130_fd_sc_hd__fill_2
Xload_slew415 input38/X VGND VGND VPWR VPWR _6029_/A2 sky130_fd_sc_hd__buf_6
XFILLER_97_349 VGND VGND VPWR VPWR sky130_fd_sc_hd__fill_1
Xload_slew448 _5487_/B VGND VGND VPWR VPWR _5452_/B sky130_fd_sc_hd__buf_2
XFILLER_93_511 VGND VGND VPWR VPWR sky130_fd_sc_hd__decap_3
XFILLER_38_449 VGND VGND VPWR VPWR sky130_fd_sc_hd__decap_3
XFILLER_65_257 VGND VGND VPWR VPWR sky130_fd_sc_hd__decap_3
XTAP_TAPCELL_ROW_88_1136 VGND VPWR sky130_fd_sc_hd__tapvpwrvgnd_1
XTAP_TAPCELL_ROW_0_209 VGND VPWR sky130_fd_sc_hd__tapvpwrvgnd_1
XFILLER_93_566 VGND VGND VPWR VPWR sky130_fd_sc_hd__decap_3
XFILLER_46_460 VGND VGND VPWR VPWR sky130_fd_sc_hd__fill_1
XFILLER_46_493 VGND VGND VPWR VPWR sky130_fd_sc_hd__fill_1
XFILLER_80_227 VGND VGND VPWR VPWR sky130_fd_sc_hd__decap_3
X_5860_ _3748_/A _5452_/B _5456_/B _5454_/X VGND VGND VPWR VPWR _5862_/B sky130_fd_sc_hd__a31o_2
XFILLER_61_430 VGND VGND VPWR VPWR sky130_fd_sc_hd__decap_3
XFILLER_61_452 VGND VGND VPWR VPWR sky130_fd_sc_hd__decap_3
XFILLER_73_290 VGND VGND VPWR VPWR sky130_fd_sc_hd__decap_3
X_4811_ _4811_/A _4811_/B _4811_/C VGND VGND VPWR VPWR _4813_/B sky130_fd_sc_hd__nand3_2
XFILLER_21_316 VGND VGND VPWR VPWR sky130_fd_sc_hd__decap_3
XFILLER_33_187 VGND VGND VPWR VPWR sky130_fd_sc_hd__fill_1
X_5791_ _6123_/A _5791_/B _5791_/C VGND VGND VPWR VPWR _5801_/A sky130_fd_sc_hd__and3_2
XTAP_TAPCELL_ROW_72_970 VGND VPWR sky130_fd_sc_hd__tapvpwrvgnd_1
XTAP_TAPCELL_ROW_44_683 VGND VPWR sky130_fd_sc_hd__tapvpwrvgnd_1
XFILLER_14_390 VGND VGND VPWR VPWR sky130_fd_sc_hd__fill_1
X_4742_ _4742_/A _4764_/B _4742_/C VGND VGND VPWR VPWR _4744_/B sky130_fd_sc_hd__nand3_2
XTAP_TAPCELL_ROW_16_385 VGND VPWR sky130_fd_sc_hd__tapvpwrvgnd_1
X_4673_ _4672_/A _4672_/C _4672_/B VGND VGND VPWR VPWR _4674_/B sky130_fd_sc_hd__a21o_2
X_6412_ _3495_/Y _4989_/B _4867_/A VGND VGND VPWR VPWR _6412_/Y sky130_fd_sc_hd__o21ai_2
X_3624_ _3624_/A _3624_/B VGND VGND VPWR VPWR _3831_/B sky130_fd_sc_hd__and2_2
XTAP_TAPCELL_ROW_99_1254 VGND VPWR sky130_fd_sc_hd__tapvpwrvgnd_1
X_6343_ _6625_/A _6368_/B VGND VGND VPWR VPWR _6700_/A sky130_fd_sc_hd__nor2_2
X_3555_ _3555_/A _3555_/B _3555_/C VGND VGND VPWR VPWR _3565_/A sky130_fd_sc_hd__nand3_2
XFILLER_0_209 VGND VGND VPWR VPWR sky130_fd_sc_hd__decap_3
XFILLER_88_305 VGND VGND VPWR VPWR sky130_fd_sc_hd__decap_3
X_6274_ _6931_/A _6904_/A VGND VGND VPWR VPWR _6274_/Y sky130_fd_sc_hd__nand2_2
X_3486_ _6276_/A VGND VGND VPWR VPWR _3486_/Y sky130_fd_sc_hd__inv_2
XFILLER_88_327 VGND VGND VPWR VPWR sky130_fd_sc_hd__decap_3
X_5225_ _5277_/C _5398_/C _5490_/D _5268_/C VGND VGND VPWR VPWR _5226_/B sky130_fd_sc_hd__a22o_2
XFILLER_69_541 VGND VGND VPWR VPWR sky130_fd_sc_hd__decap_3
XFILLER_29_416 VGND VGND VPWR VPWR sky130_fd_sc_hd__decap_3
XFILLER_56_213 VGND VGND VPWR VPWR sky130_fd_sc_hd__fill_1
X_5156_ _5156_/A _5156_/B VGND VGND VPWR VPWR _5159_/B sky130_fd_sc_hd__xnor2_2
XFILLER_29_438 VGND VGND VPWR VPWR sky130_fd_sc_hd__decap_3
XFILLER_29_449 VGND VGND VPWR VPWR sky130_fd_sc_hd__decap_3
XFILLER_84_533 VGND VGND VPWR VPWR sky130_fd_sc_hd__decap_3
X_5087_ _5084_/X _5085_/Y _5165_/A1 _5082_/Y VGND VGND VPWR VPWR _5089_/D sky130_fd_sc_hd__o211a_2
X_4107_ _4067_/A _6178_/A _4067_/C VGND VGND VPWR VPWR _4108_/B sky130_fd_sc_hd__a21o_2
XFILLER_44_419 VGND VGND VPWR VPWR sky130_fd_sc_hd__fill_1
XFILLER_56_268 VGND VGND VPWR VPWR sky130_fd_sc_hd__decap_3
X_4038_ _4039_/A _4039_/B VGND VGND VPWR VPWR _4038_/Y sky130_fd_sc_hd__nand2b_2
XFILLER_71_216 VGND VGND VPWR VPWR sky130_fd_sc_hd__decap_3
XFILLER_71_249 VGND VGND VPWR VPWR sky130_fd_sc_hd__decap_3
XFILLER_64_290 VGND VGND VPWR VPWR sky130_fd_sc_hd__decap_3
XFILLER_72_17 VGND VGND VPWR VPWR sky130_fd_sc_hd__fill_1
XFILLER_52_474 VGND VGND VPWR VPWR sky130_fd_sc_hd__fill_2
X_5989_ _5989_/A _5989_/B VGND VGND VPWR VPWR _6044_/A sky130_fd_sc_hd__xnor2_2
XFILLER_79_305 VGND VGND VPWR VPWR sky130_fd_sc_hd__decap_3
XFILLER_79_349 VGND VGND VPWR VPWR sky130_fd_sc_hd__fill_1
XFILLER_75_522 VGND VGND VPWR VPWR sky130_fd_sc_hd__decap_3
XFILLER_87_382 VGND VGND VPWR VPWR sky130_fd_sc_hd__decap_3
XFILLER_47_246 VGND VGND VPWR VPWR sky130_fd_sc_hd__fill_1
XFILLER_87_393 VGND VGND VPWR VPWR sky130_fd_sc_hd__decap_3
XFILLER_28_460 VGND VGND VPWR VPWR sky130_fd_sc_hd__decap_3
XFILLER_90_514 VGND VGND VPWR VPWR sky130_fd_sc_hd__decap_3
XFILLER_46_62 VGND VGND VPWR VPWR sky130_fd_sc_hd__fill_1
XFILLER_62_227 VGND VGND VPWR VPWR sky130_fd_sc_hd__decap_3
XFILLER_90_536 VGND VGND VPWR VPWR sky130_fd_sc_hd__decap_3
XFILLER_43_474 VGND VGND VPWR VPWR sky130_fd_sc_hd__fill_2
XFILLER_70_271 VGND VGND VPWR VPWR sky130_fd_sc_hd__decap_3
XFILLER_30_113 VGND VGND VPWR VPWR sky130_fd_sc_hd__decap_3
XFILLER_70_293 VGND VGND VPWR VPWR sky130_fd_sc_hd__decap_3
XTAP_TAPCELL_ROW_83_1088 VGND VPWR sky130_fd_sc_hd__tapvpwrvgnd_1
XFILLER_30_157 VGND VGND VPWR VPWR sky130_fd_sc_hd__decap_3
XFILLER_62_83 VGND VGND VPWR VPWR sky130_fd_sc_hd__fill_1
XFILLER_7_12 VGND VGND VPWR VPWR sky130_fd_sc_hd__decap_3
XTAP_TAPCELL_ROW_13_355 VGND VPWR sky130_fd_sc_hd__tapvpwrvgnd_1
XFILLER_11_371 VGND VGND VPWR VPWR sky130_fd_sc_hd__fill_1
XFILLER_11_393 VGND VGND VPWR VPWR sky130_fd_sc_hd__fill_2
XFILLER_7_23 VGND VGND VPWR VPWR sky130_fd_sc_hd__decap_3
XFILLER_7_353 VGND VGND VPWR VPWR sky130_fd_sc_hd__decap_3
Xwire251 _5947_/A VGND VGND VPWR VPWR _4407_/B sky130_fd_sc_hd__clkbuf_4
XFILLER_7_386 VGND VGND VPWR VPWR sky130_fd_sc_hd__decap_3
XFILLER_3_570 VGND VGND VPWR VPWR sky130_fd_sc_hd__decap_3
XFILLER_97_113 VGND VGND VPWR VPWR sky130_fd_sc_hd__decap_3
X_5010_ _5913_/B _4920_/X _5007_/B _5008_/X VGND VGND VPWR VPWR _5011_/B sky130_fd_sc_hd__o211ai_4
XFILLER_23_3 VGND VGND VPWR VPWR sky130_fd_sc_hd__decap_3
XFILLER_78_371 VGND VGND VPWR VPWR sky130_fd_sc_hd__fill_1
Xload_slew278 _5492_/B1 VGND VGND VPWR VPWR _5266_/D sky130_fd_sc_hd__buf_4
Xload_slew267 _6945_/B1 VGND VGND VPWR VPWR _6779_/A sky130_fd_sc_hd__buf_6
Xload_slew256 _5286_/A VGND VGND VPWR VPWR _3664_/B sky130_fd_sc_hd__buf_2
XFILLER_66_533 VGND VGND VPWR VPWR sky130_fd_sc_hd__decap_3
XFILLER_93_330 VGND VGND VPWR VPWR sky130_fd_sc_hd__decap_3
XTAP_TAPCELL_ROW_49_731 VGND VPWR sky130_fd_sc_hd__tapvpwrvgnd_1
XFILLER_93_352 VGND VGND VPWR VPWR sky130_fd_sc_hd__decap_3
XFILLER_19_482 VGND VGND VPWR VPWR sky130_fd_sc_hd__fill_2
XFILLER_53_216 VGND VGND VPWR VPWR sky130_fd_sc_hd__decap_3
XFILLER_81_547 VGND VGND VPWR VPWR sky130_fd_sc_hd__decap_3
XFILLER_93_396 VGND VGND VPWR VPWR sky130_fd_sc_hd__decap_3
X_6961_ _6961_/A1 _6832_/X _6875_/B VGND VGND VPWR VPWR _6961_/Y sky130_fd_sc_hd__a21oi_2
XFILLER_34_441 VGND VGND VPWR VPWR sky130_fd_sc_hd__decap_3
X_6892_ input18/X _6978_/B1 _6979_/B1 _6890_/A _6891_/X VGND VGND VPWR VPWR _6892_/X
+ sky130_fd_sc_hd__o221a_2
X_5912_ _5912_/A _5912_/B VGND VGND VPWR VPWR _5915_/A sky130_fd_sc_hd__xnor2_2
X_5843_ _5856_/A _5843_/B VGND VGND VPWR VPWR _5843_/X sky130_fd_sc_hd__or2_2
XFILLER_61_293 VGND VGND VPWR VPWR sky130_fd_sc_hd__decap_3
XFILLER_21_179 VGND VGND VPWR VPWR sky130_fd_sc_hd__decap_3
X_5774_ _6123_/A _6125_/B _5763_/C _5763_/D VGND VGND VPWR VPWR _5775_/B sky130_fd_sc_hd__a22oi_2
X_4725_ _4725_/A _5680_/B VGND VGND VPWR VPWR _4728_/A sky130_fd_sc_hd__and2_2
X_4656_ _4691_/B _4691_/A VGND VGND VPWR VPWR _4676_/B sky130_fd_sc_hd__and2b_2
X_4587_ _4585_/A _4782_/B _4823_/B _4584_/X VGND VGND VPWR VPWR _4590_/B sky130_fd_sc_hd__a31o_2
X_3607_ _4387_/B _4482_/C _4482_/D _4662_/B VGND VGND VPWR VPWR _3608_/D sky130_fd_sc_hd__a22o_2
X_6326_ _6746_/A _6317_/X _6767_/B _6325_/X VGND VGND VPWR VPWR _6326_/X sky130_fd_sc_hd__o22a_2
X_3538_ _3538_/A _3538_/B VGND VGND VPWR VPWR _4066_/A sky130_fd_sc_hd__xnor2_2
XFILLER_1_529 VGND VGND VPWR VPWR sky130_fd_sc_hd__decap_3
X_6257_ _6210_/Y _6247_/A _6247_/B _6253_/X VGND VGND VPWR VPWR _6794_/A sky130_fd_sc_hd__a31o_2
XFILLER_88_168 VGND VGND VPWR VPWR sky130_fd_sc_hd__decap_3
X_6188_ _6902_/A _6904_/B VGND VGND VPWR VPWR _6384_/C sky130_fd_sc_hd__nor2_2
X_5208_ _5707_/A _6116_/B VGND VGND VPWR VPWR _6117_/A sky130_fd_sc_hd__nand2_2
XFILLER_57_544 VGND VGND VPWR VPWR sky130_fd_sc_hd__fill_2
X_5139_ _5139_/A _5139_/B _5139_/C VGND VGND VPWR VPWR _5206_/A sky130_fd_sc_hd__and3_2
XFILLER_17_408 VGND VGND VPWR VPWR sky130_fd_sc_hd__fill_1
XFILLER_29_279 VGND VGND VPWR VPWR sky130_fd_sc_hd__fill_1
XFILLER_44_205 VGND VGND VPWR VPWR sky130_fd_sc_hd__decap_3
XFILLER_57_577 VGND VGND VPWR VPWR sky130_fd_sc_hd__decap_3
XFILLER_72_503 VGND VGND VPWR VPWR sky130_fd_sc_hd__decap_3
XFILLER_72_514 VGND VGND VPWR VPWR sky130_fd_sc_hd__decap_3
XFILLER_84_363 VGND VGND VPWR VPWR sky130_fd_sc_hd__fill_1
XFILLER_72_536 VGND VGND VPWR VPWR sky130_fd_sc_hd__fill_1
XFILLER_83_27 VGND VGND VPWR VPWR sky130_fd_sc_hd__decap_3
XFILLER_84_374 VGND VGND VPWR VPWR sky130_fd_sc_hd__decap_3
XFILLER_16_21 VGND VGND VPWR VPWR sky130_fd_sc_hd__fill_1
XFILLER_16_76 VGND VGND VPWR VPWR sky130_fd_sc_hd__decap_3
XFILLER_25_485 VGND VGND VPWR VPWR sky130_fd_sc_hd__decap_3
XFILLER_12_113 VGND VGND VPWR VPWR sky130_fd_sc_hd__fill_1
XFILLER_12_135 VGND VGND VPWR VPWR sky130_fd_sc_hd__decap_3
XFILLER_25_496 VGND VGND VPWR VPWR sky130_fd_sc_hd__decap_3
XFILLER_40_477 VGND VGND VPWR VPWR sky130_fd_sc_hd__decap_3
XFILLER_32_42 VGND VGND VPWR VPWR sky130_fd_sc_hd__fill_1
XTAP_TAPCELL_ROW_10_325 VGND VPWR sky130_fd_sc_hd__tapvpwrvgnd_1
XFILLER_4_323 VGND VGND VPWR VPWR sky130_fd_sc_hd__decap_3
XFILLER_4_378 VGND VGND VPWR VPWR sky130_fd_sc_hd__fill_1
XFILLER_79_124 VGND VGND VPWR VPWR sky130_fd_sc_hd__decap_3
XFILLER_79_157 VGND VGND VPWR VPWR sky130_fd_sc_hd__decap_3
XFILLER_0_551 VGND VGND VPWR VPWR sky130_fd_sc_hd__decap_3
XFILLER_0_573 VGND VGND VPWR VPWR sky130_fd_sc_hd__decap_3
XFILLER_67_308 VGND VGND VPWR VPWR sky130_fd_sc_hd__decap_3
XFILLER_0_595 VGND VGND VPWR VPWR sky130_fd_sc_hd__decap_3
XFILLER_48_533 VGND VGND VPWR VPWR sky130_fd_sc_hd__fill_2
XTAP_TAPCELL_ROW_46_701 VGND VPWR sky130_fd_sc_hd__tapvpwrvgnd_1
XFILLER_63_525 VGND VGND VPWR VPWR sky130_fd_sc_hd__decap_3
XFILLER_75_374 VGND VGND VPWR VPWR sky130_fd_sc_hd__decap_3
XFILLER_90_322 VGND VGND VPWR VPWR sky130_fd_sc_hd__decap_3
XTAP_TAPCELL_ROW_85_1106 VGND VPWR sky130_fd_sc_hd__tapvpwrvgnd_1
XTAP_TAPCELL_ROW_18_403 VGND VPWR sky130_fd_sc_hd__tapvpwrvgnd_1
XFILLER_73_60 VGND VGND VPWR VPWR sky130_fd_sc_hd__decap_3
XFILLER_90_377 VGND VGND VPWR VPWR sky130_fd_sc_hd__decap_3
XFILLER_71_591 VGND VGND VPWR VPWR sky130_fd_sc_hd__decap_3
XTAP_TAPCELL_ROW_26_491 VGND VPWR sky130_fd_sc_hd__tapvpwrvgnd_1
XFILLER_31_455 VGND VGND VPWR VPWR sky130_fd_sc_hd__decap_3
XFILLER_31_488 VGND VGND VPWR VPWR sky130_fd_sc_hd__fill_2
X_5490_ _5588_/A _5630_/A _5490_/C _5490_/D VGND VGND VPWR VPWR _5490_/X sky130_fd_sc_hd__and4_2
X_4510_ _4509_/A _4508_/Y _4392_/B _4504_/X VGND VGND VPWR VPWR _4510_/X sky130_fd_sc_hd__o211a_2
XTAP_TAPCELL_ROW_96_1224 VGND VPWR sky130_fd_sc_hd__tapvpwrvgnd_1
XFILLER_7_161 VGND VGND VPWR VPWR sky130_fd_sc_hd__fill_2
XFILLER_7_172 VGND VGND VPWR VPWR sky130_fd_sc_hd__decap_3
X_4441_ _4441_/A _4441_/B _4441_/C VGND VGND VPWR VPWR _4441_/X sky130_fd_sc_hd__and3_2
XPHY_EDGE_ROW_9_Right_9 VGND VGND VPWR VPWR sky130_fd_sc_hd__decap_3
X_6111_ _6138_/A _6111_/B VGND VGND VPWR VPWR _6381_/A sky130_fd_sc_hd__nand2_2
X_4372_ _4372_/A _4372_/B VGND VGND VPWR VPWR _4373_/C sky130_fd_sc_hd__xnor2_2
XFILLER_98_400 VGND VGND VPWR VPWR sky130_fd_sc_hd__decap_3
Xfanout608 input19/X VGND VGND VPWR VPWR _6275_/B sky130_fd_sc_hd__clkdlybuf4s25_1
XFILLER_98_444 VGND VGND VPWR VPWR sky130_fd_sc_hd__decap_3
XFILLER_39_511 VGND VGND VPWR VPWR sky130_fd_sc_hd__decap_3
X_6042_ _6042_/A _6042_/B VGND VGND VPWR VPWR _6043_/B sky130_fd_sc_hd__xnor2_2
XFILLER_98_477 VGND VGND VPWR VPWR sky130_fd_sc_hd__decap_3
XFILLER_100_449 VGND VGND VPWR VPWR sky130_fd_sc_hd__decap_3
XFILLER_39_533 VGND VGND VPWR VPWR sky130_fd_sc_hd__decap_3
XFILLER_66_330 VGND VGND VPWR VPWR sky130_fd_sc_hd__decap_3
XFILLER_39_577 VGND VGND VPWR VPWR sky130_fd_sc_hd__decap_3
XFILLER_54_536 VGND VGND VPWR VPWR sky130_fd_sc_hd__decap_3
XFILLER_66_374 VGND VGND VPWR VPWR sky130_fd_sc_hd__decap_3
XFILLER_81_311 VGND VGND VPWR VPWR sky130_fd_sc_hd__decap_3
XFILLER_93_193 VGND VGND VPWR VPWR sky130_fd_sc_hd__decap_3
X_6944_ _6829_/A _6680_/C _6944_/B1 _6815_/X VGND VGND VPWR VPWR _6946_/B sky130_fd_sc_hd__a2bb2o_2
XFILLER_81_377 VGND VGND VPWR VPWR sky130_fd_sc_hd__decap_3
XFILLER_22_411 VGND VGND VPWR VPWR sky130_fd_sc_hd__decap_3
XFILLER_34_282 VGND VGND VPWR VPWR sky130_fd_sc_hd__decap_3
X_6875_ _6875_/A _6875_/B VGND VGND VPWR VPWR _6875_/Y sky130_fd_sc_hd__nand2_2
XTAP_TAPCELL_ROW_52_759 VGND VPWR sky130_fd_sc_hd__tapvpwrvgnd_1
XFILLER_22_466 VGND VGND VPWR VPWR sky130_fd_sc_hd__decap_3
XFILLER_22_477 VGND VGND VPWR VPWR sky130_fd_sc_hd__decap_3
X_5826_ _5826_/A _5826_/B _5826_/C VGND VGND VPWR VPWR _5826_/X sky130_fd_sc_hd__or3_4
X_5757_ _5757_/A _5757_/B VGND VGND VPWR VPWR _5760_/B sky130_fd_sc_hd__xnor2_2
X_4708_ _4708_/A _4708_/B VGND VGND VPWR VPWR _4709_/B sky130_fd_sc_hd__xnor2_2
X_5688_ _6650_/A VGND VGND VPWR VPWR _5688_/Y sky130_fd_sc_hd__inv_2
X_4639_ _4657_/A _4657_/B VGND VGND VPWR VPWR _4642_/C sky130_fd_sc_hd__nand2b_2
XFILLER_1_337 VGND VGND VPWR VPWR sky130_fd_sc_hd__decap_3
XFILLER_89_433 VGND VGND VPWR VPWR sky130_fd_sc_hd__decap_3
X_6309_ _3498_/Y _6319_/S _4552_/A VGND VGND VPWR VPWR _6309_/Y sky130_fd_sc_hd__o21ai_2
XFILLER_49_308 VGND VGND VPWR VPWR sky130_fd_sc_hd__decap_3
XFILLER_89_477 VGND VGND VPWR VPWR sky130_fd_sc_hd__decap_3
XFILLER_76_127 VGND VGND VPWR VPWR sky130_fd_sc_hd__decap_3
XFILLER_94_26 VGND VGND VPWR VPWR sky130_fd_sc_hd__fill_2
XFILLER_45_503 VGND VGND VPWR VPWR sky130_fd_sc_hd__fill_1
XFILLER_57_352 VGND VGND VPWR VPWR sky130_fd_sc_hd__fill_2
XFILLER_57_363 VGND VGND VPWR VPWR sky130_fd_sc_hd__fill_1
XFILLER_69_190 VGND VGND VPWR VPWR sky130_fd_sc_hd__decap_3
XFILLER_27_53 VGND VGND VPWR VPWR sky130_fd_sc_hd__decap_3
XFILLER_45_514 VGND VGND VPWR VPWR sky130_fd_sc_hd__decap_3
XFILLER_57_385 VGND VGND VPWR VPWR sky130_fd_sc_hd__decap_3
XFILLER_72_300 VGND VGND VPWR VPWR sky130_fd_sc_hd__decap_3
XFILLER_84_182 VGND VGND VPWR VPWR sky130_fd_sc_hd__decap_3
XFILLER_60_517 VGND VGND VPWR VPWR sky130_fd_sc_hd__decap_3
XFILLER_13_411 VGND VGND VPWR VPWR sky130_fd_sc_hd__decap_3
XFILLER_13_455 VGND VGND VPWR VPWR sky130_fd_sc_hd__decap_3
XFILLER_43_74 VGND VGND VPWR VPWR sky130_fd_sc_hd__decap_3
XTAP_TAPCELL_ROW_80_1058 VGND VPWR sky130_fd_sc_hd__tapvpwrvgnd_1
XFILLER_9_404 VGND VGND VPWR VPWR sky130_fd_sc_hd__decap_3
XFILLER_40_274 VGND VGND VPWR VPWR sky130_fd_sc_hd__decap_3
XTAP_TAPCELL_ROW_23_461 VGND VPWR sky130_fd_sc_hd__tapvpwrvgnd_1
XFILLER_4_131 VGND VGND VPWR VPWR sky130_fd_sc_hd__decap_3
XFILLER_57_9 VGND VGND VPWR VPWR sky130_fd_sc_hd__fill_2
XFILLER_4_197 VGND VGND VPWR VPWR sky130_fd_sc_hd__decap_3
XTAP_TAPCELL_ROW_91_1176 VGND VPWR sky130_fd_sc_hd__tapvpwrvgnd_1
XFILLER_0_381 VGND VGND VPWR VPWR sky130_fd_sc_hd__decap_3
XFILLER_67_127 VGND VGND VPWR VPWR sky130_fd_sc_hd__decap_3
XFILLER_68_82 VGND VGND VPWR VPWR sky130_fd_sc_hd__fill_2
XFILLER_95_458 VGND VGND VPWR VPWR sky130_fd_sc_hd__decap_3
XFILLER_95_447 VGND VGND VPWR VPWR sky130_fd_sc_hd__fill_1
XFILLER_36_536 VGND VGND VPWR VPWR sky130_fd_sc_hd__decap_3
XFILLER_48_385 VGND VGND VPWR VPWR sky130_fd_sc_hd__decap_3
XFILLER_63_311 VGND VGND VPWR VPWR sky130_fd_sc_hd__decap_3
XFILLER_36_558 VGND VGND VPWR VPWR sky130_fd_sc_hd__decap_3
XFILLER_84_92 VGND VGND VPWR VPWR sky130_fd_sc_hd__decap_3
XFILLER_90_141 VGND VGND VPWR VPWR sky130_fd_sc_hd__fill_2
XFILLER_63_388 VGND VGND VPWR VPWR sky130_fd_sc_hd__decap_3
XFILLER_90_163 VGND VGND VPWR VPWR sky130_fd_sc_hd__decap_3
X_4990_ _4990_/A _4990_/B VGND VGND VPWR VPWR _4991_/C sky130_fd_sc_hd__xnor2_2
X_3941_ _3941_/A _3941_/B _3941_/C VGND VGND VPWR VPWR _3941_/X sky130_fd_sc_hd__and3_2
XFILLER_31_241 VGND VGND VPWR VPWR sky130_fd_sc_hd__decap_3
XFILLER_90_3 VGND VGND VPWR VPWR sky130_fd_sc_hd__fill_1
X_6660_ _6767_/B _6491_/B _6501_/X _6746_/A _6638_/A VGND VGND VPWR VPWR _6660_/X
+ sky130_fd_sc_hd__o221a_2
X_3872_ _3872_/A _3872_/B VGND VGND VPWR VPWR _3873_/B sky130_fd_sc_hd__nand2_2
X_6591_ _5135_/Y _6891_/B1 _6506_/B _6583_/A _6590_/X VGND VGND VPWR VPWR _6591_/X
+ sky130_fd_sc_hd__o221a_2
X_5611_ _5611_/A VGND VGND VPWR VPWR _5611_/Y sky130_fd_sc_hd__inv_2
X_5542_ _5542_/A _5542_/B VGND VGND VPWR VPWR _5574_/A sky130_fd_sc_hd__xnor2_2
XTAP_TAPCELL_ROW_100_1272 VGND VPWR sky130_fd_sc_hd__tapvpwrvgnd_1
XFILLER_8_470 VGND VGND VPWR VPWR sky130_fd_sc_hd__fill_1
X_5473_ _5473_/A _5473_/B VGND VGND VPWR VPWR _5473_/Y sky130_fd_sc_hd__nor2_2
X_4424_ _4822_/A _4539_/B _4423_/B _4420_/X VGND VGND VPWR VPWR _4425_/C sky130_fd_sc_hd__a31oi_2
Xfanout405 input39/X VGND VGND VPWR VPWR _6211_/B sky130_fd_sc_hd__clkdlybuf4s25_1
X_4355_ _4355_/A _4476_/B VGND VGND VPWR VPWR _4461_/A sky130_fd_sc_hd__nand2_2
XFILLER_98_230 VGND VGND VPWR VPWR sky130_fd_sc_hd__fill_1
Xfanout416 _4694_/C VGND VGND VPWR VPWR _5188_/C sky130_fd_sc_hd__clkbuf_4
Xfanout427 _6019_/C VGND VGND VPWR VPWR _4607_/D sky130_fd_sc_hd__clkdlybuf4s25_1
Xfanout438 _5321_/C VGND VGND VPWR VPWR _5341_/C sky130_fd_sc_hd__buf_4
XFILLER_98_274 VGND VGND VPWR VPWR sky130_fd_sc_hd__decap_3
XFILLER_86_436 VGND VGND VPWR VPWR sky130_fd_sc_hd__decap_3
Xfanout449 _6492_/S0 VGND VGND VPWR VPWR _4589_/B sky130_fd_sc_hd__clkdlybuf4s25_1
X_4286_ _4272_/A _4272_/C _4272_/B VGND VGND VPWR VPWR _4286_/Y sky130_fd_sc_hd__a21oi_2
XFILLER_98_285 VGND VGND VPWR VPWR sky130_fd_sc_hd__decap_3
XFILLER_100_268 VGND VGND VPWR VPWR sky130_fd_sc_hd__decap_3
XFILLER_86_458 VGND VGND VPWR VPWR sky130_fd_sc_hd__decap_3
X_6025_ _6025_/A _6025_/B VGND VGND VPWR VPWR _6026_/B sky130_fd_sc_hd__nand2_2
XTAP_TAPCELL_ROW_57_818 VGND VPWR sky130_fd_sc_hd__tapvpwrvgnd_1
XFILLER_39_374 VGND VGND VPWR VPWR sky130_fd_sc_hd__decap_3
XFILLER_66_171 VGND VGND VPWR VPWR sky130_fd_sc_hd__decap_3
XFILLER_73_119 VGND VGND VPWR VPWR sky130_fd_sc_hd__decap_3
XFILLER_94_480 VGND VGND VPWR VPWR sky130_fd_sc_hd__decap_3
XFILLER_64_29 VGND VGND VPWR VPWR sky130_fd_sc_hd__decap_3
XFILLER_81_196 VGND VGND VPWR VPWR sky130_fd_sc_hd__decap_3
X_6927_ _6174_/Y _6963_/A2 _6927_/B1 _6176_/A VGND VGND VPWR VPWR _6927_/X sky130_fd_sc_hd__o22a_2
XTAP_TAPCELL_ROW_65_895 VGND VPWR sky130_fd_sc_hd__tapvpwrvgnd_1
XFILLER_50_550 VGND VGND VPWR VPWR sky130_fd_sc_hd__fill_1
X_6858_ _6168_/X _6860_/A _6971_/B VGND VGND VPWR VPWR _6858_/Y sky130_fd_sc_hd__o21ai_2
X_5809_ _5809_/A _5809_/B VGND VGND VPWR VPWR _5810_/B sky130_fd_sc_hd__xor2_2
XFILLER_10_447 VGND VGND VPWR VPWR sky130_fd_sc_hd__decap_3
XFILLER_10_458 VGND VGND VPWR VPWR sky130_fd_sc_hd__decap_3
X_6789_ _6789_/A1 _6476_/A _6765_/Y _6786_/X _6788_/X VGND VGND VPWR VPWR _6790_/B
+ sky130_fd_sc_hd__o311a_2
XTAP_TAPCELL_ROW_20_431 VGND VPWR sky130_fd_sc_hd__tapvpwrvgnd_1
XFILLER_77_414 VGND VGND VPWR VPWR sky130_fd_sc_hd__decap_3
XFILLER_89_252 VGND VGND VPWR VPWR sky130_fd_sc_hd__decap_3
XFILLER_89_274 VGND VGND VPWR VPWR sky130_fd_sc_hd__decap_3
XFILLER_49_116 VGND VGND VPWR VPWR sky130_fd_sc_hd__decap_3
XFILLER_49_127 VGND VGND VPWR VPWR sky130_fd_sc_hd__decap_3
XFILLER_77_436 VGND VGND VPWR VPWR sky130_fd_sc_hd__decap_3
XFILLER_89_296 VGND VGND VPWR VPWR sky130_fd_sc_hd__decap_3
XFILLER_92_406 VGND VGND VPWR VPWR sky130_fd_sc_hd__decap_3
XFILLER_38_85 VGND VGND VPWR VPWR sky130_fd_sc_hd__decap_3
XFILLER_64_119 VGND VGND VPWR VPWR sky130_fd_sc_hd__decap_3
XFILLER_18_536 VGND VGND VPWR VPWR sky130_fd_sc_hd__fill_1
XFILLER_18_547 VGND VGND VPWR VPWR sky130_fd_sc_hd__fill_1
XFILLER_57_193 VGND VGND VPWR VPWR sky130_fd_sc_hd__decap_3
XFILLER_45_377 VGND VGND VPWR VPWR sky130_fd_sc_hd__decap_3
XFILLER_72_141 VGND VGND VPWR VPWR sky130_fd_sc_hd__decap_3
XFILLER_54_62 VGND VGND VPWR VPWR sky130_fd_sc_hd__decap_3
XFILLER_60_336 VGND VGND VPWR VPWR sky130_fd_sc_hd__decap_3
XFILLER_72_174 VGND VGND VPWR VPWR sky130_fd_sc_hd__decap_3
XFILLER_13_252 VGND VGND VPWR VPWR sky130_fd_sc_hd__decap_3
XFILLER_9_223 VGND VGND VPWR VPWR sky130_fd_sc_hd__fill_1
XFILLER_70_83 VGND VGND VPWR VPWR sky130_fd_sc_hd__fill_1
XFILLER_5_473 VGND VGND VPWR VPWR sky130_fd_sc_hd__decap_3
XFILLER_5_495 VGND VGND VPWR VPWR sky130_fd_sc_hd__decap_3
XFILLER_68_403 VGND VGND VPWR VPWR sky130_fd_sc_hd__decap_3
X_4140_ _4111_/Y _4139_/X _4075_/X _4085_/Y VGND VGND VPWR VPWR _4197_/A sky130_fd_sc_hd__a211oi_2
X_4071_ _4068_/A _4108_/A _4111_/A VGND VGND VPWR VPWR _4074_/B sky130_fd_sc_hd__o21ai_2
XFILLER_95_266 VGND VGND VPWR VPWR sky130_fd_sc_hd__decap_3
XFILLER_95_299 VGND VGND VPWR VPWR sky130_fd_sc_hd__decap_3
XFILLER_24_506 VGND VGND VPWR VPWR sky130_fd_sc_hd__decap_3
XFILLER_36_355 VGND VGND VPWR VPWR sky130_fd_sc_hd__fill_2
XFILLER_36_388 VGND VGND VPWR VPWR sky130_fd_sc_hd__decap_3
X_4973_ _4746_/X _4761_/Y _4956_/A _4760_/A VGND VGND VPWR VPWR _4973_/Y sky130_fd_sc_hd__o211ai_2
X_6712_ _6639_/X _6711_/X _6783_/S VGND VGND VPWR VPWR _6712_/X sky130_fd_sc_hd__mux2_1
X_3924_ _3925_/A _6153_/A VGND VGND VPWR VPWR _3924_/Y sky130_fd_sc_hd__nor2_2
XTAP_TAPCELL_ROW_62_865 VGND VPWR sky130_fd_sc_hd__tapvpwrvgnd_1
XFILLER_32_572 VGND VGND VPWR VPWR sky130_fd_sc_hd__decap_3
X_6643_ _6700_/A _6458_/X _6642_/X VGND VGND VPWR VPWR _6643_/Y sky130_fd_sc_hd__a21oi_2
XTAP_TAPCELL_ROW_34_578 VGND VPWR sky130_fd_sc_hd__tapvpwrvgnd_1
X_3855_ _3855_/A _3855_/B VGND VGND VPWR VPWR _3857_/B sky130_fd_sc_hd__xnor2_2
X_6574_ _4010_/B input28/X wire557/A wire571/A _6744_/S0 _6876_/S1 VGND VGND VPWR
+ VPWR _6574_/X sky130_fd_sc_hd__mux4_2
X_3786_ _3990_/A _3991_/B _3961_/C _3961_/D VGND VGND VPWR VPWR _3788_/A sky130_fd_sc_hd__and4_2
X_5525_ _5525_/A _5525_/B VGND VGND VPWR VPWR _5557_/A sky130_fd_sc_hd__xnor2_2
X_5456_ _5454_/X _5456_/B VGND VGND VPWR VPWR _5457_/B sky130_fd_sc_hd__and2b_2
XFILLER_59_18 VGND VGND VPWR VPWR sky130_fd_sc_hd__decap_3
X_4407_ input9/X _4407_/B VGND VGND VPWR VPWR _4409_/B sky130_fd_sc_hd__nand2_2
Xfanout202 _3923_/B VGND VGND VPWR VPWR _6152_/A sky130_fd_sc_hd__clkbuf_2
Xfanout213 _6016_/C VGND VGND VPWR VPWR _4662_/D sky130_fd_sc_hd__clkdlybuf4s25_1
X_5387_ _5381_/A _5381_/C _5620_/A VGND VGND VPWR VPWR _5388_/B sky130_fd_sc_hd__a21o_2
XFILLER_99_572 VGND VGND VPWR VPWR sky130_fd_sc_hd__decap_3
XFILLER_86_200 VGND VGND VPWR VPWR sky130_fd_sc_hd__decap_3
Xfanout235 _4755_/D VGND VGND VPWR VPWR _5382_/D sky130_fd_sc_hd__buf_6
Xfanout246 input60/X VGND VGND VPWR VPWR _6216_/B sky130_fd_sc_hd__buf_6
X_4338_ _4593_/A _4457_/D _4337_/B _4334_/X VGND VGND VPWR VPWR _4341_/B sky130_fd_sc_hd__a31o_2
XFILLER_59_458 VGND VGND VPWR VPWR sky130_fd_sc_hd__decap_3
Xfanout257 input6/X VGND VGND VPWR VPWR _6244_/B sky130_fd_sc_hd__clkdlybuf4s25_1
Xfanout268 _6363_/A VGND VGND VPWR VPWR _4978_/C sky130_fd_sc_hd__clkbuf_2
Xfanout279 _6121_/B VGND VGND VPWR VPWR _5725_/C sky130_fd_sc_hd__buf_4
X_4269_ _4269_/A _4269_/B VGND VGND VPWR VPWR _4372_/B sky130_fd_sc_hd__xnor2_2
XFILLER_39_160 VGND VGND VPWR VPWR sky130_fd_sc_hd__decap_3
XFILLER_46_119 VGND VGND VPWR VPWR sky130_fd_sc_hd__fill_2
XFILLER_86_277 VGND VGND VPWR VPWR sky130_fd_sc_hd__decap_3
X_6008_ _6008_/A _6008_/B VGND VGND VPWR VPWR _6009_/B sky130_fd_sc_hd__nand2_2
XFILLER_54_130 VGND VGND VPWR VPWR sky130_fd_sc_hd__fill_2
XFILLER_27_377 VGND VGND VPWR VPWR sky130_fd_sc_hd__decap_3
XFILLER_54_141 VGND VGND VPWR VPWR sky130_fd_sc_hd__decap_3
XFILLER_82_450 VGND VGND VPWR VPWR sky130_fd_sc_hd__decap_3
XFILLER_27_399 VGND VGND VPWR VPWR sky130_fd_sc_hd__decap_3
XFILLER_42_347 VGND VGND VPWR VPWR sky130_fd_sc_hd__decap_3
XPHY_EDGE_ROW_59_Left_160 VGND VGND VPWR VPWR sky130_fd_sc_hd__decap_3
XFILLER_23_561 VGND VGND VPWR VPWR sky130_fd_sc_hd__decap_3
XFILLER_50_380 VGND VGND VPWR VPWR sky130_fd_sc_hd__decap_3
XFILLER_6_248 VGND VGND VPWR VPWR sky130_fd_sc_hd__decap_3
XFILLER_2_421 VGND VGND VPWR VPWR sky130_fd_sc_hd__fill_2
XFILLER_65_428 VGND VGND VPWR VPWR sky130_fd_sc_hd__decap_3
XFILLER_77_266 VGND VGND VPWR VPWR sky130_fd_sc_hd__decap_3
XFILLER_77_299 VGND VGND VPWR VPWR sky130_fd_sc_hd__decap_3
XFILLER_92_214 VGND VGND VPWR VPWR sky130_fd_sc_hd__decap_3
XTAP_TAPCELL_ROW_5_270 VGND VPWR sky130_fd_sc_hd__tapvpwrvgnd_1
XFILLER_58_480 VGND VGND VPWR VPWR sky130_fd_sc_hd__decap_3
XFILLER_65_50 VGND VGND VPWR VPWR sky130_fd_sc_hd__decap_3
XFILLER_92_247 VGND VGND VPWR VPWR sky130_fd_sc_hd__decap_3
XFILLER_73_461 VGND VGND VPWR VPWR sky130_fd_sc_hd__decap_3
XFILLER_73_494 VGND VGND VPWR VPWR sky130_fd_sc_hd__decap_3
XFILLER_33_369 VGND VGND VPWR VPWR sky130_fd_sc_hd__decap_3
XFILLER_60_144 VGND VGND VPWR VPWR sky130_fd_sc_hd__fill_2
XFILLER_81_82 VGND VGND VPWR VPWR sky130_fd_sc_hd__decap_3
X_3640_ _3640_/A1 _4628_/C _3638_/D _5999_/A1 VGND VGND VPWR VPWR _3641_/B sky130_fd_sc_hd__a22o_2
X_3571_ _4636_/C _4097_/B VGND VGND VPWR VPWR _4095_/A sky130_fd_sc_hd__nand2_2
XFILLER_53_3 VGND VGND VPWR VPWR sky130_fd_sc_hd__fill_1
X_6290_ _6348_/A _6290_/B VGND VGND VPWR VPWR _6291_/B sky130_fd_sc_hd__xnor2_2
X_5310_ _5341_/B _5322_/B _5302_/B _5300_/X VGND VGND VPWR VPWR _5315_/A sky130_fd_sc_hd__a31o_2
XFILLER_5_270 VGND VGND VPWR VPWR sky130_fd_sc_hd__decap_3
X_5241_ _5241_/A _5241_/B VGND VGND VPWR VPWR _5242_/C sky130_fd_sc_hd__and2_2
XFILLER_68_200 VGND VGND VPWR VPWR sky130_fd_sc_hd__decap_3
X_5172_ _5112_/Y _5250_/A _5171_/Y _5089_/X VGND VGND VPWR VPWR _5172_/X sky130_fd_sc_hd__o211a_4
X_4123_ _4607_/B _4505_/B _4361_/C _4361_/D VGND VGND VPWR VPWR _4126_/A sky130_fd_sc_hd__and4_2
XFILLER_28_108 VGND VGND VPWR VPWR sky130_fd_sc_hd__decap_3
Xinput2 A[10] VGND VGND VPWR VPWR input2/X sky130_fd_sc_hd__clkbuf_2
X_4054_ _4054_/A _4054_/B _4054_/C VGND VGND VPWR VPWR _4056_/C sky130_fd_sc_hd__nor3_2
XTAP_TAPCELL_ROW_67_924 VGND VPWR sky130_fd_sc_hd__tapvpwrvgnd_1
XTAP_TAPCELL_ROW_39_626 VGND VPWR sky130_fd_sc_hd__tapvpwrvgnd_1
XFILLER_96_597 VGND VGND VPWR VPWR sky130_fd_sc_hd__fill_1
XFILLER_49_491 VGND VGND VPWR VPWR sky130_fd_sc_hd__decap_3
XFILLER_68_299 VGND VGND VPWR VPWR sky130_fd_sc_hd__decap_3
XFILLER_83_225 VGND VGND VPWR VPWR sky130_fd_sc_hd__decap_3
XFILLER_83_258 VGND VGND VPWR VPWR sky130_fd_sc_hd__decap_3
XFILLER_71_409 VGND VGND VPWR VPWR sky130_fd_sc_hd__decap_3
XFILLER_64_483 VGND VGND VPWR VPWR sky130_fd_sc_hd__decap_3
XFILLER_24_347 VGND VGND VPWR VPWR sky130_fd_sc_hd__decap_3
X_4956_ _4956_/A _4956_/B _4956_/C VGND VGND VPWR VPWR _4956_/X sky130_fd_sc_hd__and3_4
XFILLER_20_531 VGND VGND VPWR VPWR sky130_fd_sc_hd__fill_1
XFILLER_51_199 VGND VGND VPWR VPWR sky130_fd_sc_hd__decap_3
X_4887_ _4473_/B _4465_/C _4465_/A VGND VGND VPWR VPWR _4888_/B sky130_fd_sc_hd__o21ai_2
X_3907_ _3907_/A _3907_/B VGND VGND VPWR VPWR _3913_/A sky130_fd_sc_hd__xnor2_2
X_6626_ _6700_/A _6420_/Y _6625_/Y VGND VGND VPWR VPWR _6626_/X sky130_fd_sc_hd__a21o_2
X_3838_ _3838_/A _3838_/B VGND VGND VPWR VPWR _3840_/B sky130_fd_sc_hd__xnor2_2
X_6557_ _6698_/A _6556_/Y _6546_/X VGND VGND VPWR VPWR _6557_/X sky130_fd_sc_hd__a21o_2
X_5508_ _5514_/A _5508_/B _5473_/Y VGND VGND VPWR VPWR _5511_/A sky130_fd_sc_hd__or3b_4
X_3769_ _3769_/A _3769_/B VGND VGND VPWR VPWR _3775_/A sky130_fd_sc_hd__nor2_2
X_6488_ _6410_/X _6412_/Y _6831_/S VGND VGND VPWR VPWR _6488_/X sky130_fd_sc_hd__mux2_1
X_5439_ _5511_/B _5464_/B _5439_/C VGND VGND VPWR VPWR _5441_/A sky130_fd_sc_hd__and3_4
XFILLER_59_211 VGND VGND VPWR VPWR sky130_fd_sc_hd__decap_3
XFILLER_86_38 VGND VGND VPWR VPWR sky130_fd_sc_hd__fill_2
XFILLER_87_531 VGND VGND VPWR VPWR sky130_fd_sc_hd__decap_3
XFILLER_59_255 VGND VGND VPWR VPWR sky130_fd_sc_hd__decap_3
XFILLER_86_49 VGND VGND VPWR VPWR sky130_fd_sc_hd__decap_3
XFILLER_87_564 VGND VGND VPWR VPWR sky130_fd_sc_hd__decap_3
XFILLER_47_417 VGND VGND VPWR VPWR sky130_fd_sc_hd__decap_3
XFILLER_59_277 VGND VGND VPWR VPWR sky130_fd_sc_hd__decap_3
XFILLER_74_203 VGND VGND VPWR VPWR sky130_fd_sc_hd__decap_3
XFILLER_87_597 VGND VGND VPWR VPWR sky130_fd_sc_hd__fill_1
XFILLER_19_76 VGND VGND VPWR VPWR sky130_fd_sc_hd__decap_3
XFILLER_74_225 VGND VGND VPWR VPWR sky130_fd_sc_hd__decap_3
XTAP_TAPCELL_ROW_2_240 VGND VPWR sky130_fd_sc_hd__tapvpwrvgnd_1
XFILLER_42_133 VGND VGND VPWR VPWR sky130_fd_sc_hd__decap_3
XFILLER_35_86 VGND VGND VPWR VPWR sky130_fd_sc_hd__decap_3
XFILLER_11_520 VGND VGND VPWR VPWR sky130_fd_sc_hd__decap_3
XFILLER_11_564 VGND VGND VPWR VPWR sky130_fd_sc_hd__fill_2
XFILLER_7_579 VGND VGND VPWR VPWR sky130_fd_sc_hd__decap_3
XFILLER_2_240 VGND VGND VPWR VPWR sky130_fd_sc_hd__decap_3
XFILLER_97_317 VGND VGND VPWR VPWR sky130_fd_sc_hd__fill_1
XFILLER_65_203 VGND VGND VPWR VPWR sky130_fd_sc_hd__decap_3
XFILLER_78_597 VGND VGND VPWR VPWR sky130_fd_sc_hd__fill_1
XFILLER_93_523 VGND VGND VPWR VPWR sky130_fd_sc_hd__decap_3
XFILLER_18_6 VGND VGND VPWR VPWR sky130_fd_sc_hd__decap_3
XFILLER_65_225 VGND VGND VPWR VPWR sky130_fd_sc_hd__decap_3
XFILLER_76_82 VGND VGND VPWR VPWR sky130_fd_sc_hd__fill_2
XTAP_TAPCELL_ROW_88_1137 VGND VPWR sky130_fd_sc_hd__tapvpwrvgnd_1
XFILLER_53_409 VGND VGND VPWR VPWR sky130_fd_sc_hd__decap_3
XFILLER_65_269 VGND VGND VPWR VPWR sky130_fd_sc_hd__decap_3
XFILLER_80_206 VGND VGND VPWR VPWR sky130_fd_sc_hd__decap_3
XFILLER_93_578 VGND VGND VPWR VPWR sky130_fd_sc_hd__decap_3
XFILLER_33_133 VGND VGND VPWR VPWR sky130_fd_sc_hd__decap_3
XFILLER_92_70 VGND VGND VPWR VPWR sky130_fd_sc_hd__fill_2
X_4810_ _4526_/A _4766_/B _4527_/A _4526_/D VGND VGND VPWR VPWR _4811_/C sky130_fd_sc_hd__a22o_2
X_5790_ _5790_/A _5790_/B VGND VGND VPWR VPWR _5791_/C sky130_fd_sc_hd__nor2_2
XTAP_TAPCELL_ROW_72_971 VGND VPWR sky130_fd_sc_hd__tapvpwrvgnd_1
XTAP_TAPCELL_ROW_44_684 VGND VPWR sky130_fd_sc_hd__tapvpwrvgnd_1
XFILLER_33_199 VGND VGND VPWR VPWR sky130_fd_sc_hd__decap_3
X_4741_ _5068_/A _4757_/B _4764_/A _4740_/D VGND VGND VPWR VPWR _4742_/C sky130_fd_sc_hd__a22o_2
XTAP_TAPCELL_ROW_16_386 VGND VPWR sky130_fd_sc_hd__tapvpwrvgnd_1
X_4672_ _4672_/A _4672_/B _4672_/C VGND VGND VPWR VPWR _4672_/X sky130_fd_sc_hd__and3_2
X_6411_ _6409_/X _6410_/X _6434_/S VGND VGND VPWR VPWR _6411_/X sky130_fd_sc_hd__mux2_1
X_3623_ _3624_/A _3624_/B VGND VGND VPWR VPWR _3625_/A sky130_fd_sc_hd__nor2_2
XTAP_TAPCELL_ROW_99_1255 VGND VPWR sky130_fd_sc_hd__tapvpwrvgnd_1
X_6342_ _6342_/A _6384_/D VGND VGND VPWR VPWR _6368_/B sky130_fd_sc_hd__or2_2
X_3554_ _3555_/A _3555_/B _3555_/C VGND VGND VPWR VPWR _4048_/A sky130_fd_sc_hd__and3_2
X_6273_ _6890_/A _6273_/B VGND VGND VPWR VPWR _6273_/Y sky130_fd_sc_hd__nand2_2
X_3485_ _6175_/A VGND VGND VPWR VPWR _3485_/Y sky130_fd_sc_hd__inv_2
XFILLER_69_520 VGND VGND VPWR VPWR sky130_fd_sc_hd__decap_3
X_5224_ _5395_/A _5399_/B VGND VGND VPWR VPWR _5270_/A sky130_fd_sc_hd__nand2_2
XFILLER_69_597 VGND VGND VPWR VPWR sky130_fd_sc_hd__fill_1
XFILLER_84_512 VGND VGND VPWR VPWR sky130_fd_sc_hd__decap_3
X_5155_ _5374_/A _6501_/S _5154_/B _5151_/X VGND VGND VPWR VPWR _5159_/A sky130_fd_sc_hd__a31oi_2
X_5086_ _5165_/A1 _5082_/Y _5084_/X _5085_/Y VGND VGND VPWR VPWR _5086_/Y sky130_fd_sc_hd__a211oi_2
X_4106_ _4106_/A _4106_/B _4106_/C VGND VGND VPWR VPWR _4109_/B sky130_fd_sc_hd__nand3_2
XFILLER_84_567 VGND VGND VPWR VPWR sky130_fd_sc_hd__fill_1
X_4037_ _4035_/A _4035_/B _4042_/A VGND VGND VPWR VPWR _4039_/B sky130_fd_sc_hd__a21bo_2
XFILLER_64_280 VGND VGND VPWR VPWR sky130_fd_sc_hd__decap_3
XFILLER_71_228 VGND VGND VPWR VPWR sky130_fd_sc_hd__decap_3
XFILLER_24_144 VGND VGND VPWR VPWR sky130_fd_sc_hd__decap_3
XFILLER_52_453 VGND VGND VPWR VPWR sky130_fd_sc_hd__decap_3
XFILLER_72_29 VGND VGND VPWR VPWR sky130_fd_sc_hd__decap_3
XFILLER_24_166 VGND VGND VPWR VPWR sky130_fd_sc_hd__fill_1
X_5988_ _5988_/A _5988_/B VGND VGND VPWR VPWR _5989_/B sky130_fd_sc_hd__xnor2_2
X_4939_ _4710_/Y _4923_/X _4933_/Y _5016_/A VGND VGND VPWR VPWR _4940_/C sky130_fd_sc_hd__o211ai_2
X_6609_ _6357_/X _6360_/X _6403_/X _6406_/X wire299/X _5585_/B VGND VGND VPWR VPWR
+ _6609_/X sky130_fd_sc_hd__mux4_2
XFILLER_21_44 VGND VGND VPWR VPWR sky130_fd_sc_hd__decap_3
XFILLER_79_317 VGND VGND VPWR VPWR sky130_fd_sc_hd__decap_3
XFILLER_94_309 VGND VGND VPWR VPWR sky130_fd_sc_hd__decap_3
XFILLER_75_534 VGND VGND VPWR VPWR sky130_fd_sc_hd__decap_3
XFILLER_62_206 VGND VGND VPWR VPWR sky130_fd_sc_hd__decap_3
XFILLER_75_556 VGND VGND VPWR VPWR sky130_fd_sc_hd__decap_3
XFILLER_75_567 VGND VGND VPWR VPWR sky130_fd_sc_hd__decap_3
XFILLER_28_472 VGND VGND VPWR VPWR sky130_fd_sc_hd__decap_3
XFILLER_46_85 VGND VGND VPWR VPWR sky130_fd_sc_hd__decap_3
XFILLER_62_239 VGND VGND VPWR VPWR sky130_fd_sc_hd__decap_3
XFILLER_90_526 VGND VGND VPWR VPWR sky130_fd_sc_hd__decap_3
XFILLER_15_111 VGND VGND VPWR VPWR sky130_fd_sc_hd__fill_1
XFILLER_43_420 VGND VGND VPWR VPWR sky130_fd_sc_hd__decap_3
XFILLER_55_291 VGND VGND VPWR VPWR sky130_fd_sc_hd__decap_3
XFILLER_15_155 VGND VGND VPWR VPWR sky130_fd_sc_hd__decap_3
XFILLER_70_283 VGND VGND VPWR VPWR sky130_fd_sc_hd__decap_3
XTAP_TAPCELL_ROW_83_1089 VGND VPWR sky130_fd_sc_hd__tapvpwrvgnd_1
XFILLER_30_169 VGND VGND VPWR VPWR sky130_fd_sc_hd__decap_3
XFILLER_87_9 VGND VGND VPWR VPWR sky130_fd_sc_hd__fill_2
XTAP_TAPCELL_ROW_41_643 VGND VPWR sky130_fd_sc_hd__tapvpwrvgnd_1
XTAP_TAPCELL_ROW_13_356 VGND VPWR sky130_fd_sc_hd__tapvpwrvgnd_1
XFILLER_11_383 VGND VGND VPWR VPWR sky130_fd_sc_hd__decap_3
XFILLER_7_57 VGND VGND VPWR VPWR sky130_fd_sc_hd__decap_3
XFILLER_3_593 VGND VGND VPWR VPWR sky130_fd_sc_hd__decap_3
Xload_slew224 _3944_/B VGND VGND VPWR VPWR _6014_/C sky130_fd_sc_hd__clkbuf_4
XFILLER_66_512 VGND VGND VPWR VPWR sky130_fd_sc_hd__decap_3
XFILLER_78_394 VGND VGND VPWR VPWR sky130_fd_sc_hd__decap_3
XTAP_TAPCELL_ROW_49_732 VGND VPWR sky130_fd_sc_hd__tapvpwrvgnd_1
XFILLER_38_269 VGND VGND VPWR VPWR sky130_fd_sc_hd__fill_1
XFILLER_66_556 VGND VGND VPWR VPWR sky130_fd_sc_hd__decap_3
XFILLER_93_364 VGND VGND VPWR VPWR sky130_fd_sc_hd__decap_3
X_6960_ _6960_/A _6960_/B VGND VGND VPWR VPWR _6960_/Y sky130_fd_sc_hd__nand2_2
XFILLER_53_228 VGND VGND VPWR VPWR sky130_fd_sc_hd__decap_3
X_5911_ _5916_/A _5911_/B VGND VGND VPWR VPWR _5911_/X sky130_fd_sc_hd__and2b_2
XFILLER_81_559 VGND VGND VPWR VPWR sky130_fd_sc_hd__fill_1
X_6891_ _6904_/B _6963_/A2 _6891_/B1 _6186_/Y VGND VGND VPWR VPWR _6891_/X sky130_fd_sc_hd__o22a_2
XFILLER_34_453 VGND VGND VPWR VPWR sky130_fd_sc_hd__decap_3
XFILLER_34_475 VGND VGND VPWR VPWR sky130_fd_sc_hd__fill_1
XFILLER_34_486 VGND VGND VPWR VPWR sky130_fd_sc_hd__decap_3
X_5842_ _5257_/B _5822_/X _5837_/Y _5840_/X VGND VGND VPWR VPWR _5856_/B sky130_fd_sc_hd__o211a_4
X_5773_ _5773_/A _5773_/B VGND VGND VPWR VPWR _5786_/A sky130_fd_sc_hd__xor2_2
X_4724_ _4722_/X _4724_/B VGND VGND VPWR VPWR _4935_/A sky130_fd_sc_hd__nand2b_2
X_4655_ _5014_/A _4655_/B VGND VGND VPWR VPWR _4691_/B sky130_fd_sc_hd__xnor2_2
Xinput60 B[5] VGND VGND VPWR VPWR input60/X sky130_fd_sc_hd__buf_2
X_4586_ _4586_/A _4586_/B VGND VGND VPWR VPWR _4823_/B sky130_fd_sc_hd__xnor2_2
X_3606_ _4387_/B _4662_/B _4482_/C _4482_/D VGND VGND VPWR VPWR _3609_/A sky130_fd_sc_hd__nand4_2
X_6325_ _6321_/X _6324_/X _6924_/S VGND VGND VPWR VPWR _6325_/X sky130_fd_sc_hd__mux2_1
X_3537_ _3537_/A _3537_/B VGND VGND VPWR VPWR _3538_/B sky130_fd_sc_hd__nor2_2
XFILLER_88_147 VGND VGND VPWR VPWR sky130_fd_sc_hd__decap_3
X_6256_ _6787_/B _6787_/C _6787_/A VGND VGND VPWR VPWR _6793_/C sky130_fd_sc_hd__a21oi_2
XFILLER_29_203 VGND VGND VPWR VPWR sky130_fd_sc_hd__decap_3
XFILLER_76_309 VGND VGND VPWR VPWR sky130_fd_sc_hd__decap_3
X_6187_ _6187_/A _6187_/B VGND VGND VPWR VPWR _6904_/B sky130_fd_sc_hd__nor2_2
X_5207_ _5213_/A _5213_/B VGND VGND VPWR VPWR _5207_/X sky130_fd_sc_hd__and2b_2
XFILLER_29_225 VGND VGND VPWR VPWR sky130_fd_sc_hd__decap_3
XFILLER_69_383 VGND VGND VPWR VPWR sky130_fd_sc_hd__decap_3
XFILLER_84_331 VGND VGND VPWR VPWR sky130_fd_sc_hd__decap_3
X_5138_ _5313_/A _5311_/C _5311_/D _5138_/B2 VGND VGND VPWR VPWR _5139_/C sky130_fd_sc_hd__a22o_2
XFILLER_96_180 VGND VGND VPWR VPWR sky130_fd_sc_hd__fill_2
XFILLER_44_217 VGND VGND VPWR VPWR sky130_fd_sc_hd__fill_1
XFILLER_84_386 VGND VGND VPWR VPWR sky130_fd_sc_hd__fill_2
X_5069_ _5151_/B _5151_/C _5266_/D _5152_/A VGND VGND VPWR VPWR _5070_/B sky130_fd_sc_hd__a22o_2
XFILLER_25_420 VGND VGND VPWR VPWR sky130_fd_sc_hd__fill_1
XFILLER_72_559 VGND VGND VPWR VPWR sky130_fd_sc_hd__decap_3
XFILLER_16_55 VGND VGND VPWR VPWR sky130_fd_sc_hd__decap_3
XFILLER_80_592 VGND VGND VPWR VPWR sky130_fd_sc_hd__decap_3
XFILLER_12_147 VGND VGND VPWR VPWR sky130_fd_sc_hd__decap_3
XFILLER_32_21 VGND VGND VPWR VPWR sky130_fd_sc_hd__fill_2
XFILLER_40_456 VGND VGND VPWR VPWR sky130_fd_sc_hd__fill_1
XFILLER_8_118 VGND VGND VPWR VPWR sky130_fd_sc_hd__decap_3
XFILLER_32_65 VGND VGND VPWR VPWR sky130_fd_sc_hd__fill_1
XFILLER_40_489 VGND VGND VPWR VPWR sky130_fd_sc_hd__decap_3
XTAP_TAPCELL_ROW_10_326 VGND VPWR sky130_fd_sc_hd__tapvpwrvgnd_1
XFILLER_0_530 VGND VGND VPWR VPWR sky130_fd_sc_hd__fill_2
XFILLER_79_136 VGND VGND VPWR VPWR sky130_fd_sc_hd__decap_3
XFILLER_48_501 VGND VGND VPWR VPWR sky130_fd_sc_hd__decap_3
XFILLER_79_169 VGND VGND VPWR VPWR sky130_fd_sc_hd__decap_3
XFILLER_0_585 VGND VGND VPWR VPWR sky130_fd_sc_hd__decap_3
XFILLER_57_84 VGND VGND VPWR VPWR sky130_fd_sc_hd__decap_3
XFILLER_35_206 VGND VGND VPWR VPWR sky130_fd_sc_hd__decap_3
XFILLER_48_589 VGND VGND VPWR VPWR sky130_fd_sc_hd__decap_3
XFILLER_90_301 VGND VGND VPWR VPWR sky130_fd_sc_hd__decap_3
XTAP_TAPCELL_ROW_85_1107 VGND VPWR sky130_fd_sc_hd__tapvpwrvgnd_1
XTAP_TAPCELL_ROW_46_702 VGND VPWR sky130_fd_sc_hd__tapvpwrvgnd_1
XTAP_TAPCELL_ROW_18_404 VGND VPWR sky130_fd_sc_hd__tapvpwrvgnd_1
XFILLER_16_442 VGND VGND VPWR VPWR sky130_fd_sc_hd__fill_1
XFILLER_90_334 VGND VGND VPWR VPWR sky130_fd_sc_hd__decap_3
XFILLER_90_356 VGND VGND VPWR VPWR sky130_fd_sc_hd__decap_3
XFILLER_43_250 VGND VGND VPWR VPWR sky130_fd_sc_hd__fill_2
XFILLER_50_209 VGND VGND VPWR VPWR sky130_fd_sc_hd__decap_3
XFILLER_73_72 VGND VGND VPWR VPWR sky130_fd_sc_hd__decap_3
XFILLER_16_486 VGND VGND VPWR VPWR sky130_fd_sc_hd__decap_3
XFILLER_31_423 VGND VGND VPWR VPWR sky130_fd_sc_hd__fill_2
XFILLER_92_7 VGND VGND VPWR VPWR sky130_fd_sc_hd__decap_3
XTAP_TAPCELL_ROW_26_492 VGND VPWR sky130_fd_sc_hd__tapvpwrvgnd_1
XTAP_TAPCELL_ROW_96_1225 VGND VPWR sky130_fd_sc_hd__tapvpwrvgnd_1
X_4440_ _4440_/A _4440_/B VGND VGND VPWR VPWR _4441_/C sky130_fd_sc_hd__nor2_2
X_6110_ _6110_/A _6110_/B VGND VGND VPWR VPWR _6111_/B sky130_fd_sc_hd__or2_2
X_4371_ _4370_/A _4370_/B _4370_/C VGND VGND VPWR VPWR _4373_/A sky130_fd_sc_hd__a21oi_2
Xfanout609 input19/X VGND VGND VPWR VPWR _4290_/A sky130_fd_sc_hd__clkdlybuf4s25_1
XPHY_EDGE_ROW_13_Left_114 VGND VGND VPWR VPWR sky130_fd_sc_hd__decap_3
XFILLER_98_456 VGND VGND VPWR VPWR sky130_fd_sc_hd__decap_3
XFILLER_58_309 VGND VGND VPWR VPWR sky130_fd_sc_hd__decap_3
X_6041_ _4040_/A _4040_/B _4038_/Y VGND VGND VPWR VPWR _6049_/A sky130_fd_sc_hd__a21bo_2
XFILLER_98_467 VGND VGND VPWR VPWR sky130_fd_sc_hd__decap_3
XFILLER_85_128 VGND VGND VPWR VPWR sky130_fd_sc_hd__decap_3
XFILLER_39_545 VGND VGND VPWR VPWR sky130_fd_sc_hd__decap_3
XFILLER_66_342 VGND VGND VPWR VPWR sky130_fd_sc_hd__decap_3
XFILLER_66_386 VGND VGND VPWR VPWR sky130_fd_sc_hd__decap_3
XFILLER_81_323 VGND VGND VPWR VPWR sky130_fd_sc_hd__decap_3
XFILLER_93_150 VGND VGND VPWR VPWR sky130_fd_sc_hd__decap_3
XFILLER_93_172 VGND VGND VPWR VPWR sky130_fd_sc_hd__fill_1
X_6943_ _6371_/Y _6939_/X _6942_/Y _6898_/B VGND VGND VPWR VPWR _6946_/A sky130_fd_sc_hd__a211o_2
XFILLER_34_250 VGND VGND VPWR VPWR sky130_fd_sc_hd__fill_2
X_6874_ _6874_/A _6874_/B _6874_/C VGND VGND VPWR VPWR _6874_/X sky130_fd_sc_hd__and3_2
XFILLER_62_592 VGND VGND VPWR VPWR sky130_fd_sc_hd__decap_3
X_5825_ _5237_/A _5237_/B _5237_/C VGND VGND VPWR VPWR _5826_/C sky130_fd_sc_hd__a21oi_2
XPHY_EDGE_ROW_22_Left_123 VGND VGND VPWR VPWR sky130_fd_sc_hd__decap_3
XFILLER_22_445 VGND VGND VPWR VPWR sky130_fd_sc_hd__decap_3
X_5756_ _6217_/B _5791_/B _5735_/B _5733_/B VGND VGND VPWR VPWR _5760_/A sky130_fd_sc_hd__a31o_2
X_5687_ _5649_/Y _5653_/X _5683_/Y _5686_/Y VGND VGND VPWR VPWR _6650_/A sky130_fd_sc_hd__o211a_2
X_4707_ _6141_/A _4705_/Y _4706_/X VGND VGND VPWR VPWR _4708_/B sky130_fd_sc_hd__o21a_2
X_4638_ _4638_/A _4638_/B VGND VGND VPWR VPWR _4657_/B sky130_fd_sc_hd__xnor2_2
XFILLER_1_305 VGND VGND VPWR VPWR sky130_fd_sc_hd__decap_3
XFILLER_78_39 VGND VGND VPWR VPWR sky130_fd_sc_hd__fill_1
X_4569_ _4569_/A _4569_/B VGND VGND VPWR VPWR _4576_/A sky130_fd_sc_hd__xnor2_2
XPHY_EDGE_ROW_31_Left_132 VGND VGND VPWR VPWR sky130_fd_sc_hd__decap_3
XFILLER_89_456 VGND VGND VPWR VPWR sky130_fd_sc_hd__decap_3
X_6308_ _6765_/B _6302_/X _6961_/A1 _6307_/X VGND VGND VPWR VPWR _6308_/X sky130_fd_sc_hd__a22o_2
XFILLER_76_106 VGND VGND VPWR VPWR sky130_fd_sc_hd__decap_3
X_6239_ _6383_/B _6635_/B _6238_/Y VGND VGND VPWR VPWR _6652_/A sky130_fd_sc_hd__o21a_2
XFILLER_76_139 VGND VGND VPWR VPWR sky130_fd_sc_hd__fill_1
XFILLER_17_217 VGND VGND VPWR VPWR sky130_fd_sc_hd__decap_3
XFILLER_17_228 VGND VGND VPWR VPWR sky130_fd_sc_hd__fill_1
XFILLER_27_32 VGND VGND VPWR VPWR sky130_fd_sc_hd__decap_3
XFILLER_45_526 VGND VGND VPWR VPWR sky130_fd_sc_hd__decap_3
XFILLER_72_312 VGND VGND VPWR VPWR sky130_fd_sc_hd__decap_3
XFILLER_84_150 VGND VGND VPWR VPWR sky130_fd_sc_hd__decap_3
XFILLER_84_194 VGND VGND VPWR VPWR sky130_fd_sc_hd__fill_2
XFILLER_60_529 VGND VGND VPWR VPWR sky130_fd_sc_hd__decap_3
XFILLER_72_378 VGND VGND VPWR VPWR sky130_fd_sc_hd__decap_3
XPHY_EDGE_ROW_40_Left_141 VGND VGND VPWR VPWR sky130_fd_sc_hd__decap_3
XFILLER_13_467 VGND VGND VPWR VPWR sky130_fd_sc_hd__fill_1
XFILLER_40_231 VGND VGND VPWR VPWR sky130_fd_sc_hd__decap_3
XFILLER_40_253 VGND VGND VPWR VPWR sky130_fd_sc_hd__decap_3
XTAP_TAPCELL_ROW_80_1059 VGND VPWR sky130_fd_sc_hd__tapvpwrvgnd_1
XFILLER_9_416 VGND VGND VPWR VPWR sky130_fd_sc_hd__decap_3
XFILLER_13_489 VGND VGND VPWR VPWR sky130_fd_sc_hd__decap_3
XFILLER_40_286 VGND VGND VPWR VPWR sky130_fd_sc_hd__decap_3
XTAP_TAPCELL_ROW_23_462 VGND VPWR sky130_fd_sc_hd__tapvpwrvgnd_1
XFILLER_9_449 VGND VGND VPWR VPWR sky130_fd_sc_hd__decap_3
Xrebuffer760 _5046_/B VGND VGND VPWR VPWR _5311_/B sky130_fd_sc_hd__buf_2
XFILLER_4_176 VGND VGND VPWR VPWR sky130_fd_sc_hd__fill_2
XFILLER_4_25 VGND VGND VPWR VPWR sky130_fd_sc_hd__decap_3
XFILLER_4_69 VGND VGND VPWR VPWR sky130_fd_sc_hd__decap_3
XTAP_TAPCELL_ROW_91_1177 VGND VPWR sky130_fd_sc_hd__tapvpwrvgnd_1
XFILLER_67_139 VGND VGND VPWR VPWR sky130_fd_sc_hd__decap_3
XFILLER_68_94 VGND VGND VPWR VPWR sky130_fd_sc_hd__decap_3
XFILLER_95_426 VGND VGND VPWR VPWR sky130_fd_sc_hd__decap_3
XFILLER_75_161 VGND VGND VPWR VPWR sky130_fd_sc_hd__decap_3
XFILLER_75_172 VGND VGND VPWR VPWR sky130_fd_sc_hd__decap_3
XFILLER_63_334 VGND VGND VPWR VPWR sky130_fd_sc_hd__fill_2
XFILLER_75_194 VGND VGND VPWR VPWR sky130_fd_sc_hd__decap_3
XFILLER_63_367 VGND VGND VPWR VPWR sky130_fd_sc_hd__decap_3
X_3940_ _3940_/A _3940_/B VGND VGND VPWR VPWR _3946_/A sky130_fd_sc_hd__nor2_2
XFILLER_90_186 VGND VGND VPWR VPWR sky130_fd_sc_hd__fill_1
XFILLER_90_197 VGND VGND VPWR VPWR sky130_fd_sc_hd__decap_3
XFILLER_16_294 VGND VGND VPWR VPWR sky130_fd_sc_hd__decap_3
X_3871_ _3871_/A _3871_/B VGND VGND VPWR VPWR _3873_/A sky130_fd_sc_hd__nor2_2
XFILLER_83_3 VGND VGND VPWR VPWR sky130_fd_sc_hd__fill_1
X_6590_ _6114_/B _6963_/A2 _6605_/A2 _6621_/A2 VGND VGND VPWR VPWR _6590_/X sky130_fd_sc_hd__o22a_2
X_5610_ _5608_/A _5608_/Y _5609_/X _5562_/Y VGND VGND VPWR VPWR _5611_/A sky130_fd_sc_hd__o211ai_2
X_5541_ _5542_/A _5542_/B VGND VGND VPWR VPWR _5541_/Y sky130_fd_sc_hd__nand2b_2
XTAP_TAPCELL_ROW_100_1273 VGND VPWR sky130_fd_sc_hd__tapvpwrvgnd_1
XTAP_TAPCELL_ROW_100_1262 VGND VPWR sky130_fd_sc_hd__tapvpwrvgnd_1
X_5472_ _5345_/A _5345_/B _5345_/C VGND VGND VPWR VPWR _5473_/B sky130_fd_sc_hd__a21oi_2
X_4423_ _4420_/X _4423_/B _4822_/A _4539_/B VGND VGND VPWR VPWR _4544_/A sky130_fd_sc_hd__and4b_2
X_4354_ _4592_/A _4476_/A _4593_/C _4593_/D VGND VGND VPWR VPWR _4354_/X sky130_fd_sc_hd__and4_2
XFILLER_86_404 VGND VGND VPWR VPWR sky130_fd_sc_hd__decap_3
Xfanout417 input37/X VGND VGND VPWR VPWR _4694_/C sky130_fd_sc_hd__buf_6
Xfanout439 _6106_/B VGND VGND VPWR VPWR _5321_/C sky130_fd_sc_hd__clkbuf_4
XFILLER_58_128 VGND VGND VPWR VPWR sky130_fd_sc_hd__decap_3
X_6024_ _6024_/A _6024_/B VGND VGND VPWR VPWR _6027_/A sky130_fd_sc_hd__nand2_2
X_4285_ _4285_/A _4285_/B _4285_/C VGND VGND VPWR VPWR _4397_/A sky130_fd_sc_hd__nand3_2
XFILLER_98_297 VGND VGND VPWR VPWR sky130_fd_sc_hd__decap_3
XFILLER_100_236 VGND VGND VPWR VPWR sky130_fd_sc_hd__decap_3
XFILLER_54_301 VGND VGND VPWR VPWR sky130_fd_sc_hd__decap_3
XFILLER_66_150 VGND VGND VPWR VPWR sky130_fd_sc_hd__decap_3
XTAP_TAPCELL_ROW_57_819 VGND VPWR sky130_fd_sc_hd__tapvpwrvgnd_1
XFILLER_81_131 VGND VGND VPWR VPWR sky130_fd_sc_hd__decap_3
XFILLER_81_142 VGND VGND VPWR VPWR sky130_fd_sc_hd__fill_1
XFILLER_81_164 VGND VGND VPWR VPWR sky130_fd_sc_hd__decap_3
X_6926_ _6657_/X _6925_/Y _6929_/A VGND VGND VPWR VPWR _6926_/X sky130_fd_sc_hd__a21o_2
XFILLER_35_581 VGND VGND VPWR VPWR sky130_fd_sc_hd__fill_1
XFILLER_81_175 VGND VGND VPWR VPWR sky130_fd_sc_hd__decap_3
XTAP_TAPCELL_ROW_65_896 VGND VPWR sky130_fd_sc_hd__tapvpwrvgnd_1
XFILLER_22_220 VGND VGND VPWR VPWR sky130_fd_sc_hd__decap_3
X_6857_ _6857_/A _6857_/B VGND VGND VPWR VPWR _6857_/Y sky130_fd_sc_hd__xnor2_2
XFILLER_10_415 VGND VGND VPWR VPWR sky130_fd_sc_hd__decap_3
XFILLER_22_275 VGND VGND VPWR VPWR sky130_fd_sc_hd__decap_3
X_6788_ _6793_/C _6853_/A _6788_/C VGND VGND VPWR VPWR _6788_/X sky130_fd_sc_hd__or3_2
X_5808_ _6562_/A _6562_/B _5771_/X VGND VGND VPWR VPWR _5810_/A sky130_fd_sc_hd__a21o_2
XFILLER_13_34 VGND VGND VPWR VPWR sky130_fd_sc_hd__fill_1
X_5739_ _5739_/A _5750_/A _5757_/A _5739_/D VGND VGND VPWR VPWR _5740_/C sky130_fd_sc_hd__and4_2
XTAP_TAPCELL_ROW_20_432 VGND VPWR sky130_fd_sc_hd__tapvpwrvgnd_1
XFILLER_89_231 VGND VGND VPWR VPWR sky130_fd_sc_hd__decap_3
XFILLER_89_264 VGND VGND VPWR VPWR sky130_fd_sc_hd__fill_1
XFILLER_49_106 VGND VGND VPWR VPWR sky130_fd_sc_hd__decap_3
XFILLER_49_139 VGND VGND VPWR VPWR sky130_fd_sc_hd__decap_3
XFILLER_18_515 VGND VGND VPWR VPWR sky130_fd_sc_hd__decap_3
XFILLER_57_150 VGND VGND VPWR VPWR sky130_fd_sc_hd__decap_3
XFILLER_85_470 VGND VGND VPWR VPWR sky130_fd_sc_hd__fill_1
XFILLER_92_418 VGND VGND VPWR VPWR sky130_fd_sc_hd__fill_2
XFILLER_45_323 VGND VGND VPWR VPWR sky130_fd_sc_hd__decap_3
XFILLER_57_172 VGND VGND VPWR VPWR sky130_fd_sc_hd__decap_3
XFILLER_85_492 VGND VGND VPWR VPWR sky130_fd_sc_hd__decap_3
XTAP_TAPCELL_ROW_28_510 VGND VPWR sky130_fd_sc_hd__tapvpwrvgnd_1
XFILLER_54_41 VGND VGND VPWR VPWR sky130_fd_sc_hd__decap_3
XFILLER_54_74 VGND VGND VPWR VPWR sky130_fd_sc_hd__fill_1
XFILLER_60_315 VGND VGND VPWR VPWR sky130_fd_sc_hd__decap_3
XFILLER_72_186 VGND VGND VPWR VPWR sky130_fd_sc_hd__decap_3
XFILLER_72_197 VGND VGND VPWR VPWR sky130_fd_sc_hd__decap_3
XFILLER_13_220 VGND VGND VPWR VPWR sky130_fd_sc_hd__decap_3
XFILLER_54_85 VGND VGND VPWR VPWR sky130_fd_sc_hd__decap_3
XFILLER_9_268 VGND VGND VPWR VPWR sky130_fd_sc_hd__decap_3
XFILLER_9_246 VGND VGND VPWR VPWR sky130_fd_sc_hd__decap_3
XFILLER_79_71 VGND VGND VPWR VPWR sky130_fd_sc_hd__decap_3
XFILLER_68_415 VGND VGND VPWR VPWR sky130_fd_sc_hd__fill_1
XFILLER_68_437 VGND VGND VPWR VPWR sky130_fd_sc_hd__decap_3
X_4070_ _4070_/A _4070_/B _4070_/C VGND VGND VPWR VPWR _4111_/A sky130_fd_sc_hd__nand3_2
XFILLER_95_234 VGND VGND VPWR VPWR sky130_fd_sc_hd__decap_3
XFILLER_83_418 VGND VGND VPWR VPWR sky130_fd_sc_hd__decap_3
XFILLER_95_81 VGND VGND VPWR VPWR sky130_fd_sc_hd__decap_3
XFILLER_95_278 VGND VGND VPWR VPWR sky130_fd_sc_hd__fill_2
XFILLER_36_334 VGND VGND VPWR VPWR sky130_fd_sc_hd__decap_3
XFILLER_63_131 VGND VGND VPWR VPWR sky130_fd_sc_hd__decap_3
XFILLER_51_337 VGND VGND VPWR VPWR sky130_fd_sc_hd__decap_3
XFILLER_63_197 VGND VGND VPWR VPWR sky130_fd_sc_hd__decap_3
X_4972_ _4970_/A _5045_/A _4971_/Y _4956_/X VGND VGND VPWR VPWR _4972_/Y sky130_fd_sc_hd__a211oi_4
XFILLER_51_348 VGND VGND VPWR VPWR sky130_fd_sc_hd__decap_3
X_6711_ _5976_/D input5/X _6711_/A2 _3585_/A _6405_/S _6876_/S1 VGND VGND VPWR VPWR
+ _6711_/X sky130_fd_sc_hd__mux4_2
X_3923_ _3923_/A _3923_/B VGND VGND VPWR VPWR _6026_/A sky130_fd_sc_hd__nand2_2
XTAP_TAPCELL_ROW_62_866 VGND VPWR sky130_fd_sc_hd__tapvpwrvgnd_1
X_6642_ _6461_/X _6625_/Y _6657_/B VGND VGND VPWR VPWR _6642_/X sky130_fd_sc_hd__a21bo_2
X_3854_ _6187_/B _5947_/A VGND VGND VPWR VPWR _3855_/B sky130_fd_sc_hd__nand2_2
XTAP_TAPCELL_ROW_34_579 VGND VPWR sky130_fd_sc_hd__tapvpwrvgnd_1
XFILLER_32_595 VGND VGND VPWR VPWR sky130_fd_sc_hd__decap_3
X_6573_ _6232_/B _6605_/A2 _6506_/B _6381_/B _6572_/X VGND VGND VPWR VPWR _6573_/Y
+ sky130_fd_sc_hd__o221ai_2
X_3785_ _5993_/B _6077_/A VGND VGND VPWR VPWR _3789_/A sky130_fd_sc_hd__nand2_2
X_5524_ _5524_/A _5524_/B VGND VGND VPWR VPWR _5558_/A sky130_fd_sc_hd__or2_2
X_5455_ _5455_/A _5455_/B _5455_/C VGND VGND VPWR VPWR _5456_/B sky130_fd_sc_hd__or3_2
X_4406_ _4524_/B _4406_/B _4406_/C _4406_/D VGND VGND VPWR VPWR _4409_/A sky130_fd_sc_hd__and4_2
Xfanout214 _6016_/C VGND VGND VPWR VPWR _3834_/D sky130_fd_sc_hd__clkdlybuf4s25_1
X_5386_ _5383_/A _4757_/B _5481_/B _5385_/A VGND VGND VPWR VPWR _5483_/A sky130_fd_sc_hd__a31o_2
XFILLER_59_437 VGND VGND VPWR VPWR sky130_fd_sc_hd__fill_1
XFILLER_86_212 VGND VGND VPWR VPWR sky130_fd_sc_hd__decap_3
Xfanout225 _5328_/C VGND VGND VPWR VPWR _5311_/C sky130_fd_sc_hd__buf_8
Xfanout236 _5576_/C VGND VGND VPWR VPWR _4755_/D sky130_fd_sc_hd__buf_8
X_4337_ _4334_/X _4337_/B VGND VGND VPWR VPWR _4458_/B sky130_fd_sc_hd__and2b_2
XFILLER_99_584 VGND VGND VPWR VPWR sky130_fd_sc_hd__decap_3
XFILLER_86_234 VGND VGND VPWR VPWR sky130_fd_sc_hd__decap_3
Xfanout269 _3870_/A2 VGND VGND VPWR VPWR _6363_/A sky130_fd_sc_hd__clkbuf_2
X_4268_ _4268_/A _4268_/B VGND VGND VPWR VPWR _4372_/A sky130_fd_sc_hd__xnor2_2
XFILLER_46_109 VGND VGND VPWR VPWR sky130_fd_sc_hd__decap_3
XFILLER_67_470 VGND VGND VPWR VPWR sky130_fd_sc_hd__decap_3
XFILLER_86_289 VGND VGND VPWR VPWR sky130_fd_sc_hd__decap_3
X_6007_ _6007_/A _6007_/B VGND VGND VPWR VPWR _6009_/A sky130_fd_sc_hd__xor2_2
XFILLER_27_312 VGND VGND VPWR VPWR sky130_fd_sc_hd__fill_2
XFILLER_39_172 VGND VGND VPWR VPWR sky130_fd_sc_hd__decap_3
XFILLER_39_183 VGND VGND VPWR VPWR sky130_fd_sc_hd__decap_3
XFILLER_54_120 VGND VGND VPWR VPWR sky130_fd_sc_hd__decap_3
X_4199_ _4080_/B _4084_/X _4197_/A _4197_/Y VGND VGND VPWR VPWR _4199_/Y sky130_fd_sc_hd__a211oi_2
XFILLER_82_462 VGND VGND VPWR VPWR sky130_fd_sc_hd__decap_3
XFILLER_27_389 VGND VGND VPWR VPWR sky130_fd_sc_hd__decap_3
XFILLER_54_175 VGND VGND VPWR VPWR sky130_fd_sc_hd__decap_3
XFILLER_54_197 VGND VGND VPWR VPWR sky130_fd_sc_hd__decap_3
XFILLER_91_28 VGND VGND VPWR VPWR sky130_fd_sc_hd__decap_3
XFILLER_42_359 VGND VGND VPWR VPWR sky130_fd_sc_hd__decap_3
X_6909_ _6275_/B input18/X _6182_/B input16/X _3867_/B _6456_/S VGND VGND VPWR VPWR
+ _6909_/X sky130_fd_sc_hd__mux4_2
XFILLER_23_595 VGND VGND VPWR VPWR sky130_fd_sc_hd__decap_3
XFILLER_24_77 VGND VGND VPWR VPWR sky130_fd_sc_hd__decap_3
XFILLER_24_99 VGND VGND VPWR VPWR sky130_fd_sc_hd__decap_3
XFILLER_10_256 VGND VGND VPWR VPWR sky130_fd_sc_hd__fill_2
XFILLER_10_278 VGND VGND VPWR VPWR sky130_fd_sc_hd__decap_3
Xwire659 wire659/A VGND VGND VPWR VPWR _6093_/B sky130_fd_sc_hd__clkbuf_4
XTAP_TAPCELL_ROW_79_1050 VGND VPWR sky130_fd_sc_hd__tapvpwrvgnd_1
XFILLER_40_65 VGND VGND VPWR VPWR sky130_fd_sc_hd__decap_3
XFILLER_49_41 VGND VGND VPWR VPWR sky130_fd_sc_hd__decap_3
XFILLER_77_212 VGND VGND VPWR VPWR sky130_fd_sc_hd__decap_3
XFILLER_77_245 VGND VGND VPWR VPWR sky130_fd_sc_hd__decap_3
XFILLER_1_26 VGND VGND VPWR VPWR sky130_fd_sc_hd__decap_3
XFILLER_77_278 VGND VGND VPWR VPWR sky130_fd_sc_hd__fill_2
XTAP_TAPCELL_ROW_5_271 VGND VPWR sky130_fd_sc_hd__tapvpwrvgnd_1
XFILLER_92_226 VGND VGND VPWR VPWR sky130_fd_sc_hd__decap_3
XFILLER_45_131 VGND VGND VPWR VPWR sky130_fd_sc_hd__decap_3
XFILLER_92_259 VGND VGND VPWR VPWR sky130_fd_sc_hd__decap_3
XFILLER_18_389 VGND VGND VPWR VPWR sky130_fd_sc_hd__decap_3
XFILLER_33_315 VGND VGND VPWR VPWR sky130_fd_sc_hd__decap_3
XFILLER_33_337 VGND VGND VPWR VPWR sky130_fd_sc_hd__decap_3
XFILLER_45_175 VGND VGND VPWR VPWR sky130_fd_sc_hd__decap_3
XFILLER_60_112 VGND VGND VPWR VPWR sky130_fd_sc_hd__decap_3
XFILLER_73_473 VGND VGND VPWR VPWR sky130_fd_sc_hd__decap_3
XFILLER_45_197 VGND VGND VPWR VPWR sky130_fd_sc_hd__decap_3
XFILLER_14_551 VGND VGND VPWR VPWR sky130_fd_sc_hd__decap_3
XFILLER_60_167 VGND VGND VPWR VPWR sky130_fd_sc_hd__decap_3
XTAP_TAPCELL_ROW_31_538 VGND VPWR sky130_fd_sc_hd__tapvpwrvgnd_1
X_3570_ _4634_/A _4634_/B _6264_/A _6083_/A VGND VGND VPWR VPWR _3570_/X sky130_fd_sc_hd__and4_2
X_5240_ _5240_/A _5240_/B _5240_/C VGND VGND VPWR VPWR _5443_/A sky130_fd_sc_hd__nand3_2
XFILLER_46_3 VGND VGND VPWR VPWR sky130_fd_sc_hd__decap_3
XFILLER_68_212 VGND VGND VPWR VPWR sky130_fd_sc_hd__decap_3
X_5171_ _5089_/A _5089_/B _5086_/Y _5089_/D VGND VGND VPWR VPWR _5171_/Y sky130_fd_sc_hd__o22ai_2
XPHY_EDGE_ROW_18_Right_18 VGND VGND VPWR VPWR sky130_fd_sc_hd__decap_3
XFILLER_68_234 VGND VGND VPWR VPWR sky130_fd_sc_hd__decap_3
X_4122_ _4122_/A _4122_/B _4122_/C VGND VGND VPWR VPWR _4129_/A sky130_fd_sc_hd__nand3_2
XFILLER_96_554 VGND VGND VPWR VPWR sky130_fd_sc_hd__fill_1
XFILLER_68_267 VGND VGND VPWR VPWR sky130_fd_sc_hd__decap_3
XFILLER_83_215 VGND VGND VPWR VPWR sky130_fd_sc_hd__decap_3
X_4053_ _4057_/A VGND VGND VPWR VPWR _4056_/B sky130_fd_sc_hd__inv_2
XTAP_TAPCELL_ROW_67_925 VGND VPWR sky130_fd_sc_hd__tapvpwrvgnd_1
XFILLER_83_237 VGND VGND VPWR VPWR sky130_fd_sc_hd__decap_3
Xinput3 A[11] VGND VGND VPWR VPWR input3/X sky130_fd_sc_hd__buf_4
XTAP_TAPCELL_ROW_39_627 VGND VPWR sky130_fd_sc_hd__tapvpwrvgnd_1
XFILLER_24_315 VGND VGND VPWR VPWR sky130_fd_sc_hd__decap_3
XFILLER_36_175 VGND VGND VPWR VPWR sky130_fd_sc_hd__decap_3
XFILLER_91_281 VGND VGND VPWR VPWR sky130_fd_sc_hd__decap_3
XFILLER_36_197 VGND VGND VPWR VPWR sky130_fd_sc_hd__fill_1
X_4955_ _4760_/A _4760_/C _4760_/B VGND VGND VPWR VPWR _4956_/B sky130_fd_sc_hd__a21o_2
XPHY_EDGE_ROW_27_Right_27 VGND VGND VPWR VPWR sky130_fd_sc_hd__decap_3
XFILLER_51_189 VGND VGND VPWR VPWR sky130_fd_sc_hd__decap_3
X_3906_ _3907_/B _3907_/A VGND VGND VPWR VPWR _3906_/X sky130_fd_sc_hd__and2b_2
X_4886_ _4842_/Y _4848_/B _4882_/X _4884_/Y VGND VGND VPWR VPWR _4889_/B sky130_fd_sc_hd__a211o_2
X_6625_ _6625_/A _6625_/B VGND VGND VPWR VPWR _6625_/Y sky130_fd_sc_hd__nor2_2
X_3837_ _3941_/C _6014_/C VGND VGND VPWR VPWR _3838_/B sky130_fd_sc_hd__nand2_2
X_6556_ _6680_/A _6698_/B VGND VGND VPWR VPWR _6556_/Y sky130_fd_sc_hd__nand2_2
X_3768_ _3498_/Y _6317_/S _3525_/A _3523_/Y VGND VGND VPWR VPWR _3769_/B sky130_fd_sc_hd__o22a_2
X_5507_ _5513_/A _5508_/B _5473_/Y VGND VGND VPWR VPWR _5560_/A sky130_fd_sc_hd__nor3b_2
X_6487_ _6506_/A _6129_/B _6778_/B1 VGND VGND VPWR VPWR _6487_/Y sky130_fd_sc_hd__a21oi_2
X_3699_ _3699_/A _3699_/B VGND VGND VPWR VPWR _3701_/B sky130_fd_sc_hd__xnor2_2
XPHY_EDGE_ROW_5_Left_106 VGND VGND VPWR VPWR sky130_fd_sc_hd__decap_3
X_5438_ _5437_/B _5437_/C _5437_/A VGND VGND VPWR VPWR _5439_/C sky130_fd_sc_hd__a21o_2
XPHY_EDGE_ROW_36_Right_36 VGND VGND VPWR VPWR sky130_fd_sc_hd__decap_3
X_5369_ _5367_/A _5367_/C _5367_/B VGND VGND VPWR VPWR _5370_/C sky130_fd_sc_hd__o21ai_2
XFILLER_59_223 VGND VGND VPWR VPWR sky130_fd_sc_hd__fill_1
XFILLER_59_234 VGND VGND VPWR VPWR sky130_fd_sc_hd__decap_3
XFILLER_87_543 VGND VGND VPWR VPWR sky130_fd_sc_hd__decap_3
XFILLER_19_88 VGND VGND VPWR VPWR sky130_fd_sc_hd__fill_1
XFILLER_74_237 VGND VGND VPWR VPWR sky130_fd_sc_hd__decap_3
XTAP_TAPCELL_ROW_2_241 VGND VPWR sky130_fd_sc_hd__tapvpwrvgnd_1
XFILLER_15_315 VGND VGND VPWR VPWR sky130_fd_sc_hd__decap_3
XFILLER_27_175 VGND VGND VPWR VPWR sky130_fd_sc_hd__decap_3
XFILLER_70_421 VGND VGND VPWR VPWR sky130_fd_sc_hd__decap_3
XFILLER_82_281 VGND VGND VPWR VPWR sky130_fd_sc_hd__decap_3
XPHY_EDGE_ROW_45_Right_45 VGND VGND VPWR VPWR sky130_fd_sc_hd__decap_3
XFILLER_15_337 VGND VGND VPWR VPWR sky130_fd_sc_hd__fill_2
XFILLER_27_197 VGND VGND VPWR VPWR sky130_fd_sc_hd__fill_2
XFILLER_35_65 VGND VGND VPWR VPWR sky130_fd_sc_hd__decap_3
XFILLER_30_307 VGND VGND VPWR VPWR sky130_fd_sc_hd__fill_1
XFILLER_30_318 VGND VGND VPWR VPWR sky130_fd_sc_hd__decap_3
XFILLER_11_532 VGND VGND VPWR VPWR sky130_fd_sc_hd__decap_3
XFILLER_23_381 VGND VGND VPWR VPWR sky130_fd_sc_hd__decap_3
XPHY_EDGE_ROW_54_Right_54 VGND VGND VPWR VPWR sky130_fd_sc_hd__decap_3
XFILLER_32_9 VGND VGND VPWR VPWR sky130_fd_sc_hd__decap_3
Xload_slew428 _4607_/D VGND VGND VPWR VPWR _4387_/D sky130_fd_sc_hd__buf_4
Xload_slew406 _6211_/B VGND VGND VPWR VPWR _3814_/D sky130_fd_sc_hd__buf_4
XFILLER_78_576 VGND VGND VPWR VPWR sky130_fd_sc_hd__fill_2
XTAP_TAPCELL_ROW_88_1138 VGND VPWR sky130_fd_sc_hd__tapvpwrvgnd_1
XFILLER_93_535 VGND VGND VPWR VPWR sky130_fd_sc_hd__decap_3
XFILLER_18_120 VGND VGND VPWR VPWR sky130_fd_sc_hd__decap_3
XFILLER_46_451 VGND VGND VPWR VPWR sky130_fd_sc_hd__decap_3
XFILLER_65_248 VGND VGND VPWR VPWR sky130_fd_sc_hd__decap_3
XPHY_EDGE_ROW_63_Right_63 VGND VGND VPWR VPWR sky130_fd_sc_hd__decap_3
XFILLER_80_218 VGND VGND VPWR VPWR sky130_fd_sc_hd__decap_3
XFILLER_61_421 VGND VGND VPWR VPWR sky130_fd_sc_hd__decap_3
XFILLER_73_281 VGND VGND VPWR VPWR sky130_fd_sc_hd__decap_3
XFILLER_33_156 VGND VGND VPWR VPWR sky130_fd_sc_hd__decap_3
XFILLER_33_178 VGND VGND VPWR VPWR sky130_fd_sc_hd__decap_3
XTAP_TAPCELL_ROW_72_972 VGND VPWR sky130_fd_sc_hd__tapvpwrvgnd_1
XTAP_TAPCELL_ROW_44_674 VGND VPWR sky130_fd_sc_hd__tapvpwrvgnd_1
X_4740_ _5068_/A _4757_/B _4764_/A _4740_/D VGND VGND VPWR VPWR _4764_/B sky130_fd_sc_hd__nand4_2
XTAP_TAPCELL_ROW_16_387 VGND VPWR sky130_fd_sc_hd__tapvpwrvgnd_1
X_4671_ _4610_/A _4610_/C _4610_/B VGND VGND VPWR VPWR _4672_/C sky130_fd_sc_hd__o21ai_2
X_6410_ _6089_/B _3941_/A _6410_/S VGND VGND VPWR VPWR _6410_/X sky130_fd_sc_hd__mux2_1
X_3622_ _3655_/A _6014_/A VGND VGND VPWR VPWR _3624_/B sky130_fd_sc_hd__and2_2
XTAP_TAPCELL_ROW_99_1256 VGND VPWR sky130_fd_sc_hd__tapvpwrvgnd_1
XPHY_EDGE_ROW_78_Left_179 VGND VGND VPWR VPWR sky130_fd_sc_hd__decap_3
X_6341_ _6342_/A _6384_/D VGND VGND VPWR VPWR _6498_/B sky130_fd_sc_hd__nor2_2
XPHY_EDGE_ROW_72_Right_72 VGND VGND VPWR VPWR sky130_fd_sc_hd__decap_3
X_3553_ _3553_/A _3575_/A VGND VGND VPWR VPWR _3555_/C sky130_fd_sc_hd__nand2_2
X_6272_ _6874_/B _6874_/C _6874_/A VGND VGND VPWR VPWR _6273_/B sky130_fd_sc_hd__a21oi_2
X_3484_ _6073_/A VGND VGND VPWR VPWR _3484_/Y sky130_fd_sc_hd__inv_2
XFILLER_88_318 VGND VGND VPWR VPWR sky130_fd_sc_hd__decap_3
X_5223_ _5277_/C _5268_/C _5398_/C _5490_/D VGND VGND VPWR VPWR _5223_/X sky130_fd_sc_hd__and4_2
X_5154_ _5151_/X _5154_/B VGND VGND VPWR VPWR _5228_/B sky130_fd_sc_hd__and2b_2
X_4105_ _4106_/A _4106_/B _4106_/C VGND VGND VPWR VPWR _4109_/A sky130_fd_sc_hd__a21o_2
XFILLER_84_524 VGND VGND VPWR VPWR sky130_fd_sc_hd__decap_3
X_5085_ _5084_/A _5084_/C _5084_/B VGND VGND VPWR VPWR _5085_/Y sky130_fd_sc_hd__a21oi_2
XPHY_EDGE_ROW_87_Left_188 VGND VGND VPWR VPWR sky130_fd_sc_hd__decap_3
XPHY_EDGE_ROW_81_Right_81 VGND VGND VPWR VPWR sky130_fd_sc_hd__decap_3
XFILLER_56_248 VGND VGND VPWR VPWR sky130_fd_sc_hd__decap_3
XFILLER_56_259 VGND VGND VPWR VPWR sky130_fd_sc_hd__decap_3
X_4036_ _4036_/A _4036_/B _4036_/C VGND VGND VPWR VPWR _4042_/A sky130_fd_sc_hd__or3_2
XFILLER_71_207 VGND VGND VPWR VPWR sky130_fd_sc_hd__decap_3
XFILLER_52_421 VGND VGND VPWR VPWR sky130_fd_sc_hd__fill_1
XFILLER_52_432 VGND VGND VPWR VPWR sky130_fd_sc_hd__fill_1
X_5987_ _5987_/A _5987_/B VGND VGND VPWR VPWR _5988_/B sky130_fd_sc_hd__xnor2_2
XFILLER_52_498 VGND VGND VPWR VPWR sky130_fd_sc_hd__decap_3
X_4938_ _4933_/Y _5016_/A _4710_/Y _4923_/X VGND VGND VPWR VPWR _4940_/B sky130_fd_sc_hd__a211o_2
X_4869_ _4868_/A _4868_/B _4868_/C VGND VGND VPWR VPWR _4870_/C sky130_fd_sc_hd__a21o_2
XPHY_EDGE_ROW_96_Left_197 VGND VGND VPWR VPWR sky130_fd_sc_hd__decap_3
XFILLER_20_362 VGND VGND VPWR VPWR sky130_fd_sc_hd__fill_2
XFILLER_20_373 VGND VGND VPWR VPWR sky130_fd_sc_hd__fill_2
XFILLER_20_384 VGND VGND VPWR VPWR sky130_fd_sc_hd__decap_3
X_6608_ _6372_/A _6607_/X _6608_/S VGND VGND VPWR VPWR _6875_/A sky130_fd_sc_hd__mux2_1
XPHY_EDGE_ROW_90_Right_90 VGND VGND VPWR VPWR sky130_fd_sc_hd__decap_3
XFILLER_4_528 VGND VGND VPWR VPWR sky130_fd_sc_hd__decap_3
X_6539_ _6539_/A _6539_/B VGND VGND VPWR VPWR _6540_/D sky130_fd_sc_hd__or2_2
XTAP_TAPCELL_ROW_76_1020 VGND VPWR sky130_fd_sc_hd__tapvpwrvgnd_1
XFILLER_79_329 VGND VGND VPWR VPWR sky130_fd_sc_hd__decap_3
XFILLER_87_351 VGND VGND VPWR VPWR sky130_fd_sc_hd__decap_3
XFILLER_87_373 VGND VGND VPWR VPWR sky130_fd_sc_hd__decap_3
XFILLER_47_237 VGND VGND VPWR VPWR sky130_fd_sc_hd__decap_3
XFILLER_75_546 VGND VGND VPWR VPWR sky130_fd_sc_hd__fill_2
XFILLER_90_505 VGND VGND VPWR VPWR sky130_fd_sc_hd__decap_3
XFILLER_55_270 VGND VGND VPWR VPWR sky130_fd_sc_hd__decap_3
XFILLER_46_97 VGND VGND VPWR VPWR sky130_fd_sc_hd__decap_3
XFILLER_83_590 VGND VGND VPWR VPWR sky130_fd_sc_hd__decap_3
XFILLER_15_167 VGND VGND VPWR VPWR sky130_fd_sc_hd__fill_1
XFILLER_70_262 VGND VGND VPWR VPWR sky130_fd_sc_hd__decap_3
XFILLER_62_74 VGND VGND VPWR VPWR sky130_fd_sc_hd__decap_3
XFILLER_62_85 VGND VGND VPWR VPWR sky130_fd_sc_hd__decap_3
XTAP_TAPCELL_ROW_41_644 VGND VPWR sky130_fd_sc_hd__tapvpwrvgnd_1
XTAP_TAPCELL_ROW_13_357 VGND VPWR sky130_fd_sc_hd__tapvpwrvgnd_1
XFILLER_7_69 VGND VGND VPWR VPWR sky130_fd_sc_hd__fill_2
Xload_slew203 _6152_/A VGND VGND VPWR VPWR _3812_/A sky130_fd_sc_hd__buf_4
XFILLER_87_93 VGND VGND VPWR VPWR sky130_fd_sc_hd__decap_3
Xload_slew258 _6244_/B VGND VGND VPWR VPWR _3626_/A sky130_fd_sc_hd__buf_4
Xload_slew247 _6216_/B VGND VGND VPWR VPWR _5576_/D sky130_fd_sc_hd__buf_6
XFILLER_38_215 VGND VGND VPWR VPWR sky130_fd_sc_hd__fill_2
XFILLER_93_321 VGND VGND VPWR VPWR sky130_fd_sc_hd__decap_3
XTAP_TAPCELL_ROW_49_733 VGND VPWR sky130_fd_sc_hd__tapvpwrvgnd_1
XFILLER_66_568 VGND VGND VPWR VPWR sky130_fd_sc_hd__fill_1
XFILLER_81_505 VGND VGND VPWR VPWR sky130_fd_sc_hd__decap_3
XFILLER_93_343 VGND VGND VPWR VPWR sky130_fd_sc_hd__decap_3
XFILLER_81_516 VGND VGND VPWR VPWR sky130_fd_sc_hd__fill_1
XFILLER_81_538 VGND VGND VPWR VPWR sky130_fd_sc_hd__decap_3
XFILLER_93_387 VGND VGND VPWR VPWR sky130_fd_sc_hd__decap_3
X_5910_ _5931_/B _5902_/X _5907_/A _5908_/Y VGND VGND VPWR VPWR _5911_/B sky130_fd_sc_hd__a211o_2
XFILLER_34_421 VGND VGND VPWR VPWR sky130_fd_sc_hd__fill_2
X_6890_ _6890_/A _6902_/B VGND VGND VPWR VPWR _6890_/Y sky130_fd_sc_hd__xnor2_2
XFILLER_34_465 VGND VGND VPWR VPWR sky130_fd_sc_hd__fill_1
XFILLER_61_240 VGND VGND VPWR VPWR sky130_fd_sc_hd__decap_3
XFILLER_61_262 VGND VGND VPWR VPWR sky130_fd_sc_hd__decap_3
X_5841_ _5837_/Y _5840_/X _5257_/B _5822_/X VGND VGND VPWR VPWR _5856_/A sky130_fd_sc_hd__a211oi_2
X_5772_ _5772_/A _5772_/B VGND VGND VPWR VPWR _6562_/A sky130_fd_sc_hd__xor2_2
X_4723_ _4722_/A _4722_/C _4722_/B VGND VGND VPWR VPWR _4724_/B sky130_fd_sc_hd__a21o_4
X_4654_ _4651_/A _5018_/B _4689_/B _4653_/A VGND VGND VPWR VPWR _4691_/A sky130_fd_sc_hd__a31o_2
Xinput61 B[6] VGND VGND VPWR VPWR input61/X sky130_fd_sc_hd__buf_4
Xinput50 B[25] VGND VGND VPWR VPWR _6187_/A sky130_fd_sc_hd__clkdlybuf4s25_1
X_4585_ _4585_/A _4782_/B VGND VGND VPWR VPWR _4823_/A sky130_fd_sc_hd__nand2_2
X_3605_ _3605_/A _3605_/B _3605_/C VGND VGND VPWR VPWR _3613_/B sky130_fd_sc_hd__nand3_2
X_6324_ _6322_/X _6323_/X _6831_/S VGND VGND VPWR VPWR _6324_/X sky130_fd_sc_hd__mux2_1
X_3536_ _3955_/A _3961_/C _3961_/D _3990_/A VGND VGND VPWR VPWR _3537_/B sky130_fd_sc_hd__a22oi_2
XFILLER_88_104 VGND VGND VPWR VPWR sky130_fd_sc_hd__decap_3
X_6255_ _6255_/A _6758_/C _6255_/C VGND VGND VPWR VPWR _6787_/C sky130_fd_sc_hd__nand3_2
XFILLER_88_126 VGND VGND VPWR VPWR sky130_fd_sc_hd__decap_3
X_5206_ _5206_/A _5206_/B VGND VGND VPWR VPWR _5213_/B sky130_fd_sc_hd__nor2_2
XFILLER_88_159 VGND VGND VPWR VPWR sky130_fd_sc_hd__decap_3
X_6186_ _6902_/A VGND VGND VPWR VPWR _6186_/Y sky130_fd_sc_hd__inv_2
X_5137_ _5137_/A _5313_/B VGND VGND VPWR VPWR _5139_/B sky130_fd_sc_hd__and2_2
XFILLER_29_237 VGND VGND VPWR VPWR sky130_fd_sc_hd__decap_3
X_5068_ _5068_/A _6501_/S VGND VGND VPWR VPWR _5156_/A sky130_fd_sc_hd__nand2_2
XFILLER_84_365 VGND VGND VPWR VPWR sky130_fd_sc_hd__decap_3
X_4019_ _3964_/A _3963_/B _3963_/A VGND VGND VPWR VPWR _4020_/B sky130_fd_sc_hd__o21ba_2
XFILLER_16_67 VGND VGND VPWR VPWR sky130_fd_sc_hd__decap_3
XFILLER_25_465 VGND VGND VPWR VPWR sky130_fd_sc_hd__decap_3
XFILLER_40_402 VGND VGND VPWR VPWR sky130_fd_sc_hd__fill_1
XFILLER_52_240 VGND VGND VPWR VPWR sky130_fd_sc_hd__decap_3
XPHY_EDGE_ROW_0_Right_0 VGND VGND VPWR VPWR sky130_fd_sc_hd__decap_3
XFILLER_12_126 VGND VGND VPWR VPWR sky130_fd_sc_hd__decap_3
XFILLER_52_284 VGND VGND VPWR VPWR sky130_fd_sc_hd__decap_3
XFILLER_12_159 VGND VGND VPWR VPWR sky130_fd_sc_hd__fill_1
XTAP_TAPCELL_ROW_10_327 VGND VPWR sky130_fd_sc_hd__tapvpwrvgnd_1
XFILLER_0_542 VGND VGND VPWR VPWR sky130_fd_sc_hd__decap_3
XFILLER_0_564 VGND VGND VPWR VPWR sky130_fd_sc_hd__decap_3
XFILLER_57_63 VGND VGND VPWR VPWR sky130_fd_sc_hd__decap_3
XFILLER_57_96 VGND VGND VPWR VPWR sky130_fd_sc_hd__decap_3
XFILLER_87_192 VGND VGND VPWR VPWR sky130_fd_sc_hd__decap_3
XFILLER_35_218 VGND VGND VPWR VPWR sky130_fd_sc_hd__fill_1
XFILLER_63_516 VGND VGND VPWR VPWR sky130_fd_sc_hd__decap_3
XFILLER_75_365 VGND VGND VPWR VPWR sky130_fd_sc_hd__decap_3
XTAP_TAPCELL_ROW_85_1108 VGND VPWR sky130_fd_sc_hd__tapvpwrvgnd_1
XTAP_TAPCELL_ROW_46_703 VGND VPWR sky130_fd_sc_hd__tapvpwrvgnd_1
XTAP_TAPCELL_ROW_18_405 VGND VPWR sky130_fd_sc_hd__tapvpwrvgnd_1
XFILLER_16_421 VGND VGND VPWR VPWR sky130_fd_sc_hd__decap_3
XFILLER_90_346 VGND VGND VPWR VPWR sky130_fd_sc_hd__decap_3
XFILLER_31_402 VGND VGND VPWR VPWR sky130_fd_sc_hd__fill_1
XFILLER_43_240 VGND VGND VPWR VPWR sky130_fd_sc_hd__fill_1
XFILLER_90_368 VGND VGND VPWR VPWR sky130_fd_sc_hd__decap_3
XFILLER_16_498 VGND VGND VPWR VPWR sky130_fd_sc_hd__fill_1
XTAP_TAPCELL_ROW_54_780 VGND VPWR sky130_fd_sc_hd__tapvpwrvgnd_1
XFILLER_31_446 VGND VGND VPWR VPWR sky130_fd_sc_hd__fill_2
XTAP_TAPCELL_ROW_26_493 VGND VPWR sky130_fd_sc_hd__tapvpwrvgnd_1
XFILLER_85_7 VGND VGND VPWR VPWR sky130_fd_sc_hd__decap_3
XFILLER_7_152 VGND VGND VPWR VPWR sky130_fd_sc_hd__decap_3
XTAP_TAPCELL_ROW_96_1226 VGND VPWR sky130_fd_sc_hd__tapvpwrvgnd_1
XFILLER_7_185 VGND VGND VPWR VPWR sky130_fd_sc_hd__decap_3
X_4370_ _4370_/A _4370_/B _4370_/C VGND VGND VPWR VPWR _4370_/Y sky130_fd_sc_hd__nand3_2
XFILLER_39_502 VGND VGND VPWR VPWR sky130_fd_sc_hd__fill_2
X_6040_ _3866_/A _3866_/B _3883_/Y VGND VGND VPWR VPWR _6043_/A sky130_fd_sc_hd__o21ai_2
XFILLER_66_321 VGND VGND VPWR VPWR sky130_fd_sc_hd__decap_3
XFILLER_78_181 VGND VGND VPWR VPWR sky130_fd_sc_hd__decap_3
XFILLER_93_140 VGND VGND VPWR VPWR sky130_fd_sc_hd__fill_2
XFILLER_81_302 VGND VGND VPWR VPWR sky130_fd_sc_hd__decap_3
XFILLER_93_162 VGND VGND VPWR VPWR sky130_fd_sc_hd__decap_3
XFILLER_19_292 VGND VGND VPWR VPWR sky130_fd_sc_hd__fill_1
XFILLER_26_229 VGND VGND VPWR VPWR sky130_fd_sc_hd__decap_3
XFILLER_66_398 VGND VGND VPWR VPWR sky130_fd_sc_hd__decap_3
XFILLER_81_346 VGND VGND VPWR VPWR sky130_fd_sc_hd__decap_3
XFILLER_93_184 VGND VGND VPWR VPWR sky130_fd_sc_hd__decap_3
X_6942_ _6205_/A _6978_/B1 _6941_/X VGND VGND VPWR VPWR _6942_/Y sky130_fd_sc_hd__o21ai_2
XFILLER_81_368 VGND VGND VPWR VPWR sky130_fd_sc_hd__decap_3
X_6873_ _5261_/Y _6873_/A2 _5916_/B _6841_/A VGND VGND VPWR VPWR _6873_/X sky130_fd_sc_hd__a31o_2
XFILLER_22_424 VGND VGND VPWR VPWR sky130_fd_sc_hd__fill_1
XFILLER_34_273 VGND VGND VPWR VPWR sky130_fd_sc_hd__decap_3
X_5824_ _5242_/A _5242_/C _5443_/A VGND VGND VPWR VPWR _5830_/B sky130_fd_sc_hd__o21ai_2
X_5755_ _5755_/A _5755_/B VGND VGND VPWR VPWR _5809_/A sky130_fd_sc_hd__xnor2_2
X_5686_ _5690_/B _5690_/A VGND VGND VPWR VPWR _5686_/Y sky130_fd_sc_hd__nand2b_2
X_4706_ _6109_/A _6106_/B _6109_/B _6238_/B VGND VGND VPWR VPWR _4706_/X sky130_fd_sc_hd__a22o_2
X_4637_ _4637_/A _4648_/A VGND VGND VPWR VPWR _4657_/A sky130_fd_sc_hd__nor2_2
X_4568_ _4826_/A _4568_/B VGND VGND VPWR VPWR _4577_/A sky130_fd_sc_hd__nand2_2
XFILLER_89_446 VGND VGND VPWR VPWR sky130_fd_sc_hd__fill_2
X_6307_ _6505_/B _6306_/X _6832_/S VGND VGND VPWR VPWR _6307_/X sky130_fd_sc_hd__mux2_1
X_4499_ _4469_/A _5885_/A _4557_/A1 _4454_/X VGND VGND VPWR VPWR _4499_/X sky130_fd_sc_hd__a211o_2
X_3519_ _3872_/A _6893_/S _3518_/C VGND VGND VPWR VPWR _3520_/B sky130_fd_sc_hd__a21oi_2
XFILLER_89_468 VGND VGND VPWR VPWR sky130_fd_sc_hd__decap_3
X_6238_ _6106_/B _6238_/B VGND VGND VPWR VPWR _6238_/Y sky130_fd_sc_hd__nand2b_2
XFILLER_57_310 VGND VGND VPWR VPWR sky130_fd_sc_hd__decap_3
XFILLER_76_118 VGND VGND VPWR VPWR sky130_fd_sc_hd__decap_3
X_6169_ _6265_/A _6264_/B _6076_/Y _6170_/A VGND VGND VPWR VPWR _6172_/A sky130_fd_sc_hd__o31a_2
XFILLER_57_343 VGND VGND VPWR VPWR sky130_fd_sc_hd__decap_3
XFILLER_69_181 VGND VGND VPWR VPWR sky130_fd_sc_hd__decap_3
XFILLER_45_505 VGND VGND VPWR VPWR sky130_fd_sc_hd__decap_3
XFILLER_57_376 VGND VGND VPWR VPWR sky130_fd_sc_hd__decap_3
XFILLER_84_162 VGND VGND VPWR VPWR sky130_fd_sc_hd__fill_2
XFILLER_60_508 VGND VGND VPWR VPWR sky130_fd_sc_hd__decap_3
XFILLER_13_402 VGND VGND VPWR VPWR sky130_fd_sc_hd__decap_3
XFILLER_25_284 VGND VGND VPWR VPWR sky130_fd_sc_hd__decap_3
XFILLER_40_243 VGND VGND VPWR VPWR sky130_fd_sc_hd__decap_3
XFILLER_43_65 VGND VGND VPWR VPWR sky130_fd_sc_hd__decap_3
XFILLER_40_265 VGND VGND VPWR VPWR sky130_fd_sc_hd__decap_3
XTAP_TAPCELL_ROW_51_750 VGND VPWR sky130_fd_sc_hd__tapvpwrvgnd_1
XTAP_TAPCELL_ROW_23_463 VGND VPWR sky130_fd_sc_hd__tapvpwrvgnd_1
XFILLER_40_298 VGND VGND VPWR VPWR sky130_fd_sc_hd__decap_3
Xrebuffer750 _4755_/C VGND VGND VPWR VPWR _4738_/C sky130_fd_sc_hd__buf_2
XFILLER_4_100 VGND VGND VPWR VPWR sky130_fd_sc_hd__decap_3
Xrebuffer761 _4434_/A VGND VGND VPWR VPWR _5926_/C1 sky130_fd_sc_hd__buf_2
XFILLER_95_405 VGND VGND VPWR VPWR sky130_fd_sc_hd__decap_3
XFILLER_0_372 VGND VGND VPWR VPWR sky130_fd_sc_hd__decap_3
XFILLER_68_73 VGND VGND VPWR VPWR sky130_fd_sc_hd__decap_3
XFILLER_95_449 VGND VGND VPWR VPWR sky130_fd_sc_hd__decap_3
XFILLER_95_438 VGND VGND VPWR VPWR sky130_fd_sc_hd__decap_3
XFILLER_95_416 VGND VGND VPWR VPWR sky130_fd_sc_hd__decap_3
XFILLER_48_343 VGND VGND VPWR VPWR sky130_fd_sc_hd__fill_1
XFILLER_88_490 VGND VGND VPWR VPWR sky130_fd_sc_hd__decap_3
XFILLER_48_376 VGND VGND VPWR VPWR sky130_fd_sc_hd__decap_3
XFILLER_63_302 VGND VGND VPWR VPWR sky130_fd_sc_hd__decap_3
XFILLER_63_346 VGND VGND VPWR VPWR sky130_fd_sc_hd__decap_3
XFILLER_84_83 VGND VGND VPWR VPWR sky130_fd_sc_hd__fill_1
XFILLER_51_508 VGND VGND VPWR VPWR sky130_fd_sc_hd__decap_3
XFILLER_63_379 VGND VGND VPWR VPWR sky130_fd_sc_hd__decap_3
XFILLER_90_154 VGND VGND VPWR VPWR sky130_fd_sc_hd__decap_3
XFILLER_71_390 VGND VGND VPWR VPWR sky130_fd_sc_hd__fill_2
X_3870_ _6275_/B _3870_/A2 _4176_/A _3869_/D VGND VGND VPWR VPWR _3871_/B sky130_fd_sc_hd__a22oi_2
XFILLER_31_265 VGND VGND VPWR VPWR sky130_fd_sc_hd__decap_3
X_5540_ _5540_/A _5540_/B VGND VGND VPWR VPWR _5542_/B sky130_fd_sc_hd__xor2_2
XTAP_TAPCELL_ROW_100_1274 VGND VPWR sky130_fd_sc_hd__tapvpwrvgnd_1
XTAP_TAPCELL_ROW_100_1263 VGND VPWR sky130_fd_sc_hd__tapvpwrvgnd_1
XFILLER_8_461 VGND VGND VPWR VPWR sky130_fd_sc_hd__decap_3
X_5471_ _5869_/B1 _5469_/Y _5288_/A _5289_/Y VGND VGND VPWR VPWR _5471_/X sky130_fd_sc_hd__o211a_2
X_4422_ _6254_/B _4420_/C _4538_/D _4585_/A VGND VGND VPWR VPWR _4423_/B sky130_fd_sc_hd__a22o_2
X_4353_ _4243_/A _4243_/C _4243_/B VGND VGND VPWR VPWR _4370_/B sky130_fd_sc_hd__a21o_2
Xfanout429 _6019_/C VGND VGND VPWR VPWR _3933_/D sky130_fd_sc_hd__clkdlybuf4s25_1
X_4284_ _4279_/A _4279_/C _4279_/B VGND VGND VPWR VPWR _4285_/C sky130_fd_sc_hd__a21o_2
XFILLER_98_265 VGND VGND VPWR VPWR sky130_fd_sc_hd__decap_3
XFILLER_58_107 VGND VGND VPWR VPWR sky130_fd_sc_hd__fill_2
XFILLER_86_416 VGND VGND VPWR VPWR sky130_fd_sc_hd__decap_3
XFILLER_86_427 VGND VGND VPWR VPWR sky130_fd_sc_hd__decap_3
X_6023_ _6023_/A _6023_/B VGND VGND VPWR VPWR _6031_/A sky130_fd_sc_hd__xnor2_2
XFILLER_100_248 VGND VGND VPWR VPWR sky130_fd_sc_hd__decap_3
XFILLER_100_259 VGND VGND VPWR VPWR sky130_fd_sc_hd__decap_3
XFILLER_27_505 VGND VGND VPWR VPWR sky130_fd_sc_hd__fill_1
XFILLER_27_527 VGND VGND VPWR VPWR sky130_fd_sc_hd__decap_3
XFILLER_39_354 VGND VGND VPWR VPWR sky130_fd_sc_hd__decap_3
XFILLER_66_162 VGND VGND VPWR VPWR sky130_fd_sc_hd__decap_3
XFILLER_94_460 VGND VGND VPWR VPWR sky130_fd_sc_hd__decap_3
XFILLER_54_346 VGND VGND VPWR VPWR sky130_fd_sc_hd__decap_3
XFILLER_94_493 VGND VGND VPWR VPWR sky130_fd_sc_hd__decap_3
XFILLER_54_379 VGND VGND VPWR VPWR sky130_fd_sc_hd__fill_1
X_6925_ _6961_/A1 _6800_/X _6924_/X _6960_/A VGND VGND VPWR VPWR _6925_/Y sky130_fd_sc_hd__a22oi_2
XFILLER_81_187 VGND VGND VPWR VPWR sky130_fd_sc_hd__decap_3
XTAP_TAPCELL_ROW_65_897 VGND VPWR sky130_fd_sc_hd__tapvpwrvgnd_1
XFILLER_22_232 VGND VGND VPWR VPWR sky130_fd_sc_hd__decap_3
X_6856_ _6856_/A _6856_/B VGND VGND VPWR VPWR _6857_/B sky130_fd_sc_hd__nor2_2
X_6787_ _6787_/A _6787_/B _6787_/C VGND VGND VPWR VPWR _6788_/C sky130_fd_sc_hd__and3_2
X_5807_ _6562_/A _6562_/B VGND VGND VPWR VPWR _5807_/Y sky130_fd_sc_hd__nand2_2
X_3999_ _6196_/A _4003_/B _6286_/A _4088_/B VGND VGND VPWR VPWR _4000_/C sky130_fd_sc_hd__a22o_2
XFILLER_10_427 VGND VGND VPWR VPWR sky130_fd_sc_hd__decap_3
XFILLER_13_57 VGND VGND VPWR VPWR sky130_fd_sc_hd__decap_3
X_5738_ _5739_/A _5739_/D VGND VGND VPWR VPWR _5757_/B sky130_fd_sc_hd__nand2_2
XTAP_TAPCELL_ROW_20_422 VGND VPWR sky130_fd_sc_hd__tapvpwrvgnd_1
XFILLER_6_409 VGND VGND VPWR VPWR sky130_fd_sc_hd__decap_3
X_5669_ _5667_/A _5667_/C _5667_/B VGND VGND VPWR VPWR _5670_/C sky130_fd_sc_hd__a21oi_2
XFILLER_1_103 VGND VGND VPWR VPWR sky130_fd_sc_hd__decap_3
XFILLER_89_221 VGND VGND VPWR VPWR sky130_fd_sc_hd__decap_3
XFILLER_8_6 VGND VGND VPWR VPWR sky130_fd_sc_hd__decap_3
XFILLER_77_405 VGND VGND VPWR VPWR sky130_fd_sc_hd__decap_3
XFILLER_89_243 VGND VGND VPWR VPWR sky130_fd_sc_hd__decap_3
XFILLER_1_169 VGND VGND VPWR VPWR sky130_fd_sc_hd__fill_1
XFILLER_89_287 VGND VGND VPWR VPWR sky130_fd_sc_hd__decap_3
XFILLER_77_449 VGND VGND VPWR VPWR sky130_fd_sc_hd__decap_3
XFILLER_45_302 VGND VGND VPWR VPWR sky130_fd_sc_hd__fill_1
XFILLER_57_162 VGND VGND VPWR VPWR sky130_fd_sc_hd__decap_3
XFILLER_57_184 VGND VGND VPWR VPWR sky130_fd_sc_hd__decap_3
XTAP_TAPCELL_ROW_28_511 VGND VPWR sky130_fd_sc_hd__tapvpwrvgnd_1
XFILLER_45_368 VGND VGND VPWR VPWR sky130_fd_sc_hd__decap_3
XFILLER_26_560 VGND VGND VPWR VPWR sky130_fd_sc_hd__decap_3
XFILLER_26_582 VGND VGND VPWR VPWR sky130_fd_sc_hd__decap_3
XFILLER_60_327 VGND VGND VPWR VPWR sky130_fd_sc_hd__decap_3
XFILLER_54_97 VGND VGND VPWR VPWR sky130_fd_sc_hd__fill_1
XFILLER_9_225 VGND VGND VPWR VPWR sky130_fd_sc_hd__decap_3
XFILLER_13_287 VGND VGND VPWR VPWR sky130_fd_sc_hd__fill_1
XFILLER_9_258 VGND VGND VPWR VPWR sky130_fd_sc_hd__decap_3
XFILLER_5_486 VGND VGND VPWR VPWR sky130_fd_sc_hd__decap_3
XFILLER_79_50 VGND VGND VPWR VPWR sky130_fd_sc_hd__decap_3
XFILLER_95_246 VGND VGND VPWR VPWR sky130_fd_sc_hd__decap_3
XFILLER_36_302 VGND VGND VPWR VPWR sky130_fd_sc_hd__decap_3
XFILLER_24_519 VGND VGND VPWR VPWR sky130_fd_sc_hd__decap_3
XFILLER_91_452 VGND VGND VPWR VPWR sky130_fd_sc_hd__decap_3
XFILLER_36_379 VGND VGND VPWR VPWR sky130_fd_sc_hd__decap_3
XFILLER_63_165 VGND VGND VPWR VPWR sky130_fd_sc_hd__decap_3
XFILLER_63_187 VGND VGND VPWR VPWR sky130_fd_sc_hd__fill_2
XFILLER_91_474 VGND VGND VPWR VPWR sky130_fd_sc_hd__decap_3
X_4971_ _4956_/A _4956_/B _4956_/C VGND VGND VPWR VPWR _4971_/Y sky130_fd_sc_hd__a21oi_2
X_6710_ _6453_/X _6457_/B _6478_/X _6567_/B _6698_/A _6783_/S VGND VGND VPWR VPWR
+ _6710_/X sky130_fd_sc_hd__mux4_2
X_3922_ _3923_/B _6025_/A VGND VGND VPWR VPWR _6153_/A sky130_fd_sc_hd__nand2_2
XTAP_TAPCELL_ROW_62_867 VGND VPWR sky130_fd_sc_hd__tapvpwrvgnd_1
X_6641_ _6783_/S _6961_/A1 _6476_/Y _6640_/X _6765_/B VGND VGND VPWR VPWR _6641_/Y
+ sky130_fd_sc_hd__a32oi_2
X_3853_ _3853_/A _3853_/B VGND VGND VPWR VPWR _3855_/A sky130_fd_sc_hd__nor2_2
XTAP_TAPCELL_ROW_34_569 VGND VPWR sky130_fd_sc_hd__tapvpwrvgnd_1
X_6572_ _6115_/Y _6963_/A2 _6891_/B1 _6117_/A VGND VGND VPWR VPWR _6572_/X sky130_fd_sc_hd__o22a_2
X_3784_ _3733_/A _3733_/B _4079_/A VGND VGND VPWR VPWR _4083_/A sky130_fd_sc_hd__a21bo_2
X_5523_ _5321_/B _6212_/B _5304_/C VGND VGND VPWR VPWR _5524_/B sky130_fd_sc_hd__a21oi_2
X_5454_ _5455_/A _5455_/B _5455_/C VGND VGND VPWR VPWR _5454_/X sky130_fd_sc_hd__o21a_2
X_5385_ _5385_/A _5385_/B VGND VGND VPWR VPWR _5481_/B sky130_fd_sc_hd__nor2_2
X_4405_ _4405_/A _4405_/B _4405_/C VGND VGND VPWR VPWR _4412_/A sky130_fd_sc_hd__nand3_2
XFILLER_99_530 VGND VGND VPWR VPWR sky130_fd_sc_hd__decap_3
X_4336_ _4457_/B _4334_/C _4457_/C _4593_/B VGND VGND VPWR VPWR _4337_/B sky130_fd_sc_hd__a22o_2
Xfanout215 _5322_/B VGND VGND VPWR VPWR _5340_/B sky130_fd_sc_hd__dlymetal6s2s_1
Xfanout226 _4755_/C VGND VGND VPWR VPWR _5328_/C sky130_fd_sc_hd__buf_8
Xfanout237 input61/X VGND VGND VPWR VPWR _6116_/B sky130_fd_sc_hd__buf_6
XFILLER_59_449 VGND VGND VPWR VPWR sky130_fd_sc_hd__decap_3
Xfanout248 _4407_/B VGND VGND VPWR VPWR _4766_/B sky130_fd_sc_hd__dlygate4sd1_1
Xfanout259 input6/X VGND VGND VPWR VPWR _5976_/D sky130_fd_sc_hd__clkdlybuf4s25_1
X_4267_ _4266_/A _4386_/A VGND VGND VPWR VPWR _4269_/B sky130_fd_sc_hd__nand2b_2
XFILLER_74_419 VGND VGND VPWR VPWR sky130_fd_sc_hd__fill_1
XFILLER_86_268 VGND VGND VPWR VPWR sky130_fd_sc_hd__decap_3
X_6006_ _6006_/A _6350_/B VGND VGND VPWR VPWR _6007_/B sky130_fd_sc_hd__nand2_2
X_4198_ _4197_/A _4197_/Y _4080_/B _4084_/X VGND VGND VPWR VPWR _4201_/A sky130_fd_sc_hd__o211a_2
XFILLER_27_335 VGND VGND VPWR VPWR sky130_fd_sc_hd__fill_1
XFILLER_39_195 VGND VGND VPWR VPWR sky130_fd_sc_hd__decap_3
XFILLER_67_482 VGND VGND VPWR VPWR sky130_fd_sc_hd__decap_3
XFILLER_27_346 VGND VGND VPWR VPWR sky130_fd_sc_hd__fill_2
XFILLER_82_441 VGND VGND VPWR VPWR sky130_fd_sc_hd__decap_3
XFILLER_42_305 VGND VGND VPWR VPWR sky130_fd_sc_hd__decap_3
XFILLER_42_338 VGND VGND VPWR VPWR sky130_fd_sc_hd__decap_3
X_6908_ _6278_/A _6273_/Y _6278_/B _6932_/B VGND VGND VPWR VPWR _6908_/X sky130_fd_sc_hd__a31o_2
XFILLER_23_552 VGND VGND VPWR VPWR sky130_fd_sc_hd__decap_3
XFILLER_24_45 VGND VGND VPWR VPWR sky130_fd_sc_hd__fill_1
X_6839_ _6839_/A _6839_/B _6839_/C VGND VGND VPWR VPWR _6841_/C sky130_fd_sc_hd__and3_2
XFILLER_50_371 VGND VGND VPWR VPWR sky130_fd_sc_hd__decap_3
XFILLER_6_206 VGND VGND VPWR VPWR sky130_fd_sc_hd__fill_1
XTAP_TAPCELL_ROW_79_1051 VGND VPWR sky130_fd_sc_hd__tapvpwrvgnd_1
XFILLER_40_99 VGND VGND VPWR VPWR sky130_fd_sc_hd__decap_3
XFILLER_6_3 VGND VGND VPWR VPWR sky130_fd_sc_hd__decap_3
XFILLER_49_53 VGND VGND VPWR VPWR sky130_fd_sc_hd__decap_3
XFILLER_49_97 VGND VGND VPWR VPWR sky130_fd_sc_hd__decap_3
XFILLER_77_257 VGND VGND VPWR VPWR sky130_fd_sc_hd__decap_3
XFILLER_92_205 VGND VGND VPWR VPWR sky130_fd_sc_hd__decap_3
XTAP_TAPCELL_ROW_5_272 VGND VPWR sky130_fd_sc_hd__tapvpwrvgnd_1
XFILLER_65_41 VGND VGND VPWR VPWR sky130_fd_sc_hd__decap_3
XFILLER_92_238 VGND VGND VPWR VPWR sky130_fd_sc_hd__decap_3
XFILLER_18_368 VGND VGND VPWR VPWR sky130_fd_sc_hd__fill_1
XFILLER_45_143 VGND VGND VPWR VPWR sky130_fd_sc_hd__decap_3
XFILLER_65_85 VGND VGND VPWR VPWR sky130_fd_sc_hd__decap_3
XFILLER_73_452 VGND VGND VPWR VPWR sky130_fd_sc_hd__decap_3
XFILLER_85_290 VGND VGND VPWR VPWR sky130_fd_sc_hd__decap_3
XFILLER_33_327 VGND VGND VPWR VPWR sky130_fd_sc_hd__decap_3
XFILLER_73_485 VGND VGND VPWR VPWR sky130_fd_sc_hd__decap_3
XFILLER_60_124 VGND VGND VPWR VPWR sky130_fd_sc_hd__decap_3
XFILLER_60_179 VGND VGND VPWR VPWR sky130_fd_sc_hd__decap_3
XFILLER_81_51 VGND VGND VPWR VPWR sky130_fd_sc_hd__decap_3
XFILLER_14_596 VGND VGND VPWR VPWR sky130_fd_sc_hd__fill_2
XFILLER_41_393 VGND VGND VPWR VPWR sky130_fd_sc_hd__decap_3
XFILLER_81_73 VGND VGND VPWR VPWR sky130_fd_sc_hd__decap_3
XTAP_TAPCELL_ROW_31_539 VGND VPWR sky130_fd_sc_hd__tapvpwrvgnd_1
XFILLER_39_3 VGND VGND VPWR VPWR sky130_fd_sc_hd__fill_1
X_5170_ _5170_/A _5170_/B _5170_/C VGND VGND VPWR VPWR _5250_/A sky130_fd_sc_hd__and3_4
XFILLER_68_246 VGND VGND VPWR VPWR sky130_fd_sc_hd__decap_3
X_4121_ _4662_/B _4362_/B _3648_/A _3647_/D VGND VGND VPWR VPWR _4122_/C sky130_fd_sc_hd__a22o_2
XFILLER_56_419 VGND VGND VPWR VPWR sky130_fd_sc_hd__fill_1
X_4052_ _4055_/B _4072_/A _4055_/A VGND VGND VPWR VPWR _4057_/A sky130_fd_sc_hd__a21o_2
XFILLER_96_577 VGND VGND VPWR VPWR sky130_fd_sc_hd__fill_1
XFILLER_83_249 VGND VGND VPWR VPWR sky130_fd_sc_hd__decap_3
Xinput4 A[12] VGND VGND VPWR VPWR input4/X sky130_fd_sc_hd__clkbuf_2
XTAP_TAPCELL_ROW_39_628 VGND VPWR sky130_fd_sc_hd__tapvpwrvgnd_1
XFILLER_76_290 VGND VGND VPWR VPWR sky130_fd_sc_hd__fill_1
XFILLER_24_305 VGND VGND VPWR VPWR sky130_fd_sc_hd__decap_3
XFILLER_36_187 VGND VGND VPWR VPWR sky130_fd_sc_hd__fill_2
XFILLER_64_474 VGND VGND VPWR VPWR sky130_fd_sc_hd__fill_2
XFILLER_17_390 VGND VGND VPWR VPWR sky130_fd_sc_hd__fill_2
XFILLER_24_338 VGND VGND VPWR VPWR sky130_fd_sc_hd__decap_3
XFILLER_51_113 VGND VGND VPWR VPWR sky130_fd_sc_hd__fill_1
X_4954_ _4952_/B _5023_/B _4950_/X VGND VGND VPWR VPWR _4956_/C sky130_fd_sc_hd__a21o_2
XFILLER_32_360 VGND VGND VPWR VPWR sky130_fd_sc_hd__decap_3
XFILLER_51_157 VGND VGND VPWR VPWR sky130_fd_sc_hd__fill_1
X_3905_ _3796_/A _3795_/B _3795_/A VGND VGND VPWR VPWR _3907_/B sky130_fd_sc_hd__o21ba_2
XFILLER_32_371 VGND VGND VPWR VPWR sky130_fd_sc_hd__decap_3
X_4885_ _4882_/X _4884_/Y _4842_/Y _4848_/B VGND VGND VPWR VPWR _4889_/A sky130_fd_sc_hd__o211ai_2
X_6624_ _6638_/A _6620_/X _6623_/X _6393_/Y VGND VGND VPWR VPWR _6624_/X sky130_fd_sc_hd__a211o_2
X_3836_ _3834_/X _3836_/B VGND VGND VPWR VPWR _3838_/A sky130_fd_sc_hd__and2b_2
X_6555_ _6391_/Y _6829_/B _6830_/B _6498_/A VGND VGND VPWR VPWR _6561_/B sky130_fd_sc_hd__o22a_2
X_3767_ _3767_/A _3767_/B VGND VGND VPWR VPWR _3778_/A sky130_fd_sc_hd__nor2_2
X_5506_ _5413_/X _5474_/Y _5485_/Y _5504_/Y VGND VGND VPWR VPWR _5508_/B sky130_fd_sc_hd__o211a_2
XFILLER_10_36 VGND VGND VPWR VPWR sky130_fd_sc_hd__decap_3
X_6486_ _6506_/A _6485_/B _6757_/C VGND VGND VPWR VPWR _6486_/X sky130_fd_sc_hd__o21a_2
X_3698_ _3696_/X _3698_/B VGND VGND VPWR VPWR _3699_/B sky130_fd_sc_hd__and2b_2
X_5437_ _5437_/A _5437_/B _5437_/C VGND VGND VPWR VPWR _5464_/B sky130_fd_sc_hd__nand3_4
XFILLER_86_18 VGND VGND VPWR VPWR sky130_fd_sc_hd__decap_3
XFILLER_86_29 VGND VGND VPWR VPWR sky130_fd_sc_hd__decap_3
XFILLER_87_522 VGND VGND VPWR VPWR sky130_fd_sc_hd__decap_3
X_5368_ _6212_/A _6569_/B VGND VGND VPWR VPWR _5370_/B sky130_fd_sc_hd__nor2_2
XFILLER_59_246 VGND VGND VPWR VPWR sky130_fd_sc_hd__decap_3
XFILLER_87_555 VGND VGND VPWR VPWR sky130_fd_sc_hd__decap_3
X_5299_ _5341_/B _5322_/B VGND VGND VPWR VPWR _5303_/A sky130_fd_sc_hd__nand2_2
X_4319_ _4201_/B _4205_/X _4315_/X _4327_/A VGND VGND VPWR VPWR _4319_/X sky130_fd_sc_hd__o211a_2
XFILLER_99_393 VGND VGND VPWR VPWR sky130_fd_sc_hd__decap_3
XFILLER_19_45 VGND VGND VPWR VPWR sky130_fd_sc_hd__decap_3
XFILLER_47_408 VGND VGND VPWR VPWR sky130_fd_sc_hd__decap_3
XFILLER_59_268 VGND VGND VPWR VPWR sky130_fd_sc_hd__decap_3
XFILLER_87_588 VGND VGND VPWR VPWR sky130_fd_sc_hd__decap_3
XFILLER_27_110 VGND VGND VPWR VPWR sky130_fd_sc_hd__fill_2
XFILLER_67_290 VGND VGND VPWR VPWR sky130_fd_sc_hd__decap_3
XFILLER_74_249 VGND VGND VPWR VPWR sky130_fd_sc_hd__decap_3
XTAP_TAPCELL_ROW_2_242 VGND VPWR sky130_fd_sc_hd__tapvpwrvgnd_1
XFILLER_15_327 VGND VGND VPWR VPWR sky130_fd_sc_hd__decap_3
XFILLER_15_349 VGND VGND VPWR VPWR sky130_fd_sc_hd__decap_3
XFILLER_35_44 VGND VGND VPWR VPWR sky130_fd_sc_hd__decap_3
XFILLER_42_124 VGND VGND VPWR VPWR sky130_fd_sc_hd__decap_3
XFILLER_82_293 VGND VGND VPWR VPWR sky130_fd_sc_hd__decap_3
XFILLER_35_77 VGND VGND VPWR VPWR sky130_fd_sc_hd__decap_3
XFILLER_11_500 VGND VGND VPWR VPWR sky130_fd_sc_hd__decap_3
XFILLER_11_511 VGND VGND VPWR VPWR sky130_fd_sc_hd__decap_3
XFILLER_23_393 VGND VGND VPWR VPWR sky130_fd_sc_hd__fill_2
Xwire413 _6148_/B VGND VGND VPWR VPWR _6024_/A sky130_fd_sc_hd__buf_4
XFILLER_51_65 VGND VGND VPWR VPWR sky130_fd_sc_hd__fill_1
XFILLER_7_526 VGND VGND VPWR VPWR sky130_fd_sc_hd__decap_3
XFILLER_51_98 VGND VGND VPWR VPWR sky130_fd_sc_hd__fill_2
XFILLER_7_559 VGND VGND VPWR VPWR sky130_fd_sc_hd__fill_1
Xload_slew418 _4694_/C VGND VGND VPWR VPWR _6102_/B sky130_fd_sc_hd__buf_2
XFILLER_97_308 VGND VGND VPWR VPWR sky130_fd_sc_hd__decap_3
XFILLER_78_522 VGND VGND VPWR VPWR sky130_fd_sc_hd__fill_2
XFILLER_78_533 VGND VGND VPWR VPWR sky130_fd_sc_hd__fill_2
XFILLER_93_514 VGND VGND VPWR VPWR sky130_fd_sc_hd__decap_3
XFILLER_76_73 VGND VGND VPWR VPWR sky130_fd_sc_hd__decap_3
XTAP_TAPCELL_ROW_88_1139 VGND VPWR sky130_fd_sc_hd__tapvpwrvgnd_1
XFILLER_93_569 VGND VGND VPWR VPWR sky130_fd_sc_hd__decap_3
XFILLER_73_271 VGND VGND VPWR VPWR sky130_fd_sc_hd__decap_3
XFILLER_33_124 VGND VGND VPWR VPWR sky130_fd_sc_hd__decap_3
XFILLER_61_433 VGND VGND VPWR VPWR sky130_fd_sc_hd__decap_3
XFILLER_73_293 VGND VGND VPWR VPWR sky130_fd_sc_hd__decap_3
XFILLER_21_319 VGND VGND VPWR VPWR sky130_fd_sc_hd__decap_3
XFILLER_61_455 VGND VGND VPWR VPWR sky130_fd_sc_hd__decap_3
XTAP_TAPCELL_ROW_72_973 VGND VPWR sky130_fd_sc_hd__tapvpwrvgnd_1
XTAP_TAPCELL_ROW_44_675 VGND VPWR sky130_fd_sc_hd__tapvpwrvgnd_1
XFILLER_14_371 VGND VGND VPWR VPWR sky130_fd_sc_hd__decap_3
XTAP_TAPCELL_ROW_16_388 VGND VPWR sky130_fd_sc_hd__tapvpwrvgnd_1
X_4670_ _4669_/B _4669_/C _4669_/A VGND VGND VPWR VPWR _4672_/B sky130_fd_sc_hd__o21bai_2
X_3621_ _3831_/A _3621_/B VGND VGND VPWR VPWR _3624_/A sky130_fd_sc_hd__nor2_2
XTAP_TAPCELL_ROW_99_1257 VGND VPWR sky130_fd_sc_hd__tapvpwrvgnd_1
X_6340_ _6348_/A _6506_/B _6337_/Y _6334_/X VGND VGND VPWR VPWR _6340_/X sky130_fd_sc_hd__o211a_2
X_3552_ _3960_/A _3552_/B _3553_/A _3552_/D VGND VGND VPWR VPWR _3575_/A sky130_fd_sc_hd__nand4_2
XFILLER_6_592 VGND VGND VPWR VPWR sky130_fd_sc_hd__decap_3
X_6271_ _6271_/A VGND VGND VPWR VPWR _6874_/C sky130_fd_sc_hd__inv_2
X_3483_ _5300_/B VGND VGND VPWR VPWR _5019_/A sky130_fd_sc_hd__inv_2
X_5222_ _5222_/A _5222_/B VGND VGND VPWR VPWR _5234_/A sky130_fd_sc_hd__xnor2_2
XFILLER_69_544 VGND VGND VPWR VPWR sky130_fd_sc_hd__decap_3
X_5153_ _5268_/C _5151_/C _5266_/D _5151_/B VGND VGND VPWR VPWR _5154_/B sky130_fd_sc_hd__a22o_2
XFILLER_29_419 VGND VGND VPWR VPWR sky130_fd_sc_hd__decap_3
XFILLER_69_566 VGND VGND VPWR VPWR sky130_fd_sc_hd__decap_3
X_4104_ _4209_/A _4209_/B _4101_/X VGND VGND VPWR VPWR _4106_/C sky130_fd_sc_hd__a21o_2
XFILLER_96_363 VGND VGND VPWR VPWR sky130_fd_sc_hd__fill_1
XFILLER_56_227 VGND VGND VPWR VPWR sky130_fd_sc_hd__fill_2
X_5084_ _5084_/A _5084_/B _5084_/C VGND VGND VPWR VPWR _5084_/X sky130_fd_sc_hd__and3_4
XFILLER_49_290 VGND VGND VPWR VPWR sky130_fd_sc_hd__decap_3
X_4035_ _4035_/A _4035_/B VGND VGND VPWR VPWR _4036_/C sky130_fd_sc_hd__xnor2_2
XFILLER_71_219 VGND VGND VPWR VPWR sky130_fd_sc_hd__decap_3
XFILLER_64_271 VGND VGND VPWR VPWR sky130_fd_sc_hd__decap_3
XFILLER_64_293 VGND VGND VPWR VPWR sky130_fd_sc_hd__fill_1
X_5986_ _5984_/X _5986_/B VGND VGND VPWR VPWR _5987_/B sky130_fd_sc_hd__and2b_2
XFILLER_12_319 VGND VGND VPWR VPWR sky130_fd_sc_hd__decap_3
X_4937_ _4933_/Y _5016_/A _4710_/Y _4923_/X VGND VGND VPWR VPWR _4993_/B sky130_fd_sc_hd__a211oi_2
X_4868_ _4868_/A _4868_/B _4868_/C VGND VGND VPWR VPWR _4870_/B sky130_fd_sc_hd__nand3_2
X_6607_ _6526_/B _6606_/X _6783_/S VGND VGND VPWR VPWR _6607_/X sky130_fd_sc_hd__mux2_1
X_3819_ _3819_/A _3819_/B VGND VGND VPWR VPWR _3821_/C sky130_fd_sc_hd__xnor2_2
X_4799_ _6248_/B _4985_/B VGND VGND VPWR VPWR _4977_/A sky130_fd_sc_hd__nand2_2
XFILLER_21_57 VGND VGND VPWR VPWR sky130_fd_sc_hd__decap_3
X_6538_ _6393_/Y _6524_/X _6537_/X _6586_/A VGND VGND VPWR VPWR _6539_/B sky130_fd_sc_hd__a22o_2
XTAP_TAPCELL_ROW_76_1010 VGND VPWR sky130_fd_sc_hd__tapvpwrvgnd_1
X_6469_ _6224_/A _6605_/A2 _6506_/B _6381_/D _6468_/X VGND VGND VPWR VPWR _6472_/B
+ sky130_fd_sc_hd__o221ai_2
XFILLER_79_308 VGND VGND VPWR VPWR sky130_fd_sc_hd__fill_2
XFILLER_75_525 VGND VGND VPWR VPWR sky130_fd_sc_hd__decap_3
XFILLER_87_385 VGND VGND VPWR VPWR sky130_fd_sc_hd__decap_3
XFILLER_87_396 VGND VGND VPWR VPWR sky130_fd_sc_hd__decap_3
XFILLER_28_463 VGND VGND VPWR VPWR sky130_fd_sc_hd__decap_3
XFILLER_55_260 VGND VGND VPWR VPWR sky130_fd_sc_hd__fill_1
XFILLER_90_517 VGND VGND VPWR VPWR sky130_fd_sc_hd__fill_1
XFILLER_90_539 VGND VGND VPWR VPWR sky130_fd_sc_hd__decap_3
XFILLER_15_102 VGND VGND VPWR VPWR sky130_fd_sc_hd__decap_3
XFILLER_43_411 VGND VGND VPWR VPWR sky130_fd_sc_hd__decap_3
XFILLER_70_230 VGND VGND VPWR VPWR sky130_fd_sc_hd__decap_3
XFILLER_62_42 VGND VGND VPWR VPWR sky130_fd_sc_hd__decap_3
XFILLER_70_274 VGND VGND VPWR VPWR sky130_fd_sc_hd__fill_1
XFILLER_70_296 VGND VGND VPWR VPWR sky130_fd_sc_hd__decap_3
XFILLER_11_330 VGND VGND VPWR VPWR sky130_fd_sc_hd__decap_3
XTAP_TAPCELL_ROW_41_645 VGND VPWR sky130_fd_sc_hd__tapvpwrvgnd_1
XTAP_TAPCELL_ROW_13_358 VGND VPWR sky130_fd_sc_hd__tapvpwrvgnd_1
XFILLER_7_15 VGND VGND VPWR VPWR sky130_fd_sc_hd__decap_3
XFILLER_7_26 VGND VGND VPWR VPWR sky130_fd_sc_hd__decap_3
XFILLER_7_323 VGND VGND VPWR VPWR sky130_fd_sc_hd__decap_3
XFILLER_7_356 VGND VGND VPWR VPWR sky130_fd_sc_hd__decap_3
Xwire265 _6118_/B VGND VGND VPWR VPWR _6498_/A sky130_fd_sc_hd__clkbuf_4
XFILLER_7_389 VGND VGND VPWR VPWR sky130_fd_sc_hd__decap_3
XFILLER_3_573 VGND VGND VPWR VPWR sky130_fd_sc_hd__decap_3
XFILLER_87_50 VGND VGND VPWR VPWR sky130_fd_sc_hd__fill_1
XFILLER_23_6 VGND VGND VPWR VPWR sky130_fd_sc_hd__decap_3
XFILLER_66_503 VGND VGND VPWR VPWR sky130_fd_sc_hd__decap_3
XFILLER_78_330 VGND VGND VPWR VPWR sky130_fd_sc_hd__decap_3
XFILLER_78_352 VGND VGND VPWR VPWR sky130_fd_sc_hd__decap_3
XFILLER_66_536 VGND VGND VPWR VPWR sky130_fd_sc_hd__fill_1
XFILLER_93_311 VGND VGND VPWR VPWR sky130_fd_sc_hd__fill_2
XFILLER_19_441 VGND VGND VPWR VPWR sky130_fd_sc_hd__decap_3
XFILLER_93_333 VGND VGND VPWR VPWR sky130_fd_sc_hd__decap_3
XFILLER_93_355 VGND VGND VPWR VPWR sky130_fd_sc_hd__decap_3
XTAP_TAPCELL_ROW_49_734 VGND VPWR sky130_fd_sc_hd__tapvpwrvgnd_1
XFILLER_46_260 VGND VGND VPWR VPWR sky130_fd_sc_hd__fill_1
XFILLER_53_219 VGND VGND VPWR VPWR sky130_fd_sc_hd__decap_3
XFILLER_34_411 VGND VGND VPWR VPWR sky130_fd_sc_hd__decap_3
XFILLER_93_399 VGND VGND VPWR VPWR sky130_fd_sc_hd__decap_3
XFILLER_34_444 VGND VGND VPWR VPWR sky130_fd_sc_hd__decap_3
XFILLER_34_477 VGND VGND VPWR VPWR sky130_fd_sc_hd__decap_3
X_5840_ _5840_/A _5840_/B _5840_/C VGND VGND VPWR VPWR _5840_/X sky130_fd_sc_hd__or3_4
XFILLER_61_296 VGND VGND VPWR VPWR sky130_fd_sc_hd__decap_3
X_5771_ _5772_/A _5772_/B VGND VGND VPWR VPWR _5771_/X sky130_fd_sc_hd__and2_2
X_4722_ _4722_/A _4722_/B _4722_/C VGND VGND VPWR VPWR _4722_/X sky130_fd_sc_hd__and3_2
Xinput40 B[16] VGND VGND VPWR VPWR _3923_/A sky130_fd_sc_hd__clkbuf_4
X_4653_ _4653_/A _4653_/B VGND VGND VPWR VPWR _4689_/B sky130_fd_sc_hd__nor2_2
Xinput62 B[7] VGND VGND VPWR VPWR input62/X sky130_fd_sc_hd__buf_6
Xinput51 B[26] VGND VGND VPWR VPWR input51/X sky130_fd_sc_hd__clkdlybuf4s25_1
X_4584_ _4586_/B _4586_/A VGND VGND VPWR VPWR _4584_/X sky130_fd_sc_hd__and2b_2
X_3604_ _5983_/D _6024_/A _3588_/C _3588_/D VGND VGND VPWR VPWR _3605_/C sky130_fd_sc_hd__a22o_2
X_6323_ _3655_/A _3628_/C _6410_/S VGND VGND VPWR VPWR _6323_/X sky130_fd_sc_hd__mux2_1
X_3535_ _3990_/A _3955_/A _3961_/C _3961_/D VGND VGND VPWR VPWR _3537_/A sky130_fd_sc_hd__and4_2
X_6254_ _6090_/A _6254_/B VGND VGND VPWR VPWR _6258_/A sky130_fd_sc_hd__and2b_2
X_5205_ _5139_/A _5139_/C _5139_/B VGND VGND VPWR VPWR _5206_/B sky130_fd_sc_hd__a21oi_2
X_6185_ _6187_/A _6187_/B VGND VGND VPWR VPWR _6902_/A sky130_fd_sc_hd__and2_2
XFILLER_69_374 VGND VGND VPWR VPWR sky130_fd_sc_hd__decap_3
XFILLER_84_322 VGND VGND VPWR VPWR sky130_fd_sc_hd__decap_3
X_5136_ _5313_/A _5211_/A _5311_/C _5311_/D VGND VGND VPWR VPWR _5139_/A sky130_fd_sc_hd__nand4_2
XFILLER_57_569 VGND VGND VPWR VPWR sky130_fd_sc_hd__decap_3
X_5067_ _5151_/B _5152_/A _5151_/C _5266_/D VGND VGND VPWR VPWR _5067_/X sky130_fd_sc_hd__and4_2
XFILLER_44_208 VGND VGND VPWR VPWR sky130_fd_sc_hd__decap_3
XFILLER_72_517 VGND VGND VPWR VPWR sky130_fd_sc_hd__fill_2
XFILLER_84_377 VGND VGND VPWR VPWR sky130_fd_sc_hd__decap_3
X_4018_ _4018_/A _4018_/B VGND VGND VPWR VPWR _4020_/A sky130_fd_sc_hd__nor2_2
XFILLER_65_591 VGND VGND VPWR VPWR sky130_fd_sc_hd__decap_3
XFILLER_16_79 VGND VGND VPWR VPWR sky130_fd_sc_hd__decap_3
XFILLER_25_499 VGND VGND VPWR VPWR sky130_fd_sc_hd__decap_3
XFILLER_80_583 VGND VGND VPWR VPWR sky130_fd_sc_hd__decap_3
X_5969_ _5969_/A _5969_/B VGND VGND VPWR VPWR _5970_/B sky130_fd_sc_hd__xnor2_2
XFILLER_12_138 VGND VGND VPWR VPWR sky130_fd_sc_hd__fill_2
XFILLER_32_12 VGND VGND VPWR VPWR sky130_fd_sc_hd__fill_1
XFILLER_40_447 VGND VGND VPWR VPWR sky130_fd_sc_hd__decap_3
XTAP_TAPCELL_ROW_82_1080 VGND VPWR sky130_fd_sc_hd__tapvpwrvgnd_1
XFILLER_20_182 VGND VGND VPWR VPWR sky130_fd_sc_hd__decap_3
XTAP_TAPCELL_ROW_10_317 VGND VPWR sky130_fd_sc_hd__tapvpwrvgnd_1
XFILLER_4_326 VGND VGND VPWR VPWR sky130_fd_sc_hd__decap_3
XFILLER_0_521 VGND VGND VPWR VPWR sky130_fd_sc_hd__decap_3
XFILLER_79_127 VGND VGND VPWR VPWR sky130_fd_sc_hd__decap_3
XFILLER_0_554 VGND VGND VPWR VPWR sky130_fd_sc_hd__decap_3
XFILLER_79_149 VGND VGND VPWR VPWR sky130_fd_sc_hd__fill_1
XFILLER_0_576 VGND VGND VPWR VPWR sky130_fd_sc_hd__decap_3
XFILLER_75_311 VGND VGND VPWR VPWR sky130_fd_sc_hd__decap_3
XFILLER_75_377 VGND VGND VPWR VPWR sky130_fd_sc_hd__decap_3
XTAP_TAPCELL_ROW_85_1109 VGND VPWR sky130_fd_sc_hd__tapvpwrvgnd_1
XTAP_TAPCELL_ROW_46_704 VGND VPWR sky130_fd_sc_hd__tapvpwrvgnd_1
XTAP_TAPCELL_ROW_18_406 VGND VPWR sky130_fd_sc_hd__tapvpwrvgnd_1
XFILLER_16_411 VGND VGND VPWR VPWR sky130_fd_sc_hd__decap_3
XFILLER_90_325 VGND VGND VPWR VPWR sky130_fd_sc_hd__decap_3
XFILLER_71_550 VGND VGND VPWR VPWR sky130_fd_sc_hd__decap_3
XFILLER_71_561 VGND VGND VPWR VPWR sky130_fd_sc_hd__decap_3
XFILLER_73_52 VGND VGND VPWR VPWR sky130_fd_sc_hd__decap_3
XFILLER_73_63 VGND VGND VPWR VPWR sky130_fd_sc_hd__decap_3
XFILLER_16_477 VGND VGND VPWR VPWR sky130_fd_sc_hd__decap_3
XFILLER_43_274 VGND VGND VPWR VPWR sky130_fd_sc_hd__fill_1
XFILLER_71_594 VGND VGND VPWR VPWR sky130_fd_sc_hd__decap_3
XTAP_TAPCELL_ROW_54_781 VGND VPWR sky130_fd_sc_hd__tapvpwrvgnd_1
XFILLER_31_458 VGND VGND VPWR VPWR sky130_fd_sc_hd__decap_3
XTAP_TAPCELL_ROW_26_494 VGND VPWR sky130_fd_sc_hd__tapvpwrvgnd_1
XFILLER_7_175 VGND VGND VPWR VPWR sky130_fd_sc_hd__decap_3
XTAP_TAPCELL_ROW_96_1227 VGND VPWR sky130_fd_sc_hd__tapvpwrvgnd_1
XFILLER_98_403 VGND VGND VPWR VPWR sky130_fd_sc_hd__fill_2
XFILLER_98_447 VGND VGND VPWR VPWR sky130_fd_sc_hd__decap_3
XFILLER_21_3 VGND VGND VPWR VPWR sky130_fd_sc_hd__decap_3
XFILLER_39_514 VGND VGND VPWR VPWR sky130_fd_sc_hd__decap_3
XFILLER_66_300 VGND VGND VPWR VPWR sky130_fd_sc_hd__decap_3
XFILLER_39_536 VGND VGND VPWR VPWR sky130_fd_sc_hd__decap_3
XFILLER_66_333 VGND VGND VPWR VPWR sky130_fd_sc_hd__decap_3
XFILLER_54_528 VGND VGND VPWR VPWR sky130_fd_sc_hd__decap_3
XFILLER_66_377 VGND VGND VPWR VPWR sky130_fd_sc_hd__decap_3
XFILLER_81_314 VGND VGND VPWR VPWR sky130_fd_sc_hd__decap_3
XFILLER_54_539 VGND VGND VPWR VPWR sky130_fd_sc_hd__decap_3
XFILLER_93_196 VGND VGND VPWR VPWR sky130_fd_sc_hd__decap_3
X_6941_ _6074_/A _6978_/A2 _6979_/B1 _6348_/C _6940_/Y VGND VGND VPWR VPWR _6941_/X
+ sky130_fd_sc_hd__o221a_2
XFILLER_62_561 VGND VGND VPWR VPWR sky130_fd_sc_hd__fill_1
X_6872_ _6873_/A2 _5261_/Y _5916_/B VGND VGND VPWR VPWR _6872_/Y sky130_fd_sc_hd__a21oi_4
XFILLER_22_403 VGND VGND VPWR VPWR sky130_fd_sc_hd__fill_1
XFILLER_34_285 VGND VGND VPWR VPWR sky130_fd_sc_hd__decap_3
XFILLER_62_583 VGND VGND VPWR VPWR sky130_fd_sc_hd__decap_3
X_5823_ _5248_/B _5248_/A _5248_/C VGND VGND VPWR VPWR _5831_/B sky130_fd_sc_hd__a21oi_2
XFILLER_22_469 VGND VGND VPWR VPWR sky130_fd_sc_hd__decap_3
X_5754_ _5752_/X _5754_/B VGND VGND VPWR VPWR _6597_/A sky130_fd_sc_hd__and2b_2
X_5685_ _5685_/A _5685_/B VGND VGND VPWR VPWR _5690_/B sky130_fd_sc_hd__xor2_2
X_4705_ _6109_/A _6109_/B VGND VGND VPWR VPWR _4705_/Y sky130_fd_sc_hd__nand2_2
X_4636_ _4637_/A _4635_/Y _4636_/C _5018_/B VGND VGND VPWR VPWR _4648_/A sky130_fd_sc_hd__and4bb_2
X_6306_ wire507/A _4010_/B _3544_/A wire557/A _6410_/S _6893_/S VGND VGND VPWR VPWR
+ _6306_/X sky130_fd_sc_hd__mux4_2
X_4567_ _4567_/A _4567_/B VGND VGND VPWR VPWR _6935_/A sky130_fd_sc_hd__xnor2_2
XFILLER_89_436 VGND VGND VPWR VPWR sky130_fd_sc_hd__decap_3
X_4498_ _4469_/A _5885_/A wire116/X _4454_/X VGND VGND VPWR VPWR _4558_/D sky130_fd_sc_hd__a211oi_2
X_3518_ _3872_/A _6893_/S _3518_/C VGND VGND VPWR VPWR _3880_/B sky130_fd_sc_hd__and3_2
X_6237_ _6383_/D _6235_/Y _6236_/Y VGND VGND VPWR VPWR _6635_/B sky130_fd_sc_hd__o21a_2
X_6168_ _6168_/A _6168_/B VGND VGND VPWR VPWR _6168_/X sky130_fd_sc_hd__and2_2
XFILLER_69_193 VGND VGND VPWR VPWR sky130_fd_sc_hd__decap_3
X_5119_ _5035_/A _5035_/C _5035_/B VGND VGND VPWR VPWR _5120_/C sky130_fd_sc_hd__o21ai_2
XFILLER_94_29 VGND VGND VPWR VPWR sky130_fd_sc_hd__fill_1
XFILLER_17_208 VGND VGND VPWR VPWR sky130_fd_sc_hd__decap_3
XFILLER_45_517 VGND VGND VPWR VPWR sky130_fd_sc_hd__decap_3
XFILLER_72_303 VGND VGND VPWR VPWR sky130_fd_sc_hd__decap_3
XFILLER_84_141 VGND VGND VPWR VPWR sky130_fd_sc_hd__decap_3
X_6099_ _6100_/A _6100_/B VGND VGND VPWR VPWR _6758_/A sky130_fd_sc_hd__nand2_2
XFILLER_38_580 VGND VGND VPWR VPWR sky130_fd_sc_hd__fill_1
XFILLER_57_388 VGND VGND VPWR VPWR sky130_fd_sc_hd__decap_3
XFILLER_72_325 VGND VGND VPWR VPWR sky130_fd_sc_hd__decap_3
XFILLER_84_185 VGND VGND VPWR VPWR sky130_fd_sc_hd__decap_3
XFILLER_13_414 VGND VGND VPWR VPWR sky130_fd_sc_hd__decap_3
XFILLER_13_425 VGND VGND VPWR VPWR sky130_fd_sc_hd__decap_3
XFILLER_53_561 VGND VGND VPWR VPWR sky130_fd_sc_hd__decap_3
XFILLER_13_447 VGND VGND VPWR VPWR sky130_fd_sc_hd__fill_1
XFILLER_13_458 VGND VGND VPWR VPWR sky130_fd_sc_hd__decap_3
XFILLER_40_222 VGND VGND VPWR VPWR sky130_fd_sc_hd__decap_3
XFILLER_80_380 VGND VGND VPWR VPWR sky130_fd_sc_hd__decap_3
XFILLER_9_407 VGND VGND VPWR VPWR sky130_fd_sc_hd__decap_3
XFILLER_40_277 VGND VGND VPWR VPWR sky130_fd_sc_hd__decap_3
XFILLER_43_77 VGND VGND VPWR VPWR sky130_fd_sc_hd__decap_3
XTAP_TAPCELL_ROW_51_751 VGND VPWR sky130_fd_sc_hd__tapvpwrvgnd_1
XFILLER_21_491 VGND VGND VPWR VPWR sky130_fd_sc_hd__decap_3
Xrebuffer740 _5144_/Y VGND VGND VPWR VPWR _5218_/C1 sky130_fd_sc_hd__buf_2
Xrebuffer751 fanout291/X VGND VGND VPWR VPWR _6313_/B sky130_fd_sc_hd__buf_2
Xrebuffer762 _5525_/B VGND VGND VPWR VPWR _5504_/B sky130_fd_sc_hd__buf_2
XFILLER_4_134 VGND VGND VPWR VPWR sky130_fd_sc_hd__decap_3
XTAP_TAPCELL_ROW_91_1168 VGND VPWR sky130_fd_sc_hd__tapvpwrvgnd_1
XFILLER_0_340 VGND VGND VPWR VPWR sky130_fd_sc_hd__decap_3
XFILLER_0_384 VGND VGND VPWR VPWR sky130_fd_sc_hd__decap_3
XFILLER_88_480 VGND VGND VPWR VPWR sky130_fd_sc_hd__decap_3
XTAP_TAPCELL_ROW_59_840 VGND VPWR sky130_fd_sc_hd__tapvpwrvgnd_1
XFILLER_75_141 VGND VGND VPWR VPWR sky130_fd_sc_hd__decap_3
XFILLER_36_528 VGND VGND VPWR VPWR sky130_fd_sc_hd__decap_3
XFILLER_36_539 VGND VGND VPWR VPWR sky130_fd_sc_hd__decap_3
XFILLER_48_388 VGND VGND VPWR VPWR sky130_fd_sc_hd__decap_3
XFILLER_63_314 VGND VGND VPWR VPWR sky130_fd_sc_hd__decap_3
XFILLER_90_111 VGND VGND VPWR VPWR sky130_fd_sc_hd__decap_3
XFILLER_84_95 VGND VGND VPWR VPWR sky130_fd_sc_hd__decap_3
XFILLER_90_166 VGND VGND VPWR VPWR sky130_fd_sc_hd__fill_2
XFILLER_31_244 VGND VGND VPWR VPWR sky130_fd_sc_hd__decap_3
XFILLER_12_480 VGND VGND VPWR VPWR sky130_fd_sc_hd__decap_3
XTAP_TAPCELL_ROW_100_1275 VGND VPWR sky130_fd_sc_hd__tapvpwrvgnd_1
XTAP_TAPCELL_ROW_100_1264 VGND VPWR sky130_fd_sc_hd__tapvpwrvgnd_1
X_5470_ _5288_/A _5289_/Y _5469_/Y _5468_/X VGND VGND VPWR VPWR _5470_/Y sky130_fd_sc_hd__a211oi_4
XFILLER_69_3 VGND VGND VPWR VPWR sky130_fd_sc_hd__decap_3
X_4421_ _6254_/B _4420_/C _4538_/D _6085_/B VGND VGND VPWR VPWR _4421_/Y sky130_fd_sc_hd__a22oi_2
X_4352_ _4350_/A _4350_/C _4350_/B VGND VGND VPWR VPWR _4352_/Y sky130_fd_sc_hd__a21oi_4
Xfanout419 _6019_/A VGND VGND VPWR VPWR _4607_/C sky130_fd_sc_hd__clkdlybuf4s25_1
X_4283_ _4283_/A _4405_/A VGND VGND VPWR VPWR _4285_/B sky130_fd_sc_hd__nand2_2
XFILLER_39_300 VGND VGND VPWR VPWR sky130_fd_sc_hd__decap_3
XFILLER_86_439 VGND VGND VPWR VPWR sky130_fd_sc_hd__decap_3
X_6022_ _6020_/X _6022_/B VGND VGND VPWR VPWR _6023_/B sky130_fd_sc_hd__and2b_2
XFILLER_98_288 VGND VGND VPWR VPWR sky130_fd_sc_hd__decap_3
XFILLER_98_277 VGND VGND VPWR VPWR sky130_fd_sc_hd__fill_1
XFILLER_79_491 VGND VGND VPWR VPWR sky130_fd_sc_hd__decap_3
XFILLER_39_377 VGND VGND VPWR VPWR sky130_fd_sc_hd__decap_3
XFILLER_66_130 VGND VGND VPWR VPWR sky130_fd_sc_hd__decap_3
XFILLER_66_141 VGND VGND VPWR VPWR sky130_fd_sc_hd__decap_3
XFILLER_94_472 VGND VGND VPWR VPWR sky130_fd_sc_hd__decap_3
XFILLER_66_174 VGND VGND VPWR VPWR sky130_fd_sc_hd__decap_3
XFILLER_81_111 VGND VGND VPWR VPWR sky130_fd_sc_hd__fill_1
XFILLER_81_122 VGND VGND VPWR VPWR sky130_fd_sc_hd__decap_3
XFILLER_94_483 VGND VGND VPWR VPWR sky130_fd_sc_hd__decap_3
X_6924_ _6310_/X _6321_/X _6924_/S VGND VGND VPWR VPWR _6924_/X sky130_fd_sc_hd__mux2_1
XFILLER_22_200 VGND VGND VPWR VPWR sky130_fd_sc_hd__fill_1
XFILLER_35_572 VGND VGND VPWR VPWR sky130_fd_sc_hd__decap_3
XTAP_TAPCELL_ROW_65_898 VGND VPWR sky130_fd_sc_hd__tapvpwrvgnd_1
XFILLER_22_211 VGND VGND VPWR VPWR sky130_fd_sc_hd__decap_3
XFILLER_62_391 VGND VGND VPWR VPWR sky130_fd_sc_hd__decap_3
XFILLER_81_199 VGND VGND VPWR VPWR sky130_fd_sc_hd__decap_3
X_6855_ _6168_/B _6971_/B _6842_/Y _6854_/X VGND VGND VPWR VPWR _6992_/A sky130_fd_sc_hd__a31o_4
X_6786_ _6161_/B _6778_/X _6779_/X _6785_/X VGND VGND VPWR VPWR _6786_/X sky130_fd_sc_hd__o211a_2
X_5806_ _5806_/A _5806_/B VGND VGND VPWR VPWR _6562_/B sky130_fd_sc_hd__nand2_2
X_3998_ _4024_/A _6007_/A VGND VGND VPWR VPWR _6005_/S sky130_fd_sc_hd__or2_2
XFILLER_13_25 VGND VGND VPWR VPWR sky130_fd_sc_hd__fill_1
XFILLER_50_597 VGND VGND VPWR VPWR sky130_fd_sc_hd__fill_1
X_5737_ _5748_/B _5710_/C _5710_/A VGND VGND VPWR VPWR _5739_/D sky130_fd_sc_hd__a21o_2
XTAP_TAPCELL_ROW_20_423 VGND VPWR sky130_fd_sc_hd__tapvpwrvgnd_1
X_5668_ _5734_/A _5727_/B VGND VGND VPWR VPWR _5670_/B sky130_fd_sc_hd__nand2_2
X_5599_ _5599_/A _5599_/B VGND VGND VPWR VPWR _5600_/B sky130_fd_sc_hd__nor2_2
X_4619_ _4619_/A _4619_/B VGND VGND VPWR VPWR _4632_/B sky130_fd_sc_hd__nor2_2
XFILLER_89_200 VGND VGND VPWR VPWR sky130_fd_sc_hd__decap_3
XFILLER_89_255 VGND VGND VPWR VPWR sky130_fd_sc_hd__decap_3
XFILLER_49_119 VGND VGND VPWR VPWR sky130_fd_sc_hd__fill_2
XFILLER_77_417 VGND VGND VPWR VPWR sky130_fd_sc_hd__decap_3
XFILLER_77_439 VGND VGND VPWR VPWR sky130_fd_sc_hd__decap_3
XFILLER_89_277 VGND VGND VPWR VPWR sky130_fd_sc_hd__decap_3
XFILLER_89_299 VGND VGND VPWR VPWR sky130_fd_sc_hd__decap_3
XFILLER_18_506 VGND VGND VPWR VPWR sky130_fd_sc_hd__decap_3
XFILLER_57_141 VGND VGND VPWR VPWR sky130_fd_sc_hd__decap_3
XFILLER_85_461 VGND VGND VPWR VPWR sky130_fd_sc_hd__decap_3
XFILLER_92_409 VGND VGND VPWR VPWR sky130_fd_sc_hd__decap_3
XFILLER_45_314 VGND VGND VPWR VPWR sky130_fd_sc_hd__fill_2
XFILLER_57_196 VGND VGND VPWR VPWR sky130_fd_sc_hd__decap_3
XFILLER_72_111 VGND VGND VPWR VPWR sky130_fd_sc_hd__decap_3
XTAP_TAPCELL_ROW_56_810 VGND VPWR sky130_fd_sc_hd__tapvpwrvgnd_1
XTAP_TAPCELL_ROW_28_512 VGND VPWR sky130_fd_sc_hd__tapvpwrvgnd_1
XFILLER_54_32 VGND VGND VPWR VPWR sky130_fd_sc_hd__decap_3
XFILLER_72_144 VGND VGND VPWR VPWR sky130_fd_sc_hd__decap_3
XFILLER_26_572 VGND VGND VPWR VPWR sky130_fd_sc_hd__decap_3
XFILLER_54_65 VGND VGND VPWR VPWR sky130_fd_sc_hd__decap_3
XFILLER_72_177 VGND VGND VPWR VPWR sky130_fd_sc_hd__decap_3
XFILLER_41_542 VGND VGND VPWR VPWR sky130_fd_sc_hd__decap_3
XFILLER_53_380 VGND VGND VPWR VPWR sky130_fd_sc_hd__decap_3
XFILLER_60_339 VGND VGND VPWR VPWR sky130_fd_sc_hd__decap_3
XFILLER_13_255 VGND VGND VPWR VPWR sky130_fd_sc_hd__decap_3
XFILLER_70_53 VGND VGND VPWR VPWR sky130_fd_sc_hd__fill_2
XFILLER_5_432 VGND VGND VPWR VPWR sky130_fd_sc_hd__decap_3
XFILLER_5_476 VGND VGND VPWR VPWR sky130_fd_sc_hd__decap_3
XFILLER_5_498 VGND VGND VPWR VPWR sky130_fd_sc_hd__decap_3
XFILLER_68_406 VGND VGND VPWR VPWR sky130_fd_sc_hd__decap_3
XFILLER_95_225 VGND VGND VPWR VPWR sky130_fd_sc_hd__decap_3
XFILLER_76_450 VGND VGND VPWR VPWR sky130_fd_sc_hd__decap_3
XFILLER_83_409 VGND VGND VPWR VPWR sky130_fd_sc_hd__decap_3
XFILLER_95_269 VGND VGND VPWR VPWR sky130_fd_sc_hd__decap_3
XFILLER_24_509 VGND VGND VPWR VPWR sky130_fd_sc_hd__fill_2
XFILLER_36_347 VGND VGND VPWR VPWR sky130_fd_sc_hd__fill_2
XFILLER_63_122 VGND VGND VPWR VPWR sky130_fd_sc_hd__decap_3
XFILLER_91_442 VGND VGND VPWR VPWR sky130_fd_sc_hd__decap_3
XFILLER_17_572 VGND VGND VPWR VPWR sky130_fd_sc_hd__fill_1
XFILLER_51_306 VGND VGND VPWR VPWR sky130_fd_sc_hd__decap_3
XFILLER_91_497 VGND VGND VPWR VPWR sky130_fd_sc_hd__decap_3
X_4970_ _4970_/A _4970_/B _4970_/C VGND VGND VPWR VPWR _5045_/A sky130_fd_sc_hd__nand3_4
X_3921_ _6025_/B _6024_/A VGND VGND VPWR VPWR _3926_/A sky130_fd_sc_hd__nand2_2
XFILLER_32_575 VGND VGND VPWR VPWR sky130_fd_sc_hd__decap_3
X_6640_ _6574_/X _6639_/X _6783_/S VGND VGND VPWR VPWR _6640_/X sky130_fd_sc_hd__mux2_1
X_3852_ _6014_/D _3851_/B _6182_/B _5948_/A VGND VGND VPWR VPWR _3853_/B sky130_fd_sc_hd__a22oi_2
XTAP_TAPCELL_ROW_62_868 VGND VPWR sky130_fd_sc_hd__tapvpwrvgnd_1
X_6571_ _6625_/A _6570_/X _6568_/X VGND VGND VPWR VPWR _6571_/X sky130_fd_sc_hd__a21o_2
X_5522_ _5516_/X _5517_/Y _5372_/X _5374_/X VGND VGND VPWR VPWR _5522_/X sky130_fd_sc_hd__a211o_2
X_3783_ _4077_/B _4077_/C _4077_/A VGND VGND VPWR VPWR _4079_/A sky130_fd_sc_hd__a21o_2
XFILLER_8_281 VGND VGND VPWR VPWR sky130_fd_sc_hd__decap_3
X_5453_ _5453_/A _5453_/B VGND VGND VPWR VPWR _5455_/C sky130_fd_sc_hd__xnor2_2
X_5384_ _5382_/A _5382_/C _5382_/D _5382_/B VGND VGND VPWR VPWR _5385_/B sky130_fd_sc_hd__a22oi_2
X_4404_ _4282_/A _4407_/B _4283_/A _4282_/D VGND VGND VPWR VPWR _4405_/C sky130_fd_sc_hd__a22o_2
X_4335_ _4593_/A _4457_/D VGND VGND VPWR VPWR _4458_/A sky130_fd_sc_hd__nand2_2
XFILLER_86_203 VGND VGND VPWR VPWR sky130_fd_sc_hd__decap_3
Xfanout227 _6215_/B VGND VGND VPWR VPWR _4755_/C sky130_fd_sc_hd__buf_8
XFILLER_99_575 VGND VGND VPWR VPWR sky130_fd_sc_hd__decap_3
XFILLER_86_225 VGND VGND VPWR VPWR sky130_fd_sc_hd__decap_3
X_4266_ _4266_/A _4266_/B _4266_/C VGND VGND VPWR VPWR _4386_/A sky130_fd_sc_hd__or3_4
XFILLER_39_152 VGND VGND VPWR VPWR sky130_fd_sc_hd__decap_3
X_6005_ _6004_/B _6004_/Y _6005_/S VGND VGND VPWR VPWR _6010_/A sky130_fd_sc_hd__mux2_1
X_4197_ _4197_/A _4197_/B _4197_/C VGND VGND VPWR VPWR _4197_/Y sky130_fd_sc_hd__nor3_2
XFILLER_39_163 VGND VGND VPWR VPWR sky130_fd_sc_hd__decap_3
XPHY_EDGE_ROW_19_Left_120 VGND VGND VPWR VPWR sky130_fd_sc_hd__decap_3
XFILLER_54_144 VGND VGND VPWR VPWR sky130_fd_sc_hd__decap_3
XFILLER_82_453 VGND VGND VPWR VPWR sky130_fd_sc_hd__decap_3
XFILLER_94_291 VGND VGND VPWR VPWR sky130_fd_sc_hd__decap_3
XFILLER_91_19 VGND VGND VPWR VPWR sky130_fd_sc_hd__fill_1
XFILLER_23_520 VGND VGND VPWR VPWR sky130_fd_sc_hd__fill_1
XFILLER_24_24 VGND VGND VPWR VPWR sky130_fd_sc_hd__decap_3
XFILLER_35_391 VGND VGND VPWR VPWR sky130_fd_sc_hd__fill_1
X_6907_ _6921_/C _6907_/B VGND VGND VPWR VPWR _6907_/X sky130_fd_sc_hd__or2_4
XFILLER_23_564 VGND VGND VPWR VPWR sky130_fd_sc_hd__fill_1
X_6838_ _5876_/A _5876_/B _5264_/Y VGND VGND VPWR VPWR _6839_/C sky130_fd_sc_hd__a21o_4
XFILLER_50_383 VGND VGND VPWR VPWR sky130_fd_sc_hd__decap_3
XFILLER_10_236 VGND VGND VPWR VPWR sky130_fd_sc_hd__fill_1
X_6769_ _6930_/A _6769_/B _6769_/C VGND VGND VPWR VPWR _6769_/X sky130_fd_sc_hd__or3_2
XFILLER_2_446 VGND VGND VPWR VPWR sky130_fd_sc_hd__decap_3
XFILLER_77_225 VGND VGND VPWR VPWR sky130_fd_sc_hd__decap_3
XFILLER_77_236 VGND VGND VPWR VPWR sky130_fd_sc_hd__decap_3
XFILLER_77_269 VGND VGND VPWR VPWR sky130_fd_sc_hd__decap_3
XTAP_TAPCELL_ROW_5_273 VGND VPWR sky130_fd_sc_hd__tapvpwrvgnd_1
XFILLER_45_100 VGND VGND VPWR VPWR sky130_fd_sc_hd__decap_3
XFILLER_58_483 VGND VGND VPWR VPWR sky130_fd_sc_hd__decap_3
XFILLER_92_217 VGND VGND VPWR VPWR sky130_fd_sc_hd__decap_3
XFILLER_45_122 VGND VGND VPWR VPWR sky130_fd_sc_hd__decap_3
XFILLER_65_53 VGND VGND VPWR VPWR sky130_fd_sc_hd__decap_3
XFILLER_73_442 VGND VGND VPWR VPWR sky130_fd_sc_hd__decap_3
XFILLER_73_464 VGND VGND VPWR VPWR sky130_fd_sc_hd__decap_3
XFILLER_26_380 VGND VGND VPWR VPWR sky130_fd_sc_hd__decap_3
XFILLER_73_497 VGND VGND VPWR VPWR sky130_fd_sc_hd__decap_3
XFILLER_14_542 VGND VGND VPWR VPWR sky130_fd_sc_hd__decap_3
XFILLER_41_350 VGND VGND VPWR VPWR sky130_fd_sc_hd__decap_3
XFILLER_81_41 VGND VGND VPWR VPWR sky130_fd_sc_hd__fill_2
XFILLER_81_85 VGND VGND VPWR VPWR sky130_fd_sc_hd__decap_3
XFILLER_5_273 VGND VGND VPWR VPWR sky130_fd_sc_hd__decap_3
XFILLER_68_203 VGND VGND VPWR VPWR sky130_fd_sc_hd__decap_3
X_4120_ _4483_/A _4476_/B _4119_/B _4116_/X VGND VGND VPWR VPWR _4122_/B sky130_fd_sc_hd__a31o_2
XFILLER_1_490 VGND VGND VPWR VPWR sky130_fd_sc_hd__decap_3
X_4051_ _4051_/A _4051_/B _4051_/C VGND VGND VPWR VPWR _4072_/A sky130_fd_sc_hd__or3_2
XTAP_TAPCELL_ROW_67_916 VGND VPWR sky130_fd_sc_hd__tapvpwrvgnd_1
XFILLER_49_494 VGND VGND VPWR VPWR sky130_fd_sc_hd__decap_3
XFILLER_83_228 VGND VGND VPWR VPWR sky130_fd_sc_hd__decap_3
Xinput5 A[13] VGND VGND VPWR VPWR input5/X sky130_fd_sc_hd__clkbuf_2
XTAP_TAPCELL_ROW_39_629 VGND VPWR sky130_fd_sc_hd__tapvpwrvgnd_1
XFILLER_36_111 VGND VGND VPWR VPWR sky130_fd_sc_hd__fill_1
XFILLER_64_486 VGND VGND VPWR VPWR sky130_fd_sc_hd__decap_3
X_4953_ _4953_/A _4953_/B VGND VGND VPWR VPWR _5023_/B sky130_fd_sc_hd__xnor2_2
XFILLER_32_350 VGND VGND VPWR VPWR sky130_fd_sc_hd__decap_3
XFILLER_51_169 VGND VGND VPWR VPWR sky130_fd_sc_hd__decap_3
X_3904_ _3904_/A _3904_/B VGND VGND VPWR VPWR _3907_/A sky130_fd_sc_hd__xnor2_2
X_6623_ _6961_/A1 _6448_/Y _6622_/X _6765_/B VGND VGND VPWR VPWR _6623_/X sky130_fd_sc_hd__a22o_2
X_4884_ _4883_/A _4883_/C _4883_/B VGND VGND VPWR VPWR _4884_/Y sky130_fd_sc_hd__a21oi_2
X_3835_ _6019_/D _3941_/B _3834_/D _3941_/A VGND VGND VPWR VPWR _3836_/B sky130_fd_sc_hd__a22o_2
XFILLER_20_589 VGND VGND VPWR VPWR sky130_fd_sc_hd__fill_1
X_6554_ _6765_/B _6554_/B VGND VGND VPWR VPWR _6830_/B sky130_fd_sc_hd__nand2_2
X_3766_ _4176_/A _6893_/S _3528_/C VGND VGND VPWR VPWR _3767_/B sky130_fd_sc_hd__a21oi_2
X_6485_ _6506_/A _6485_/B VGND VGND VPWR VPWR _6485_/Y sky130_fd_sc_hd__nand2_2
X_5505_ _5485_/Y _5504_/Y _5413_/X _5474_/Y VGND VGND VPWR VPWR _5513_/A sky130_fd_sc_hd__a211oi_2
XFILLER_10_26 VGND VGND VPWR VPWR sky130_fd_sc_hd__fill_2
X_5436_ _5432_/X _5434_/Y _5377_/A _5377_/Y VGND VGND VPWR VPWR _5437_/C sky130_fd_sc_hd__o211ai_4
X_3697_ _6016_/D _3851_/B _5948_/A _6014_/D VGND VGND VPWR VPWR _3698_/B sky130_fd_sc_hd__a22o_2
X_5367_ _5367_/A _5367_/B _5367_/C VGND VGND VPWR VPWR _5370_/A sky130_fd_sc_hd__or3_2
XFILLER_59_214 VGND VGND VPWR VPWR sky130_fd_sc_hd__decap_3
XFILLER_59_225 VGND VGND VPWR VPWR sky130_fd_sc_hd__decap_3
XFILLER_87_534 VGND VGND VPWR VPWR sky130_fd_sc_hd__decap_3
X_5298_ _5298_/A _5298_/B VGND VGND VPWR VPWR _5417_/A sky130_fd_sc_hd__nor2_2
X_4318_ _4315_/X _4327_/A _4201_/B _4205_/X VGND VGND VPWR VPWR _4321_/A sky130_fd_sc_hd__a211oi_2
XFILLER_19_35 VGND VGND VPWR VPWR sky130_fd_sc_hd__decap_3
XFILLER_59_258 VGND VGND VPWR VPWR sky130_fd_sc_hd__fill_1
XFILLER_87_567 VGND VGND VPWR VPWR sky130_fd_sc_hd__decap_3
X_4249_ _4249_/A _4249_/B _4249_/C VGND VGND VPWR VPWR _4350_/A sky130_fd_sc_hd__or3_4
XFILLER_19_79 VGND VGND VPWR VPWR sky130_fd_sc_hd__decap_3
XFILLER_74_206 VGND VGND VPWR VPWR sky130_fd_sc_hd__decap_3
XFILLER_74_228 VGND VGND VPWR VPWR sky130_fd_sc_hd__decap_3
XFILLER_27_144 VGND VGND VPWR VPWR sky130_fd_sc_hd__decap_3
XFILLER_55_420 VGND VGND VPWR VPWR sky130_fd_sc_hd__decap_3
XTAP_TAPCELL_ROW_2_243 VGND VPWR sky130_fd_sc_hd__tapvpwrvgnd_1
XFILLER_70_412 VGND VGND VPWR VPWR sky130_fd_sc_hd__decap_3
XFILLER_82_250 VGND VGND VPWR VPWR sky130_fd_sc_hd__fill_2
XFILLER_27_188 VGND VGND VPWR VPWR sky130_fd_sc_hd__decap_3
XFILLER_42_136 VGND VGND VPWR VPWR sky130_fd_sc_hd__decap_3
XFILLER_30_309 VGND VGND VPWR VPWR sky130_fd_sc_hd__fill_2
XFILLER_35_89 VGND VGND VPWR VPWR sky130_fd_sc_hd__decap_3
XFILLER_42_158 VGND VGND VPWR VPWR sky130_fd_sc_hd__decap_3
XFILLER_11_523 VGND VGND VPWR VPWR sky130_fd_sc_hd__decap_3
XFILLER_50_180 VGND VGND VPWR VPWR sky130_fd_sc_hd__decap_3
XFILLER_2_243 VGND VGND VPWR VPWR sky130_fd_sc_hd__fill_1
Xload_slew408 input39/X VGND VGND VPWR VPWR fanout402/A sky130_fd_sc_hd__buf_6
XFILLER_2_287 VGND VGND VPWR VPWR sky130_fd_sc_hd__fill_2
XFILLER_18_9 VGND VGND VPWR VPWR sky130_fd_sc_hd__fill_1
XFILLER_65_206 VGND VGND VPWR VPWR sky130_fd_sc_hd__decap_3
XFILLER_65_228 VGND VGND VPWR VPWR sky130_fd_sc_hd__decap_3
XFILLER_76_85 VGND VGND VPWR VPWR sky130_fd_sc_hd__fill_2
Xfanout580 _5547_/A VGND VGND VPWR VPWR _6123_/A sky130_fd_sc_hd__clkbuf_4
Xfanout591 _6196_/B VGND VGND VPWR VPWR _3868_/A sky130_fd_sc_hd__clkdlybuf4s25_1
XFILLER_93_526 VGND VGND VPWR VPWR sky130_fd_sc_hd__decap_3
XFILLER_58_280 VGND VGND VPWR VPWR sky130_fd_sc_hd__decap_3
XFILLER_73_250 VGND VGND VPWR VPWR sky130_fd_sc_hd__decap_3
XFILLER_80_209 VGND VGND VPWR VPWR sky130_fd_sc_hd__decap_3
XFILLER_33_103 VGND VGND VPWR VPWR sky130_fd_sc_hd__decap_3
XFILLER_33_136 VGND VGND VPWR VPWR sky130_fd_sc_hd__decap_3
XFILLER_33_169 VGND VGND VPWR VPWR sky130_fd_sc_hd__decap_3
XFILLER_61_467 VGND VGND VPWR VPWR sky130_fd_sc_hd__fill_1
XTAP_TAPCELL_ROW_72_974 VGND VPWR sky130_fd_sc_hd__tapvpwrvgnd_1
XTAP_TAPCELL_ROW_44_676 VGND VPWR sky130_fd_sc_hd__tapvpwrvgnd_1
XTAP_TAPCELL_ROW_16_389 VGND VPWR sky130_fd_sc_hd__tapvpwrvgnd_1
X_3620_ _3812_/A _3933_/B _3933_/D _3628_/C VGND VGND VPWR VPWR _3621_/B sky130_fd_sc_hd__a22oi_2
XTAP_TAPCELL_ROW_99_1258 VGND VPWR sky130_fd_sc_hd__tapvpwrvgnd_1
X_3551_ _3550_/A _3551_/A2 _3551_/B1 _4482_/A VGND VGND VPWR VPWR _3552_/D sky130_fd_sc_hd__a22o_2
XFILLER_6_571 VGND VGND VPWR VPWR sky130_fd_sc_hd__decap_3
XFILLER_51_3 VGND VGND VPWR VPWR sky130_fd_sc_hd__fill_1
X_6270_ _6860_/A _6269_/X _6263_/X VGND VGND VPWR VPWR _6271_/A sky130_fd_sc_hd__a21o_2
XFILLER_88_309 VGND VGND VPWR VPWR sky130_fd_sc_hd__decap_3
X_5221_ _6249_/B _5487_/B VGND VGND VPWR VPWR _5236_/A sky130_fd_sc_hd__nand2_2
XFILLER_69_523 VGND VGND VPWR VPWR sky130_fd_sc_hd__decap_3
X_5152_ _5152_/A _6501_/S VGND VGND VPWR VPWR _5228_/A sky130_fd_sc_hd__nand2_2
X_4103_ _4103_/A _4103_/B VGND VGND VPWR VPWR _4209_/B sky130_fd_sc_hd__xnor2_2
XFILLER_84_515 VGND VGND VPWR VPWR sky130_fd_sc_hd__decap_3
X_5083_ _4991_/A _4991_/B _4991_/C VGND VGND VPWR VPWR _5084_/C sky130_fd_sc_hd__a21o_2
XFILLER_56_239 VGND VGND VPWR VPWR sky130_fd_sc_hd__decap_3
X_4034_ _3915_/A _3916_/Y _3798_/X _3807_/A VGND VGND VPWR VPWR _4036_/B sky130_fd_sc_hd__a211oi_2
XFILLER_52_412 VGND VGND VPWR VPWR sky130_fd_sc_hd__decap_3
XFILLER_92_592 VGND VGND VPWR VPWR sky130_fd_sc_hd__decap_3
XFILLER_52_456 VGND VGND VPWR VPWR sky130_fd_sc_hd__decap_3
X_5985_ _5984_/A _5984_/B _5984_/C _5984_/D VGND VGND VPWR VPWR _5986_/B sky130_fd_sc_hd__a22o_2
X_4936_ _5015_/A _5015_/B VGND VGND VPWR VPWR _5016_/A sky130_fd_sc_hd__nand2_2
XFILLER_20_342 VGND VGND VPWR VPWR sky130_fd_sc_hd__decap_3
XFILLER_32_180 VGND VGND VPWR VPWR sky130_fd_sc_hd__decap_3
X_4867_ _4867_/A _4867_/B VGND VGND VPWR VPWR _4868_/C sky130_fd_sc_hd__xnor2_2
XFILLER_20_353 VGND VGND VPWR VPWR sky130_fd_sc_hd__decap_3
X_6606_ _6621_/A1 _6621_/A2 _6621_/A3 _6606_/A3 _6395_/S _6938_/S1 VGND VGND VPWR
+ VPWR _6606_/X sky130_fd_sc_hd__mux4_2
X_3818_ _3819_/A _3819_/B VGND VGND VPWR VPWR _3932_/A sky130_fd_sc_hd__nand2b_2
X_6537_ _6355_/X _6357_/X _6360_/X _6403_/X wire299/X _5585_/B VGND VGND VPWR VPWR
+ _6537_/X sky130_fd_sc_hd__mux4_2
X_4798_ _4800_/A _4800_/B VGND VGND VPWR VPWR _4798_/X sky130_fd_sc_hd__and2b_2
XFILLER_21_47 VGND VGND VPWR VPWR sky130_fd_sc_hd__fill_1
X_3749_ _4280_/B _4659_/B VGND VGND VPWR VPWR _4151_/A sky130_fd_sc_hd__nand2_2
XTAP_TAPCELL_ROW_76_1011 VGND VPWR sky130_fd_sc_hd__tapvpwrvgnd_1
X_6468_ _6124_/B _6331_/B _6891_/B1 _6124_/A VGND VGND VPWR VPWR _6468_/X sky130_fd_sc_hd__o2bb2a_2
X_6399_ _6397_/X _6569_/C _6456_/S VGND VGND VPWR VPWR _6521_/B sky130_fd_sc_hd__mux2_1
X_5419_ _5420_/A _5420_/B VGND VGND VPWR VPWR _5445_/A sky130_fd_sc_hd__or2_2
XFILLER_87_364 VGND VGND VPWR VPWR sky130_fd_sc_hd__decap_3
XFILLER_75_537 VGND VGND VPWR VPWR sky130_fd_sc_hd__decap_3
XFILLER_75_559 VGND VGND VPWR VPWR sky130_fd_sc_hd__fill_1
XFILLER_28_475 VGND VGND VPWR VPWR sky130_fd_sc_hd__fill_1
XFILLER_62_209 VGND VGND VPWR VPWR sky130_fd_sc_hd__decap_3
XFILLER_83_570 VGND VGND VPWR VPWR sky130_fd_sc_hd__decap_3
XFILLER_90_529 VGND VGND VPWR VPWR sky130_fd_sc_hd__decap_3
XFILLER_43_423 VGND VGND VPWR VPWR sky130_fd_sc_hd__decap_3
XFILLER_46_88 VGND VGND VPWR VPWR sky130_fd_sc_hd__fill_2
XFILLER_55_294 VGND VGND VPWR VPWR sky130_fd_sc_hd__decap_3
XFILLER_15_158 VGND VGND VPWR VPWR sky130_fd_sc_hd__decap_3
XFILLER_15_169 VGND VGND VPWR VPWR sky130_fd_sc_hd__decap_3
XFILLER_43_445 VGND VGND VPWR VPWR sky130_fd_sc_hd__decap_3
XFILLER_70_253 VGND VGND VPWR VPWR sky130_fd_sc_hd__decap_3
XFILLER_70_286 VGND VGND VPWR VPWR sky130_fd_sc_hd__fill_2
XFILLER_23_191 VGND VGND VPWR VPWR sky130_fd_sc_hd__decap_3
XFILLER_62_65 VGND VGND VPWR VPWR sky130_fd_sc_hd__fill_2
XTAP_TAPCELL_ROW_41_646 VGND VPWR sky130_fd_sc_hd__tapvpwrvgnd_1
XFILLER_11_386 VGND VGND VPWR VPWR sky130_fd_sc_hd__decap_3
Xwire299 wire299/A VGND VGND VPWR VPWR wire299/X sky130_fd_sc_hd__clkbuf_4
XFILLER_3_530 VGND VGND VPWR VPWR sky130_fd_sc_hd__fill_2
XTAP_TAPCELL_ROW_94_1199 VGND VPWR sky130_fd_sc_hd__tapvpwrvgnd_1
XFILLER_3_596 VGND VGND VPWR VPWR sky130_fd_sc_hd__fill_2
Xload_slew216 _5340_/B VGND VGND VPWR VPWR _5203_/D sky130_fd_sc_hd__buf_6
XFILLER_87_84 VGND VGND VPWR VPWR sky130_fd_sc_hd__fill_1
Xload_slew249 _4766_/B VGND VGND VPWR VPWR _4526_/B sky130_fd_sc_hd__buf_4
Xload_slew238 _6116_/B VGND VGND VPWR VPWR _5576_/C sky130_fd_sc_hd__buf_6
XFILLER_38_206 VGND VGND VPWR VPWR sky130_fd_sc_hd__decap_3
XFILLER_66_515 VGND VGND VPWR VPWR sky130_fd_sc_hd__decap_3
XFILLER_66_526 VGND VGND VPWR VPWR sky130_fd_sc_hd__decap_3
XFILLER_78_397 VGND VGND VPWR VPWR sky130_fd_sc_hd__decap_3
XFILLER_66_559 VGND VGND VPWR VPWR sky130_fd_sc_hd__decap_3
XTAP_TAPCELL_ROW_49_735 VGND VPWR sky130_fd_sc_hd__tapvpwrvgnd_1
XFILLER_93_367 VGND VGND VPWR VPWR sky130_fd_sc_hd__decap_3
XFILLER_46_272 VGND VGND VPWR VPWR sky130_fd_sc_hd__decap_3
XFILLER_74_592 VGND VGND VPWR VPWR sky130_fd_sc_hd__decap_3
XFILLER_34_456 VGND VGND VPWR VPWR sky130_fd_sc_hd__fill_2
XFILLER_61_231 VGND VGND VPWR VPWR sky130_fd_sc_hd__decap_3
XFILLER_61_253 VGND VGND VPWR VPWR sky130_fd_sc_hd__decap_3
XFILLER_61_275 VGND VGND VPWR VPWR sky130_fd_sc_hd__decap_3
X_5770_ _5773_/A _5773_/B VGND VGND VPWR VPWR _5772_/B sky130_fd_sc_hd__and2b_2
XFILLER_99_3 VGND VGND VPWR VPWR sky130_fd_sc_hd__fill_1
X_4721_ _4697_/A _4697_/C _4697_/B VGND VGND VPWR VPWR _4722_/C sky130_fd_sc_hd__o21ai_2
X_4652_ _4685_/A _4925_/C _4685_/D _4687_/C VGND VGND VPWR VPWR _4653_/B sky130_fd_sc_hd__a22oi_2
Xinput30 A[7] VGND VGND VPWR VPWR input30/X sky130_fd_sc_hd__clkbuf_2
X_3603_ _3900_/A _6098_/A _3580_/B _3578_/X VGND VGND VPWR VPWR _3605_/B sky130_fd_sc_hd__a31o_2
Xinput63 B[8] VGND VGND VPWR VPWR input63/X sky130_fd_sc_hd__buf_2
Xinput52 B[27] VGND VGND VPWR VPWR _5993_/A sky130_fd_sc_hd__clkdlybuf4s25_1
Xinput41 B[17] VGND VGND VPWR VPWR _5976_/C sky130_fd_sc_hd__dlymetal6s4s_1
X_4583_ _6248_/B _4785_/B _4582_/B _4579_/X VGND VGND VPWR VPWR _4586_/B sky130_fd_sc_hd__a31oi_2
X_6322_ _6089_/B _6093_/B _6410_/S VGND VGND VPWR VPWR _6322_/X sky130_fd_sc_hd__mux2_1
X_3534_ _3991_/B _6077_/A VGND VGND VPWR VPWR _3538_/A sky130_fd_sc_hd__nand2_2
XFILLER_6_390 VGND VGND VPWR VPWR sky130_fd_sc_hd__decap_3
X_6253_ _6793_/B _6252_/Y _6795_/B VGND VGND VPWR VPWR _6253_/X sky130_fd_sc_hd__o21a_2
XFILLER_88_139 VGND VGND VPWR VPWR sky130_fd_sc_hd__fill_1
X_5204_ _5204_/A _5295_/A VGND VGND VPWR VPWR _5213_/A sky130_fd_sc_hd__nor2_2
X_6184_ _6190_/C VGND VGND VPWR VPWR _6874_/A sky130_fd_sc_hd__inv_2
XFILLER_29_206 VGND VGND VPWR VPWR sky130_fd_sc_hd__decap_3
XFILLER_69_386 VGND VGND VPWR VPWR sky130_fd_sc_hd__decap_3
XFILLER_84_312 VGND VGND VPWR VPWR sky130_fd_sc_hd__fill_1
X_5135_ _6214_/B _6112_/B VGND VGND VPWR VPWR _5135_/Y sky130_fd_sc_hd__nand2_2
XFILLER_29_228 VGND VGND VPWR VPWR sky130_fd_sc_hd__fill_2
XFILLER_84_334 VGND VGND VPWR VPWR sky130_fd_sc_hd__decap_3
X_5066_ _5066_/A _5066_/B VGND VGND VPWR VPWR _5078_/A sky130_fd_sc_hd__xnor2_2
X_4017_ _4016_/A _4016_/B _4016_/C VGND VGND VPWR VPWR _4018_/B sky130_fd_sc_hd__o21a_2
XFILLER_65_570 VGND VGND VPWR VPWR sky130_fd_sc_hd__decap_3
XFILLER_65_581 VGND VGND VPWR VPWR sky130_fd_sc_hd__fill_2
XFILLER_16_36 VGND VGND VPWR VPWR sky130_fd_sc_hd__decap_3
XFILLER_16_58 VGND VGND VPWR VPWR sky130_fd_sc_hd__decap_3
XFILLER_52_253 VGND VGND VPWR VPWR sky130_fd_sc_hd__decap_3
XFILLER_80_595 VGND VGND VPWR VPWR sky130_fd_sc_hd__decap_3
X_5968_ _5968_/A _5968_/B VGND VGND VPWR VPWR _5970_/A sky130_fd_sc_hd__xnor2_2
X_4919_ _4588_/Y _4591_/Y _5913_/A _4918_/X VGND VGND VPWR VPWR _5913_/B sky130_fd_sc_hd__a211oi_4
XTAP_TAPCELL_ROW_82_1081 VGND VPWR sky130_fd_sc_hd__tapvpwrvgnd_1
X_5899_ _5896_/Y _5898_/X _5892_/X _5893_/Y VGND VGND VPWR VPWR _5931_/A sky130_fd_sc_hd__a211o_2
XTAP_TAPCELL_ROW_10_318 VGND VPWR sky130_fd_sc_hd__tapvpwrvgnd_1
XFILLER_20_194 VGND VGND VPWR VPWR sky130_fd_sc_hd__fill_2
XFILLER_0_500 VGND VGND VPWR VPWR sky130_fd_sc_hd__decap_3
XFILLER_79_139 VGND VGND VPWR VPWR sky130_fd_sc_hd__fill_1
XFILLER_0_533 VGND VGND VPWR VPWR sky130_fd_sc_hd__decap_3
XFILLER_48_504 VGND VGND VPWR VPWR sky130_fd_sc_hd__decap_3
XFILLER_87_150 VGND VGND VPWR VPWR sky130_fd_sc_hd__decap_3
XFILLER_57_87 VGND VGND VPWR VPWR sky130_fd_sc_hd__fill_2
XFILLER_87_183 VGND VGND VPWR VPWR sky130_fd_sc_hd__decap_3
XFILLER_35_209 VGND VGND VPWR VPWR sky130_fd_sc_hd__decap_3
XFILLER_90_304 VGND VGND VPWR VPWR sky130_fd_sc_hd__decap_3
XTAP_TAPCELL_ROW_46_705 VGND VPWR sky130_fd_sc_hd__tapvpwrvgnd_1
XTAP_TAPCELL_ROW_18_407 VGND VPWR sky130_fd_sc_hd__tapvpwrvgnd_1
XFILLER_56_592 VGND VGND VPWR VPWR sky130_fd_sc_hd__decap_3
XFILLER_73_31 VGND VGND VPWR VPWR sky130_fd_sc_hd__decap_3
XFILLER_90_337 VGND VGND VPWR VPWR sky130_fd_sc_hd__decap_3
XFILLER_43_231 VGND VGND VPWR VPWR sky130_fd_sc_hd__decap_3
XFILLER_90_359 VGND VGND VPWR VPWR sky130_fd_sc_hd__decap_3
XFILLER_16_489 VGND VGND VPWR VPWR sky130_fd_sc_hd__decap_3
XFILLER_73_75 VGND VGND VPWR VPWR sky130_fd_sc_hd__fill_1
XFILLER_73_97 VGND VGND VPWR VPWR sky130_fd_sc_hd__decap_3
XTAP_TAPCELL_ROW_54_782 VGND VPWR sky130_fd_sc_hd__tapvpwrvgnd_1
XTAP_TAPCELL_ROW_26_495 VGND VPWR sky130_fd_sc_hd__tapvpwrvgnd_1
XTAP_TAPCELL_ROW_96_1228 VGND VPWR sky130_fd_sc_hd__tapvpwrvgnd_1
XFILLER_7_198 VGND VGND VPWR VPWR sky130_fd_sc_hd__decap_3
XFILLER_98_83 VGND VGND VPWR VPWR sky130_fd_sc_hd__fill_1
XFILLER_66_312 VGND VGND VPWR VPWR sky130_fd_sc_hd__decap_3
XFILLER_78_150 VGND VGND VPWR VPWR sky130_fd_sc_hd__decap_3
XFILLER_39_548 VGND VGND VPWR VPWR sky130_fd_sc_hd__fill_2
XFILLER_66_345 VGND VGND VPWR VPWR sky130_fd_sc_hd__fill_1
XFILLER_93_153 VGND VGND VPWR VPWR sky130_fd_sc_hd__decap_3
X_6940_ _6940_/A _6977_/B VGND VGND VPWR VPWR _6940_/Y sky130_fd_sc_hd__nand2_2
XFILLER_66_389 VGND VGND VPWR VPWR sky130_fd_sc_hd__decap_3
XFILLER_81_326 VGND VGND VPWR VPWR sky130_fd_sc_hd__fill_2
XFILLER_81_337 VGND VGND VPWR VPWR sky130_fd_sc_hd__decap_3
X_6871_ _6871_/A _6874_/A VGND VGND VPWR VPWR _6871_/Y sky130_fd_sc_hd__xnor2_2
XFILLER_34_253 VGND VGND VPWR VPWR sky130_fd_sc_hd__decap_3
X_5822_ _5257_/A _5255_/X _5077_/Y _5079_/Y VGND VGND VPWR VPWR _5822_/X sky130_fd_sc_hd__o211a_2
XFILLER_62_595 VGND VGND VPWR VPWR sky130_fd_sc_hd__decap_3
X_5753_ _5752_/A _5752_/B _5752_/C VGND VGND VPWR VPWR _5754_/B sky130_fd_sc_hd__a21o_2
X_4704_ _6109_/A _6109_/B VGND VGND VPWR VPWR _6213_/A sky130_fd_sc_hd__and2_2
X_5684_ _5596_/A _5596_/B _5597_/X VGND VGND VPWR VPWR _5690_/A sky130_fd_sc_hd__a21o_2
X_4635_ _4634_/A _4925_/C _4685_/D _4634_/B VGND VGND VPWR VPWR _4635_/Y sky130_fd_sc_hd__a22oi_2
X_4566_ _4567_/A _4567_/B VGND VGND VPWR VPWR _6951_/A sky130_fd_sc_hd__or2_2
X_6305_ wire571/A _4003_/B _6004_/B wire672/X _6831_/S _6410_/S VGND VGND VPWR VPWR
+ _6505_/B sky130_fd_sc_hd__mux4_2
X_3517_ _3517_/A _3517_/B VGND VGND VPWR VPWR _3518_/C sky130_fd_sc_hd__xor2_2
XFILLER_1_308 VGND VGND VPWR VPWR sky130_fd_sc_hd__fill_2
X_4497_ _4497_/A _4497_/B _4497_/C VGND VGND VPWR VPWR _5885_/A sky130_fd_sc_hd__nand3_2
XFILLER_89_459 VGND VGND VPWR VPWR sky130_fd_sc_hd__decap_3
X_6236_ _6109_/B _6236_/B VGND VGND VPWR VPWR _6236_/Y sky130_fd_sc_hd__nand2b_2
XFILLER_57_301 VGND VGND VPWR VPWR sky130_fd_sc_hd__decap_3
XFILLER_76_109 VGND VGND VPWR VPWR sky130_fd_sc_hd__decap_3
X_6167_ _6842_/B _6842_/C _6842_/A VGND VGND VPWR VPWR _6168_/B sky130_fd_sc_hd__a21o_2
XFILLER_57_334 VGND VGND VPWR VPWR sky130_fd_sc_hd__fill_2
XFILLER_69_172 VGND VGND VPWR VPWR sky130_fd_sc_hd__decap_3
X_5118_ _5117_/B _5117_/C _5117_/A VGND VGND VPWR VPWR _5120_/B sky130_fd_sc_hd__a21bo_2
XFILLER_27_35 VGND VGND VPWR VPWR sky130_fd_sc_hd__decap_3
XFILLER_84_131 VGND VGND VPWR VPWR sky130_fd_sc_hd__decap_3
XFILLER_84_153 VGND VGND VPWR VPWR sky130_fd_sc_hd__decap_3
X_6098_ _6098_/A _6098_/B VGND VGND VPWR VPWR _6208_/B sky130_fd_sc_hd__or2_2
XFILLER_27_57 VGND VGND VPWR VPWR sky130_fd_sc_hd__decap_3
XFILLER_45_529 VGND VGND VPWR VPWR sky130_fd_sc_hd__decap_3
XFILLER_72_315 VGND VGND VPWR VPWR sky130_fd_sc_hd__decap_3
XFILLER_84_197 VGND VGND VPWR VPWR sky130_fd_sc_hd__decap_3
X_5049_ _5046_/X _5049_/B VGND VGND VPWR VPWR _5123_/B sky130_fd_sc_hd__and2b_2
XFILLER_25_231 VGND VGND VPWR VPWR sky130_fd_sc_hd__decap_3
XFILLER_27_79 VGND VGND VPWR VPWR sky130_fd_sc_hd__decap_3
XFILLER_25_253 VGND VGND VPWR VPWR sky130_fd_sc_hd__decap_3
XFILLER_43_12 VGND VGND VPWR VPWR sky130_fd_sc_hd__fill_1
XFILLER_40_234 VGND VGND VPWR VPWR sky130_fd_sc_hd__decap_3
XFILLER_43_45 VGND VGND VPWR VPWR sky130_fd_sc_hd__decap_3
XFILLER_80_392 VGND VGND VPWR VPWR sky130_fd_sc_hd__decap_3
XFILLER_40_256 VGND VGND VPWR VPWR sky130_fd_sc_hd__decap_3
XTAP_TAPCELL_ROW_51_752 VGND VPWR sky130_fd_sc_hd__tapvpwrvgnd_1
XTAP_TAPCELL_ROW_23_454 VGND VPWR sky130_fd_sc_hd__tapvpwrvgnd_1
XFILLER_9_419 VGND VGND VPWR VPWR sky130_fd_sc_hd__fill_1
XFILLER_40_289 VGND VGND VPWR VPWR sky130_fd_sc_hd__decap_3
Xrebuffer730 _5061_/X VGND VGND VPWR VPWR _5147_/C1 sky130_fd_sc_hd__buf_2
Xrebuffer741 _5244_/B VGND VGND VPWR VPWR _5245_/A1 sky130_fd_sc_hd__buf_2
Xrebuffer752 _5328_/C VGND VGND VPWR VPWR _5382_/C sky130_fd_sc_hd__buf_2
Xrebuffer763 _5817_/Y VGND VGND VPWR VPWR _6686_/A3 sky130_fd_sc_hd__buf_2
XFILLER_68_20 VGND VGND VPWR VPWR sky130_fd_sc_hd__fill_1
XFILLER_0_330 VGND VGND VPWR VPWR sky130_fd_sc_hd__decap_3
XFILLER_68_42 VGND VGND VPWR VPWR sky130_fd_sc_hd__decap_3
XTAP_TAPCELL_ROW_91_1169 VGND VPWR sky130_fd_sc_hd__tapvpwrvgnd_1
XFILLER_95_429 VGND VGND VPWR VPWR sky130_fd_sc_hd__decap_3
XFILLER_48_334 VGND VGND VPWR VPWR sky130_fd_sc_hd__decap_3
XFILLER_68_97 VGND VGND VPWR VPWR sky130_fd_sc_hd__decap_3
XTAP_TAPCELL_ROW_59_841 VGND VPWR sky130_fd_sc_hd__tapvpwrvgnd_1
XFILLER_29_581 VGND VGND VPWR VPWR sky130_fd_sc_hd__fill_1
XFILLER_63_337 VGND VGND VPWR VPWR sky130_fd_sc_hd__decap_3
XFILLER_75_164 VGND VGND VPWR VPWR sky130_fd_sc_hd__decap_3
XFILLER_75_175 VGND VGND VPWR VPWR sky130_fd_sc_hd__decap_3
XFILLER_75_197 VGND VGND VPWR VPWR sky130_fd_sc_hd__decap_3
XFILLER_84_63 VGND VGND VPWR VPWR sky130_fd_sc_hd__decap_3
XFILLER_63_359 VGND VGND VPWR VPWR sky130_fd_sc_hd__fill_2
XFILLER_16_253 VGND VGND VPWR VPWR sky130_fd_sc_hd__decap_3
XFILLER_16_297 VGND VGND VPWR VPWR sky130_fd_sc_hd__fill_2
XFILLER_44_595 VGND VGND VPWR VPWR sky130_fd_sc_hd__decap_3
XFILLER_71_381 VGND VGND VPWR VPWR sky130_fd_sc_hd__decap_3
XTAP_TAPCELL_ROW_100_1276 VGND VPWR sky130_fd_sc_hd__tapvpwrvgnd_1
XTAP_TAPCELL_ROW_100_1265 VGND VPWR sky130_fd_sc_hd__tapvpwrvgnd_1
XFILLER_12_492 VGND VGND VPWR VPWR sky130_fd_sc_hd__decap_3
XFILLER_8_452 VGND VGND VPWR VPWR sky130_fd_sc_hd__decap_3
X_4420_ _6254_/B _6085_/B _4420_/C _4538_/D VGND VGND VPWR VPWR _4420_/X sky130_fd_sc_hd__and4_2
X_4351_ _4351_/A VGND VGND VPWR VPWR _4351_/Y sky130_fd_sc_hd__inv_2
Xfanout409 _6029_/A2 VGND VGND VPWR VPWR _4617_/B sky130_fd_sc_hd__clkbuf_2
X_4282_ _4282_/A _4407_/B _4283_/A _4282_/D VGND VGND VPWR VPWR _4405_/A sky130_fd_sc_hd__nand4_2
XFILLER_79_470 VGND VGND VPWR VPWR sky130_fd_sc_hd__decap_3
XFILLER_86_407 VGND VGND VPWR VPWR sky130_fd_sc_hd__decap_3
X_6021_ _6021_/A _6021_/B _6021_/C _6021_/D VGND VGND VPWR VPWR _6022_/B sky130_fd_sc_hd__or4_2
XFILLER_100_239 VGND VGND VPWR VPWR sky130_fd_sc_hd__decap_3
XFILLER_39_312 VGND VGND VPWR VPWR sky130_fd_sc_hd__decap_3
XFILLER_66_153 VGND VGND VPWR VPWR sky130_fd_sc_hd__fill_1
XFILLER_94_451 VGND VGND VPWR VPWR sky130_fd_sc_hd__decap_3
XFILLER_54_304 VGND VGND VPWR VPWR sky130_fd_sc_hd__decap_3
XFILLER_35_540 VGND VGND VPWR VPWR sky130_fd_sc_hd__decap_3
XFILLER_66_197 VGND VGND VPWR VPWR sky130_fd_sc_hd__decap_3
XFILLER_81_134 VGND VGND VPWR VPWR sky130_fd_sc_hd__decap_3
X_6923_ _6923_/A _6923_/B _6923_/C VGND VGND VPWR VPWR _6934_/A sky130_fd_sc_hd__and3_2
XFILLER_81_167 VGND VGND VPWR VPWR sky130_fd_sc_hd__fill_1
XFILLER_81_178 VGND VGND VPWR VPWR sky130_fd_sc_hd__decap_3
XTAP_TAPCELL_ROW_65_899 VGND VPWR sky130_fd_sc_hd__tapvpwrvgnd_1
XFILLER_22_223 VGND VGND VPWR VPWR sky130_fd_sc_hd__decap_3
X_6854_ _6854_/A _6854_/B _6854_/C _6853_/X VGND VGND VPWR VPWR _6854_/X sky130_fd_sc_hd__or4b_4
X_6785_ _6965_/A _6785_/B _6785_/C VGND VGND VPWR VPWR _6785_/X sky130_fd_sc_hd__and3_2
X_5805_ _6514_/A _6514_/B _5786_/A _5788_/A _5788_/B VGND VGND VPWR VPWR _5806_/B
+ sky130_fd_sc_hd__a2111o_2
X_3997_ _4003_/B _6286_/A VGND VGND VPWR VPWR _6007_/A sky130_fd_sc_hd__nand2_2
XFILLER_10_418 VGND VGND VPWR VPWR sky130_fd_sc_hd__fill_2
XFILLER_22_278 VGND VGND VPWR VPWR sky130_fd_sc_hd__decap_3
X_5736_ _5769_/A _5769_/B VGND VGND VPWR VPWR _5757_/A sky130_fd_sc_hd__nor2_2
X_5667_ _5667_/A _5667_/B _5667_/C VGND VGND VPWR VPWR _5670_/A sky130_fd_sc_hd__and3_2
XTAP_TAPCELL_ROW_20_424 VGND VPWR sky130_fd_sc_hd__tapvpwrvgnd_1
X_4618_ _4634_/B _4616_/C _4616_/D _4636_/C VGND VGND VPWR VPWR _4619_/B sky130_fd_sc_hd__a22oi_2
X_5598_ _5598_/A _5598_/B VGND VGND VPWR VPWR _5639_/A sky130_fd_sc_hd__xnor2_2
XFILLER_89_212 VGND VGND VPWR VPWR sky130_fd_sc_hd__decap_3
X_4549_ _4549_/A _4549_/B _4897_/A VGND VGND VPWR VPWR _4550_/B sky130_fd_sc_hd__nor3_2
XFILLER_1_127 VGND VGND VPWR VPWR sky130_fd_sc_hd__decap_3
XFILLER_1_138 VGND VGND VPWR VPWR sky130_fd_sc_hd__decap_3
XFILLER_89_234 VGND VGND VPWR VPWR sky130_fd_sc_hd__decap_3
XFILLER_38_12 VGND VGND VPWR VPWR sky130_fd_sc_hd__fill_1
XFILLER_49_109 VGND VGND VPWR VPWR sky130_fd_sc_hd__decap_3
X_6219_ _6219_/A _6608_/S VGND VGND VPWR VPWR _6227_/B sky130_fd_sc_hd__or2_2
XFILLER_57_120 VGND VGND VPWR VPWR sky130_fd_sc_hd__decap_3
XFILLER_57_153 VGND VGND VPWR VPWR sky130_fd_sc_hd__decap_3
XFILLER_18_518 VGND VGND VPWR VPWR sky130_fd_sc_hd__decap_3
XFILLER_45_326 VGND VGND VPWR VPWR sky130_fd_sc_hd__fill_1
XFILLER_57_175 VGND VGND VPWR VPWR sky130_fd_sc_hd__decap_3
XFILLER_85_495 VGND VGND VPWR VPWR sky130_fd_sc_hd__decap_3
XTAP_TAPCELL_ROW_56_800 VGND VPWR sky130_fd_sc_hd__tapvpwrvgnd_1
XTAP_TAPCELL_ROW_28_513 VGND VPWR sky130_fd_sc_hd__tapvpwrvgnd_1
XFILLER_54_44 VGND VGND VPWR VPWR sky130_fd_sc_hd__fill_2
XFILLER_60_318 VGND VGND VPWR VPWR sky130_fd_sc_hd__decap_3
XFILLER_72_189 VGND VGND VPWR VPWR sky130_fd_sc_hd__fill_2
XFILLER_13_223 VGND VGND VPWR VPWR sky130_fd_sc_hd__fill_1
XFILLER_13_234 VGND VGND VPWR VPWR sky130_fd_sc_hd__decap_3
XFILLER_41_521 VGND VGND VPWR VPWR sky130_fd_sc_hd__decap_3
XFILLER_54_88 VGND VGND VPWR VPWR sky130_fd_sc_hd__decap_3
XTAP_TAPCELL_ROW_36_590 VGND VPWR sky130_fd_sc_hd__tapvpwrvgnd_1
XFILLER_9_249 VGND VGND VPWR VPWR sky130_fd_sc_hd__decap_3
XFILLER_5_455 VGND VGND VPWR VPWR sky130_fd_sc_hd__fill_1
XFILLER_79_74 VGND VGND VPWR VPWR sky130_fd_sc_hd__decap_3
XFILLER_0_160 VGND VGND VPWR VPWR sky130_fd_sc_hd__decap_3
XFILLER_95_237 VGND VGND VPWR VPWR sky130_fd_sc_hd__decap_3
XFILLER_48_131 VGND VGND VPWR VPWR sky130_fd_sc_hd__decap_3
XFILLER_48_164 VGND VGND VPWR VPWR sky130_fd_sc_hd__decap_3
XFILLER_36_337 VGND VGND VPWR VPWR sky130_fd_sc_hd__decap_3
XFILLER_48_197 VGND VGND VPWR VPWR sky130_fd_sc_hd__fill_1
XFILLER_63_134 VGND VGND VPWR VPWR sky130_fd_sc_hd__decap_3
XFILLER_51_329 VGND VGND VPWR VPWR sky130_fd_sc_hd__decap_3
X_3920_ _5983_/B _3976_/B _3911_/B _3909_/X VGND VGND VPWR VPWR _3928_/A sky130_fd_sc_hd__a31o_2
X_3851_ _6014_/D _3851_/B _6182_/B _5948_/A VGND VGND VPWR VPWR _3853_/A sky130_fd_sc_hd__and4_2
XTAP_TAPCELL_ROW_62_869 VGND VPWR sky130_fd_sc_hd__tapvpwrvgnd_1
XFILLER_81_3 VGND VGND VPWR VPWR sky130_fd_sc_hd__decap_3
X_6570_ _6731_/A _6447_/B _6569_/X VGND VGND VPWR VPWR _6570_/X sky130_fd_sc_hd__a21o_2
X_3782_ _4077_/B _3782_/B _3782_/C VGND VGND VPWR VPWR _4077_/C sky130_fd_sc_hd__nand3_2
X_5521_ _5820_/A VGND VGND VPWR VPWR _6722_/B sky130_fd_sc_hd__inv_2
X_5452_ _5452_/A _5452_/B VGND VGND VPWR VPWR _5457_/A sky130_fd_sc_hd__nand2_2
X_5383_ _5383_/A _5383_/B VGND VGND VPWR VPWR _5481_/A sky130_fd_sc_hd__nand2_2
X_4403_ _4524_/A _4518_/B _4402_/B _4399_/X VGND VGND VPWR VPWR _4405_/B sky130_fd_sc_hd__a31o_2
XFILLER_99_521 VGND VGND VPWR VPWR sky130_fd_sc_hd__decap_3
X_4334_ _4593_/B _4457_/B _4334_/C _4457_/C VGND VGND VPWR VPWR _4334_/X sky130_fd_sc_hd__and4_2
Xfanout206 input67/X VGND VGND VPWR VPWR _6332_/A sky130_fd_sc_hd__clkdlybuf4s25_1
Xfanout217 _5680_/B VGND VGND VPWR VPWR _5322_/B sky130_fd_sc_hd__buf_6
Xfanout228 input62/X VGND VGND VPWR VPWR _6112_/B sky130_fd_sc_hd__buf_6
XFILLER_99_587 VGND VGND VPWR VPWR sky130_fd_sc_hd__decap_3
XFILLER_86_215 VGND VGND VPWR VPWR sky130_fd_sc_hd__fill_1
XFILLER_86_237 VGND VGND VPWR VPWR sky130_fd_sc_hd__fill_2
Xfanout239 _4767_/D VGND VGND VPWR VPWR _3685_/D sky130_fd_sc_hd__clkdlybuf4s25_1
X_6004_ _6196_/A _6004_/B VGND VGND VPWR VPWR _6004_/Y sky130_fd_sc_hd__nand2_2
X_4265_ _4263_/A _4387_/C _4387_/D _5976_/B VGND VGND VPWR VPWR _4266_/C sky130_fd_sc_hd__a22oi_2
XFILLER_67_440 VGND VGND VPWR VPWR sky130_fd_sc_hd__decap_3
XFILLER_86_259 VGND VGND VPWR VPWR sky130_fd_sc_hd__decap_3
X_4196_ _4075_/X _4085_/Y _4111_/Y _4139_/X VGND VGND VPWR VPWR _4197_/C sky130_fd_sc_hd__o211a_2
XFILLER_39_186 VGND VGND VPWR VPWR sky130_fd_sc_hd__decap_3
XFILLER_67_473 VGND VGND VPWR VPWR sky130_fd_sc_hd__decap_3
XFILLER_27_337 VGND VGND VPWR VPWR sky130_fd_sc_hd__decap_3
XFILLER_54_123 VGND VGND VPWR VPWR sky130_fd_sc_hd__fill_2
XFILLER_54_178 VGND VGND VPWR VPWR sky130_fd_sc_hd__decap_3
XFILLER_82_465 VGND VGND VPWR VPWR sky130_fd_sc_hd__fill_1
XFILLER_42_329 VGND VGND VPWR VPWR sky130_fd_sc_hd__decap_3
X_6906_ _5917_/X _5930_/A _5934_/C _6841_/A VGND VGND VPWR VPWR _6907_/B sky130_fd_sc_hd__a31o_2
X_6837_ _6923_/A _6822_/X _6825_/Y _6836_/X VGND VGND VPWR VPWR _6983_/B sky130_fd_sc_hd__a211o_2
XTAP_TAPCELL_ROW_33_560 VGND VPWR sky130_fd_sc_hd__tapvpwrvgnd_1
X_6768_ _6372_/B _6761_/X _6944_/B1 _6622_/X VGND VGND VPWR VPWR _6769_/C sky130_fd_sc_hd__a22o_2
X_6699_ _6680_/A _6867_/A _6698_/X _6625_/B VGND VGND VPWR VPWR _6699_/X sky130_fd_sc_hd__a31o_2
X_5719_ _5720_/A _5720_/B VGND VGND VPWR VPWR _5719_/X sky130_fd_sc_hd__and2b_2
XTAP_TAPCELL_ROW_79_1042 VGND VPWR sky130_fd_sc_hd__tapvpwrvgnd_1
XFILLER_40_68 VGND VGND VPWR VPWR sky130_fd_sc_hd__decap_3
XFILLER_49_11 VGND VGND VPWR VPWR sky130_fd_sc_hd__fill_2
XFILLER_49_44 VGND VGND VPWR VPWR sky130_fd_sc_hd__decap_3
XFILLER_77_215 VGND VGND VPWR VPWR sky130_fd_sc_hd__decap_3
XFILLER_1_29 VGND VGND VPWR VPWR sky130_fd_sc_hd__fill_2
XFILLER_77_248 VGND VGND VPWR VPWR sky130_fd_sc_hd__decap_3
XFILLER_65_21 VGND VGND VPWR VPWR sky130_fd_sc_hd__decap_3
XFILLER_65_32 VGND VGND VPWR VPWR sky130_fd_sc_hd__decap_3
XFILLER_92_229 VGND VGND VPWR VPWR sky130_fd_sc_hd__decap_3
XTAP_TAPCELL_ROW_5_274 VGND VPWR sky130_fd_sc_hd__tapvpwrvgnd_1
XFILLER_100_592 VGND VGND VPWR VPWR sky130_fd_sc_hd__decap_3
XFILLER_45_134 VGND VGND VPWR VPWR sky130_fd_sc_hd__decap_3
XFILLER_73_421 VGND VGND VPWR VPWR sky130_fd_sc_hd__decap_3
XFILLER_85_281 VGND VGND VPWR VPWR sky130_fd_sc_hd__decap_3
XFILLER_33_318 VGND VGND VPWR VPWR sky130_fd_sc_hd__decap_3
XFILLER_45_178 VGND VGND VPWR VPWR sky130_fd_sc_hd__decap_3
XFILLER_73_476 VGND VGND VPWR VPWR sky130_fd_sc_hd__decap_3
XFILLER_26_392 VGND VGND VPWR VPWR sky130_fd_sc_hd__decap_3
XFILLER_60_115 VGND VGND VPWR VPWR sky130_fd_sc_hd__fill_1
XFILLER_14_554 VGND VGND VPWR VPWR sky130_fd_sc_hd__fill_1
XFILLER_14_587 VGND VGND VPWR VPWR sky130_fd_sc_hd__fill_1
XFILLER_81_64 VGND VGND VPWR VPWR sky130_fd_sc_hd__decap_3
XFILLER_5_241 VGND VGND VPWR VPWR sky130_fd_sc_hd__fill_1
XFILLER_46_6 VGND VGND VPWR VPWR sky130_fd_sc_hd__fill_2
XFILLER_68_215 VGND VGND VPWR VPWR sky130_fd_sc_hd__fill_2
XFILLER_68_237 VGND VGND VPWR VPWR sky130_fd_sc_hd__decap_3
XFILLER_96_546 VGND VGND VPWR VPWR sky130_fd_sc_hd__fill_1
X_4050_ _4055_/B _4050_/B VGND VGND VPWR VPWR _4051_/C sky130_fd_sc_hd__nand2_2
XTAP_TAPCELL_ROW_67_917 VGND VPWR sky130_fd_sc_hd__tapvpwrvgnd_1
XFILLER_83_218 VGND VGND VPWR VPWR sky130_fd_sc_hd__decap_3
Xinput6 A[14] VGND VGND VPWR VPWR input6/X sky130_fd_sc_hd__buf_2
XFILLER_64_432 VGND VGND VPWR VPWR sky130_fd_sc_hd__fill_2
XFILLER_24_318 VGND VGND VPWR VPWR sky130_fd_sc_hd__decap_3
XFILLER_36_178 VGND VGND VPWR VPWR sky130_fd_sc_hd__decap_3
XFILLER_64_465 VGND VGND VPWR VPWR sky130_fd_sc_hd__decap_3
XFILLER_91_240 VGND VGND VPWR VPWR sky130_fd_sc_hd__decap_3
XFILLER_24_329 VGND VGND VPWR VPWR sky130_fd_sc_hd__decap_3
XFILLER_64_498 VGND VGND VPWR VPWR sky130_fd_sc_hd__decap_3
X_4952_ _4950_/X _4952_/B VGND VGND VPWR VPWR _5023_/A sky130_fd_sc_hd__nand2b_2
X_4883_ _4883_/A _4883_/B _4883_/C VGND VGND VPWR VPWR _4883_/Y sky130_fd_sc_hd__nand3_2
X_3903_ _3901_/X _3903_/B VGND VGND VPWR VPWR _3904_/B sky130_fd_sc_hd__and2b_2
X_6622_ _6552_/X _6621_/X _6761_/S VGND VGND VPWR VPWR _6622_/X sky130_fd_sc_hd__mux2_1
X_3834_ _6019_/D _3941_/A _3941_/B _3834_/D VGND VGND VPWR VPWR _3834_/X sky130_fd_sc_hd__and4_2
XTAP_TAPCELL_ROW_30_530 VGND VPWR sky130_fd_sc_hd__tapvpwrvgnd_1
X_6553_ _6446_/Y _6552_/X _6761_/S VGND VGND VPWR VPWR _6554_/B sky130_fd_sc_hd__mux2_1
X_3765_ _3872_/A _3765_/B VGND VGND VPWR VPWR _3781_/A sky130_fd_sc_hd__nand2_2
X_6484_ _6484_/A _6484_/B VGND VGND VPWR VPWR _6484_/Y sky130_fd_sc_hd__nand2_2
X_5504_ _5504_/A _5504_/B VGND VGND VPWR VPWR _5504_/Y sky130_fd_sc_hd__nand2_2
X_3696_ _6016_/D _6014_/D _3851_/B _5948_/A VGND VGND VPWR VPWR _3696_/X sky130_fd_sc_hd__and4_2
X_5435_ _5377_/A _5377_/Y _5432_/X _5434_/Y VGND VGND VPWR VPWR _5437_/B sky130_fd_sc_hd__a211o_2
X_5366_ _6673_/A2 _5399_/B _5278_/A _5276_/Y VGND VGND VPWR VPWR _5367_/C sky130_fd_sc_hd__o2bb2a_2
XFILLER_59_237 VGND VGND VPWR VPWR sky130_fd_sc_hd__decap_3
XFILLER_87_546 VGND VGND VPWR VPWR sky130_fd_sc_hd__decap_3
X_5297_ _5296_/A _5296_/B _5296_/C VGND VGND VPWR VPWR _5298_/B sky130_fd_sc_hd__a21oi_2
X_4317_ _4259_/X _4313_/B _4314_/Y _4316_/X VGND VGND VPWR VPWR _4327_/A sky130_fd_sc_hd__a211o_2
XFILLER_19_25 VGND VGND VPWR VPWR sky130_fd_sc_hd__fill_1
X_4248_ _4248_/A _4248_/B VGND VGND VPWR VPWR _4249_/C sky130_fd_sc_hd__xnor2_2
XFILLER_67_281 VGND VGND VPWR VPWR sky130_fd_sc_hd__decap_3
X_4179_ _4551_/A _4539_/B _3773_/A _3771_/Y VGND VGND VPWR VPWR _4180_/B sky130_fd_sc_hd__o2bb2a_2
XTAP_TAPCELL_ROW_2_233 VGND VPWR sky130_fd_sc_hd__tapvpwrvgnd_1
XFILLER_15_318 VGND VGND VPWR VPWR sky130_fd_sc_hd__decap_3
XFILLER_27_178 VGND VGND VPWR VPWR sky130_fd_sc_hd__fill_2
XFILLER_70_424 VGND VGND VPWR VPWR sky130_fd_sc_hd__fill_2
XFILLER_82_284 VGND VGND VPWR VPWR sky130_fd_sc_hd__decap_3
XFILLER_23_340 VGND VGND VPWR VPWR sky130_fd_sc_hd__decap_3
XFILLER_35_68 VGND VGND VPWR VPWR sky130_fd_sc_hd__decap_3
XFILLER_23_362 VGND VGND VPWR VPWR sky130_fd_sc_hd__decap_3
XFILLER_23_384 VGND VGND VPWR VPWR sky130_fd_sc_hd__decap_3
XFILLER_11_535 VGND VGND VPWR VPWR sky130_fd_sc_hd__fill_2
XPHY_EDGE_ROW_14_Right_14 VGND VGND VPWR VPWR sky130_fd_sc_hd__decap_3
Xwire437 _4608_/B VGND VGND VPWR VPWR _4264_/B sky130_fd_sc_hd__clkbuf_4
XFILLER_78_513 VGND VGND VPWR VPWR sky130_fd_sc_hd__decap_3
XPHY_EDGE_ROW_23_Right_23 VGND VGND VPWR VPWR sky130_fd_sc_hd__decap_3
XFILLER_93_505 VGND VGND VPWR VPWR sky130_fd_sc_hd__decap_3
Xfanout570 _4006_/A VGND VGND VPWR VPWR wire571/A sky130_fd_sc_hd__clkdlybuf4s25_1
Xfanout581 _6552_/A3 VGND VGND VPWR VPWR _5547_/A sky130_fd_sc_hd__dlymetal6s4s_1
Xfanout592 input21/X VGND VGND VPWR VPWR _3872_/A sky130_fd_sc_hd__clkdlybuf4s25_1
XFILLER_46_410 VGND VGND VPWR VPWR sky130_fd_sc_hd__decap_3
XFILLER_46_421 VGND VGND VPWR VPWR sky130_fd_sc_hd__decap_3
XFILLER_46_454 VGND VGND VPWR VPWR sky130_fd_sc_hd__decap_3
XFILLER_73_262 VGND VGND VPWR VPWR sky130_fd_sc_hd__decap_3
XFILLER_61_424 VGND VGND VPWR VPWR sky130_fd_sc_hd__decap_3
XFILLER_73_284 VGND VGND VPWR VPWR sky130_fd_sc_hd__decap_3
XPHY_EDGE_ROW_1_Left_102 VGND VGND VPWR VPWR sky130_fd_sc_hd__decap_3
XFILLER_33_159 VGND VGND VPWR VPWR sky130_fd_sc_hd__fill_2
XFILLER_92_85 VGND VGND VPWR VPWR sky130_fd_sc_hd__decap_3
XTAP_TAPCELL_ROW_72_975 VGND VPWR sky130_fd_sc_hd__tapvpwrvgnd_1
XPHY_EDGE_ROW_38_Left_139 VGND VGND VPWR VPWR sky130_fd_sc_hd__decap_3
XPHY_EDGE_ROW_32_Right_32 VGND VGND VPWR VPWR sky130_fd_sc_hd__decap_3
XTAP_TAPCELL_ROW_44_677 VGND VPWR sky130_fd_sc_hd__tapvpwrvgnd_1
XFILLER_14_384 VGND VGND VPWR VPWR sky130_fd_sc_hd__decap_3
XTAP_TAPCELL_ROW_99_1259 VGND VPWR sky130_fd_sc_hd__tapvpwrvgnd_1
X_3550_ _3550_/A _3550_/B _3969_/B _3969_/D VGND VGND VPWR VPWR _3553_/A sky130_fd_sc_hd__nand4_2
X_5220_ _5220_/A1 _5217_/X _5448_/A _5200_/Y VGND VGND VPWR VPWR _5237_/B sky130_fd_sc_hd__o211ai_2
XPHY_EDGE_ROW_47_Left_148 VGND VGND VPWR VPWR sky130_fd_sc_hd__decap_3
XFILLER_44_3 VGND VGND VPWR VPWR sky130_fd_sc_hd__decap_3
XPHY_EDGE_ROW_41_Right_41 VGND VGND VPWR VPWR sky130_fd_sc_hd__decap_3
X_5151_ _5268_/C _5151_/B _5151_/C _5266_/D VGND VGND VPWR VPWR _5151_/X sky130_fd_sc_hd__and4_2
XFILLER_96_321 VGND VGND VPWR VPWR sky130_fd_sc_hd__decap_3
XFILLER_69_579 VGND VGND VPWR VPWR sky130_fd_sc_hd__decap_3
X_5082_ _5166_/B VGND VGND VPWR VPWR _5082_/Y sky130_fd_sc_hd__inv_2
X_4102_ _4102_/A _4102_/B VGND VGND VPWR VPWR _4209_/A sky130_fd_sc_hd__xnor2_2
XFILLER_56_207 VGND VGND VPWR VPWR sky130_fd_sc_hd__decap_3
XFILLER_84_527 VGND VGND VPWR VPWR sky130_fd_sc_hd__decap_3
X_4033_ _4043_/A _4043_/B VGND VGND VPWR VPWR _4035_/B sky130_fd_sc_hd__and2b_2
XFILLER_96_398 VGND VGND VPWR VPWR sky130_fd_sc_hd__decap_3
XFILLER_96_365 VGND VGND VPWR VPWR sky130_fd_sc_hd__fill_1
XFILLER_49_270 VGND VGND VPWR VPWR sky130_fd_sc_hd__decap_3
XFILLER_49_281 VGND VGND VPWR VPWR sky130_fd_sc_hd__decap_3
XFILLER_37_465 VGND VGND VPWR VPWR sky130_fd_sc_hd__decap_3
XFILLER_64_251 VGND VGND VPWR VPWR sky130_fd_sc_hd__fill_1
XFILLER_64_262 VGND VGND VPWR VPWR sky130_fd_sc_hd__decap_3
XPHY_EDGE_ROW_56_Left_157 VGND VGND VPWR VPWR sky130_fd_sc_hd__decap_3
XPHY_EDGE_ROW_50_Right_50 VGND VGND VPWR VPWR sky130_fd_sc_hd__decap_3
XFILLER_24_137 VGND VGND VPWR VPWR sky130_fd_sc_hd__decap_3
X_5984_ _5984_/A _5984_/B _5984_/C _5984_/D VGND VGND VPWR VPWR _5984_/X sky130_fd_sc_hd__and4_2
X_4935_ _4935_/A _4935_/B VGND VGND VPWR VPWR _5015_/B sky130_fd_sc_hd__xnor2_2
XFILLER_32_170 VGND VGND VPWR VPWR sky130_fd_sc_hd__fill_1
X_4866_ _4862_/Y _4864_/X _4816_/Y _4818_/X VGND VGND VPWR VPWR _4868_/B sky130_fd_sc_hd__o211ai_2
X_6605_ _6110_/A _6605_/A2 _6506_/B _6381_/A _6604_/X VGND VGND VPWR VPWR _6605_/X
+ sky130_fd_sc_hd__o221a_2
X_4797_ _4797_/A _4797_/B VGND VGND VPWR VPWR _4800_/B sky130_fd_sc_hd__xnor2_2
X_3817_ _3817_/A _3817_/B VGND VGND VPWR VPWR _3819_/B sky130_fd_sc_hd__xnor2_2
XFILLER_20_387 VGND VGND VPWR VPWR sky130_fd_sc_hd__decap_3
X_6536_ _6536_/A _6536_/B VGND VGND VPWR VPWR _6539_/A sky130_fd_sc_hd__nand2_2
X_3748_ _3748_/A input8/X _4662_/C _4662_/D VGND VGND VPWR VPWR _3748_/X sky130_fd_sc_hd__and4_2
XFILLER_4_509 VGND VGND VPWR VPWR sky130_fd_sc_hd__decap_3
XTAP_TAPCELL_ROW_76_1012 VGND VPWR sky130_fd_sc_hd__tapvpwrvgnd_1
XPHY_EDGE_ROW_65_Left_166 VGND VGND VPWR VPWR sky130_fd_sc_hd__decap_3
X_6467_ _6467_/A _6467_/B VGND VGND VPWR VPWR _6472_/A sky130_fd_sc_hd__nor2_2
X_3679_ _3679_/A _4407_/B VGND VGND VPWR VPWR _3683_/A sky130_fd_sc_hd__nand2_2
X_6398_ _6286_/B _6397_/S _5962_/A VGND VGND VPWR VPWR _6569_/C sky130_fd_sc_hd__o21ai_2
X_5418_ _5418_/A _5418_/B VGND VGND VPWR VPWR _5420_/B sky130_fd_sc_hd__xnor2_2
XFILLER_87_310 VGND VGND VPWR VPWR sky130_fd_sc_hd__decap_3
X_5349_ _5349_/A _5349_/B _5349_/C VGND VGND VPWR VPWR _5428_/A sky130_fd_sc_hd__nand3_2
XFILLER_87_354 VGND VGND VPWR VPWR sky130_fd_sc_hd__fill_2
XFILLER_75_505 VGND VGND VPWR VPWR sky130_fd_sc_hd__decap_3
XFILLER_87_376 VGND VGND VPWR VPWR sky130_fd_sc_hd__decap_3
XFILLER_28_421 VGND VGND VPWR VPWR sky130_fd_sc_hd__decap_3
XFILLER_28_454 VGND VGND VPWR VPWR sky130_fd_sc_hd__decap_3
XFILLER_55_251 VGND VGND VPWR VPWR sky130_fd_sc_hd__decap_3
XFILLER_90_508 VGND VGND VPWR VPWR sky130_fd_sc_hd__decap_3
XTAP_TAPCELL_ROW_87_1130 VGND VPWR sky130_fd_sc_hd__tapvpwrvgnd_1
XPHY_EDGE_ROW_74_Left_175 VGND VGND VPWR VPWR sky130_fd_sc_hd__decap_3
XFILLER_43_402 VGND VGND VPWR VPWR sky130_fd_sc_hd__decap_3
XFILLER_55_273 VGND VGND VPWR VPWR sky130_fd_sc_hd__decap_3
XFILLER_83_593 VGND VGND VPWR VPWR sky130_fd_sc_hd__decap_3
XFILLER_70_221 VGND VGND VPWR VPWR sky130_fd_sc_hd__decap_3
XFILLER_70_243 VGND VGND VPWR VPWR sky130_fd_sc_hd__decap_3
XFILLER_70_265 VGND VGND VPWR VPWR sky130_fd_sc_hd__decap_3
XFILLER_11_321 VGND VGND VPWR VPWR sky130_fd_sc_hd__fill_2
XFILLER_30_129 VGND VGND VPWR VPWR sky130_fd_sc_hd__decap_3
XFILLER_62_77 VGND VGND VPWR VPWR sky130_fd_sc_hd__decap_3
XFILLER_62_88 VGND VGND VPWR VPWR sky130_fd_sc_hd__decap_3
XTAP_TAPCELL_ROW_41_647 VGND VPWR sky130_fd_sc_hd__tapvpwrvgnd_1
XTAP_TAPCELL_ROW_13_349 VGND VPWR sky130_fd_sc_hd__tapvpwrvgnd_1
XFILLER_11_365 VGND VGND VPWR VPWR sky130_fd_sc_hd__decap_3
XPHY_EDGE_ROW_83_Left_184 VGND VGND VPWR VPWR sky130_fd_sc_hd__decap_3
XFILLER_87_41 VGND VGND VPWR VPWR sky130_fd_sc_hd__decap_3
XFILLER_78_321 VGND VGND VPWR VPWR sky130_fd_sc_hd__decap_3
XFILLER_78_343 VGND VGND VPWR VPWR sky130_fd_sc_hd__decap_3
XFILLER_78_365 VGND VGND VPWR VPWR sky130_fd_sc_hd__decap_3
XFILLER_87_96 VGND VGND VPWR VPWR sky130_fd_sc_hd__decap_3
XFILLER_93_302 VGND VGND VPWR VPWR sky130_fd_sc_hd__decap_3
XFILLER_19_432 VGND VGND VPWR VPWR sky130_fd_sc_hd__decap_3
XFILLER_93_324 VGND VGND VPWR VPWR sky130_fd_sc_hd__decap_3
XFILLER_93_346 VGND VGND VPWR VPWR sky130_fd_sc_hd__decap_3
XTAP_TAPCELL_ROW_49_736 VGND VPWR sky130_fd_sc_hd__tapvpwrvgnd_1
XPHY_EDGE_ROW_92_Left_193 VGND VGND VPWR VPWR sky130_fd_sc_hd__decap_3
XFILLER_46_240 VGND VGND VPWR VPWR sky130_fd_sc_hd__fill_2
XFILLER_81_508 VGND VGND VPWR VPWR sky130_fd_sc_hd__fill_1
XFILLER_19_476 VGND VGND VPWR VPWR sky130_fd_sc_hd__decap_3
XFILLER_34_402 VGND VGND VPWR VPWR sky130_fd_sc_hd__decap_3
XFILLER_61_221 VGND VGND VPWR VPWR sky130_fd_sc_hd__decap_3
XFILLER_61_243 VGND VGND VPWR VPWR sky130_fd_sc_hd__decap_3
XFILLER_61_265 VGND VGND VPWR VPWR sky130_fd_sc_hd__decap_3
XFILLER_14_181 VGND VGND VPWR VPWR sky130_fd_sc_hd__fill_1
X_4720_ _4719_/B _4719_/C _4719_/A VGND VGND VPWR VPWR _4722_/B sky130_fd_sc_hd__o21bai_2
X_4651_ _4651_/A _5018_/B VGND VGND VPWR VPWR _4689_/A sky130_fd_sc_hd__nand2_2
Xinput20 A[27] VGND VGND VPWR VPWR input20/X sky130_fd_sc_hd__clkdlybuf4s25_1
Xinput31 A[8] VGND VGND VPWR VPWR wire496/A sky130_fd_sc_hd__clkbuf_2
X_3602_ _3602_/A _3602_/B VGND VGND VPWR VPWR _3613_/A sky130_fd_sc_hd__xnor2_2
Xinput64 B[9] VGND VGND VPWR VPWR _6016_/C sky130_fd_sc_hd__clkbuf_4
Xinput53 B[28] VGND VGND VPWR VPWR _4003_/C sky130_fd_sc_hd__buf_1
Xinput42 B[18] VGND VGND VPWR VPWR input42/X sky130_fd_sc_hd__dlymetal6s4s_1
X_4582_ _4579_/X _4582_/B VGND VGND VPWR VPWR _4783_/B sky130_fd_sc_hd__and2b_2
X_6321_ _6319_/X _6320_/Y _6893_/S VGND VGND VPWR VPWR _6321_/X sky130_fd_sc_hd__mux2_1
X_3533_ _3868_/A _3765_/B _3729_/B _3532_/A VGND VGND VPWR VPWR _4204_/A sky130_fd_sc_hd__a31o_2
X_6252_ _6787_/A _6787_/B VGND VGND VPWR VPWR _6252_/Y sky130_fd_sc_hd__nor2_2
XFILLER_88_107 VGND VGND VPWR VPWR sky130_fd_sc_hd__fill_1
XFILLER_88_129 VGND VGND VPWR VPWR sky130_fd_sc_hd__fill_2
X_6183_ _6192_/A _6878_/A VGND VGND VPWR VPWR _6190_/C sky130_fd_sc_hd__nand2_2
X_5203_ _5204_/A _5202_/Y _5311_/A _5203_/D VGND VGND VPWR VPWR _5295_/A sky130_fd_sc_hd__and4bb_2
X_5134_ _5134_/A _5134_/B VGND VGND VPWR VPWR _6114_/A sky130_fd_sc_hd__and2_2
XFILLER_57_505 VGND VGND VPWR VPWR sky130_fd_sc_hd__decap_3
XFILLER_84_302 VGND VGND VPWR VPWR sky130_fd_sc_hd__decap_3
XFILLER_84_346 VGND VGND VPWR VPWR sky130_fd_sc_hd__decap_3
X_5065_ _6248_/B _5452_/B VGND VGND VPWR VPWR _5080_/A sky130_fd_sc_hd__nand2_2
XFILLER_84_368 VGND VGND VPWR VPWR sky130_fd_sc_hd__decap_3
X_4016_ _4016_/A _4016_/B _4016_/C VGND VGND VPWR VPWR _4018_/A sky130_fd_sc_hd__nor3_2
XFILLER_25_446 VGND VGND VPWR VPWR sky130_fd_sc_hd__fill_2
XFILLER_52_221 VGND VGND VPWR VPWR sky130_fd_sc_hd__decap_3
XFILLER_52_243 VGND VGND VPWR VPWR sky130_fd_sc_hd__fill_2
XFILLER_80_530 VGND VGND VPWR VPWR sky130_fd_sc_hd__fill_2
XFILLER_25_468 VGND VGND VPWR VPWR sky130_fd_sc_hd__fill_2
XFILLER_40_416 VGND VGND VPWR VPWR sky130_fd_sc_hd__decap_3
X_5967_ _3868_/A _3868_/B _3878_/B _3877_/A VGND VGND VPWR VPWR _5968_/B sky130_fd_sc_hd__a31o_2
XFILLER_12_129 VGND VGND VPWR VPWR sky130_fd_sc_hd__decap_3
XFILLER_52_287 VGND VGND VPWR VPWR sky130_fd_sc_hd__decap_3
X_4918_ _4915_/Y _4916_/X _4878_/Y _4880_/Y VGND VGND VPWR VPWR _4918_/X sky130_fd_sc_hd__o211a_2
XTAP_TAPCELL_ROW_82_1082 VGND VPWR sky130_fd_sc_hd__tapvpwrvgnd_1
X_5898_ _4907_/X _4911_/C _5896_/A _5897_/X VGND VGND VPWR VPWR _5898_/X sky130_fd_sc_hd__a211o_2
X_4849_ _4848_/B _4848_/C _4848_/A VGND VGND VPWR VPWR _4849_/Y sky130_fd_sc_hd__a21oi_2
XTAP_TAPCELL_ROW_10_319 VGND VPWR sky130_fd_sc_hd__tapvpwrvgnd_1
XFILLER_4_306 VGND VGND VPWR VPWR sky130_fd_sc_hd__fill_2
X_6519_ _6227_/B _6227_/C _6381_/C VGND VGND VPWR VPWR _6520_/C sky130_fd_sc_hd__a21o_2
XFILLER_79_118 VGND VGND VPWR VPWR sky130_fd_sc_hd__decap_3
XFILLER_0_545 VGND VGND VPWR VPWR sky130_fd_sc_hd__decap_3
XFILLER_0_567 VGND VGND VPWR VPWR sky130_fd_sc_hd__decap_3
XFILLER_0_589 VGND VGND VPWR VPWR sky130_fd_sc_hd__decap_3
XFILLER_87_162 VGND VGND VPWR VPWR sky130_fd_sc_hd__decap_3
XFILLER_57_66 VGND VGND VPWR VPWR sky130_fd_sc_hd__decap_3
XFILLER_87_195 VGND VGND VPWR VPWR sky130_fd_sc_hd__decap_3
XFILLER_57_99 VGND VGND VPWR VPWR sky130_fd_sc_hd__decap_3
XFILLER_63_519 VGND VGND VPWR VPWR sky130_fd_sc_hd__decap_3
XFILLER_75_368 VGND VGND VPWR VPWR sky130_fd_sc_hd__decap_3
XFILLER_16_402 VGND VGND VPWR VPWR sky130_fd_sc_hd__decap_3
XFILLER_16_424 VGND VGND VPWR VPWR sky130_fd_sc_hd__fill_2
XFILLER_28_273 VGND VGND VPWR VPWR sky130_fd_sc_hd__decap_3
XFILLER_90_316 VGND VGND VPWR VPWR sky130_fd_sc_hd__decap_3
XTAP_TAPCELL_ROW_18_408 VGND VPWR sky130_fd_sc_hd__tapvpwrvgnd_1
XFILLER_71_585 VGND VGND VPWR VPWR sky130_fd_sc_hd__decap_3
XFILLER_31_449 VGND VGND VPWR VPWR sky130_fd_sc_hd__decap_3
XTAP_TAPCELL_ROW_54_783 VGND VPWR sky130_fd_sc_hd__tapvpwrvgnd_1
XTAP_TAPCELL_ROW_26_485 VGND VPWR sky130_fd_sc_hd__tapvpwrvgnd_1
XFILLER_11_151 VGND VGND VPWR VPWR sky130_fd_sc_hd__decap_3
XFILLER_7_111 VGND VGND VPWR VPWR sky130_fd_sc_hd__fill_1
XFILLER_7_155 VGND VGND VPWR VPWR sky130_fd_sc_hd__decap_3
XTAP_TAPCELL_ROW_96_1229 VGND VPWR sky130_fd_sc_hd__tapvpwrvgnd_1
XFILLER_7_188 VGND VGND VPWR VPWR sky130_fd_sc_hd__decap_3
XFILLER_3_350 VGND VGND VPWR VPWR sky130_fd_sc_hd__fill_1
XFILLER_3_372 VGND VGND VPWR VPWR sky130_fd_sc_hd__decap_3
XFILLER_39_505 VGND VGND VPWR VPWR sky130_fd_sc_hd__decap_3
XFILLER_78_162 VGND VGND VPWR VPWR sky130_fd_sc_hd__fill_1
XFILLER_39_527 VGND VGND VPWR VPWR sky130_fd_sc_hd__decap_3
XFILLER_66_324 VGND VGND VPWR VPWR sky130_fd_sc_hd__decap_3
XFILLER_78_184 VGND VGND VPWR VPWR sky130_fd_sc_hd__decap_3
XFILLER_81_305 VGND VGND VPWR VPWR sky130_fd_sc_hd__decap_3
XFILLER_93_165 VGND VGND VPWR VPWR sky130_fd_sc_hd__decap_3
XFILLER_93_187 VGND VGND VPWR VPWR sky130_fd_sc_hd__decap_3
XFILLER_34_221 VGND VGND VPWR VPWR sky130_fd_sc_hd__decap_3
XFILLER_34_243 VGND VGND VPWR VPWR sky130_fd_sc_hd__fill_1
XFILLER_62_552 VGND VGND VPWR VPWR sky130_fd_sc_hd__decap_3
XFILLER_81_349 VGND VGND VPWR VPWR sky130_fd_sc_hd__decap_3
X_6870_ _6841_/A _6857_/Y _6869_/X VGND VGND VPWR VPWR _6992_/B sky130_fd_sc_hd__o21bai_2
XFILLER_34_276 VGND VGND VPWR VPWR sky130_fd_sc_hd__decap_3
X_5821_ _5820_/Y _6705_/B1 _5570_/Y VGND VGND VPWR VPWR _6739_/A sky130_fd_sc_hd__a21o_4
X_5752_ _5752_/A _5752_/B _5752_/C VGND VGND VPWR VPWR _5752_/X sky130_fd_sc_hd__and3_2
X_4703_ _4965_/A _5203_/D VGND VGND VPWR VPWR _4708_/A sky130_fd_sc_hd__nand2_2
XFILLER_30_460 VGND VGND VPWR VPWR sky130_fd_sc_hd__decap_3
X_5683_ _5685_/A _5685_/B VGND VGND VPWR VPWR _5683_/Y sky130_fd_sc_hd__nand2b_2
XFILLER_30_493 VGND VGND VPWR VPWR sky130_fd_sc_hd__decap_3
XFILLER_8_71 VGND VGND VPWR VPWR sky130_fd_sc_hd__fill_1
X_4634_ _4634_/A _4634_/B _4925_/C _4685_/D VGND VGND VPWR VPWR _4637_/A sky130_fd_sc_hd__and4_2
X_4565_ _4565_/A _4565_/B VGND VGND VPWR VPWR _4567_/B sky130_fd_sc_hd__nor2_2
X_6304_ _5019_/A _6358_/A2 _6375_/A VGND VGND VPWR VPWR _6447_/A sky130_fd_sc_hd__o21a_2
X_3516_ _3517_/A _3517_/B VGND VGND VPWR VPWR _3880_/A sky130_fd_sc_hd__and2_2
X_4496_ _4471_/Y _4472_/X _4491_/Y _4883_/A VGND VGND VPWR VPWR _4497_/C sky130_fd_sc_hd__o211ai_2
XPHY_EDGE_ROW_4_Right_4 VGND VGND VPWR VPWR sky130_fd_sc_hd__decap_3
X_6235_ _6381_/A _6215_/Y _6234_/X _3497_/Y _6110_/A VGND VGND VPWR VPWR _6235_/Y
+ sky130_fd_sc_hd__a32oi_2
XFILLER_69_140 VGND VGND VPWR VPWR sky130_fd_sc_hd__decap_3
XFILLER_69_162 VGND VGND VPWR VPWR sky130_fd_sc_hd__decap_3
X_6166_ _6842_/B _6166_/B VGND VGND VPWR VPWR _6261_/C sky130_fd_sc_hd__nand2_2
XFILLER_69_184 VGND VGND VPWR VPWR sky130_fd_sc_hd__decap_3
X_6097_ _6098_/A _6098_/B VGND VGND VPWR VPWR _6097_/Y sky130_fd_sc_hd__nor2_2
X_5117_ _5117_/A _5117_/B _5117_/C VGND VGND VPWR VPWR _5194_/A sky130_fd_sc_hd__nand3_2
XFILLER_45_508 VGND VGND VPWR VPWR sky130_fd_sc_hd__decap_3
XFILLER_57_346 VGND VGND VPWR VPWR sky130_fd_sc_hd__decap_3
X_5048_ _5311_/A _5341_/C _5341_/D _5046_/B VGND VGND VPWR VPWR _5049_/B sky130_fd_sc_hd__a22o_2
XFILLER_57_379 VGND VGND VPWR VPWR sky130_fd_sc_hd__decap_3
XTAP_TAPCELL_ROW_84_1100 VGND VPWR sky130_fd_sc_hd__tapvpwrvgnd_1
XFILLER_25_221 VGND VGND VPWR VPWR sky130_fd_sc_hd__decap_3
XFILLER_13_405 VGND VGND VPWR VPWR sky130_fd_sc_hd__decap_3
XFILLER_80_360 VGND VGND VPWR VPWR sky130_fd_sc_hd__decap_3
XFILLER_13_449 VGND VGND VPWR VPWR sky130_fd_sc_hd__decap_3
XFILLER_25_287 VGND VGND VPWR VPWR sky130_fd_sc_hd__decap_3
XFILLER_80_371 VGND VGND VPWR VPWR sky130_fd_sc_hd__decap_3
X_6999_ _6999_/A _6999_/B VGND VGND VPWR VPWR _6999_/Y sky130_fd_sc_hd__nand2_2
XFILLER_40_246 VGND VGND VPWR VPWR sky130_fd_sc_hd__decap_3
XFILLER_40_268 VGND VGND VPWR VPWR sky130_fd_sc_hd__decap_3
XFILLER_43_68 VGND VGND VPWR VPWR sky130_fd_sc_hd__decap_3
XTAP_TAPCELL_ROW_51_753 VGND VPWR sky130_fd_sc_hd__tapvpwrvgnd_1
XTAP_TAPCELL_ROW_23_455 VGND VPWR sky130_fd_sc_hd__tapvpwrvgnd_1
Xrebuffer731 _5433_/Y VGND VGND VPWR VPWR _5461_/C1 sky130_fd_sc_hd__buf_2
Xrebuffer742 _5826_/B VGND VGND VPWR VPWR _5827_/A1 sky130_fd_sc_hd__buf_2
XFILLER_4_103 VGND VGND VPWR VPWR sky130_fd_sc_hd__decap_3
Xrebuffer753 _5328_/C VGND VGND VPWR VPWR _5134_/B sky130_fd_sc_hd__buf_2
Xrebuffer764 _4762_/X VGND VGND VPWR VPWR _4974_/C1 sky130_fd_sc_hd__buf_2
XFILLER_4_125 VGND VGND VPWR VPWR sky130_fd_sc_hd__decap_3
XFILLER_4_29 VGND VGND VPWR VPWR sky130_fd_sc_hd__fill_2
XFILLER_68_76 VGND VGND VPWR VPWR sky130_fd_sc_hd__decap_3
XFILLER_95_419 VGND VGND VPWR VPWR sky130_fd_sc_hd__fill_1
XFILLER_0_375 VGND VGND VPWR VPWR sky130_fd_sc_hd__decap_3
XFILLER_88_471 VGND VGND VPWR VPWR sky130_fd_sc_hd__decap_3
XFILLER_88_493 VGND VGND VPWR VPWR sky130_fd_sc_hd__decap_3
XFILLER_75_132 VGND VGND VPWR VPWR sky130_fd_sc_hd__decap_3
XFILLER_48_379 VGND VGND VPWR VPWR sky130_fd_sc_hd__fill_1
XFILLER_63_305 VGND VGND VPWR VPWR sky130_fd_sc_hd__decap_3
XFILLER_90_102 VGND VGND VPWR VPWR sky130_fd_sc_hd__decap_3
XFILLER_63_349 VGND VGND VPWR VPWR sky130_fd_sc_hd__decap_3
XFILLER_44_563 VGND VGND VPWR VPWR sky130_fd_sc_hd__fill_1
XFILLER_90_157 VGND VGND VPWR VPWR sky130_fd_sc_hd__decap_3
XFILLER_16_276 VGND VGND VPWR VPWR sky130_fd_sc_hd__decap_3
XFILLER_31_268 VGND VGND VPWR VPWR sky130_fd_sc_hd__fill_2
XFILLER_12_460 VGND VGND VPWR VPWR sky130_fd_sc_hd__decap_3
XTAP_TAPCELL_ROW_100_1277 VGND VPWR sky130_fd_sc_hd__tapvpwrvgnd_1
XTAP_TAPCELL_ROW_100_1266 VGND VPWR sky130_fd_sc_hd__tapvpwrvgnd_1
XFILLER_8_464 VGND VGND VPWR VPWR sky130_fd_sc_hd__decap_3
X_4350_ _4350_/A _4350_/B _4350_/C VGND VGND VPWR VPWR _4350_/X sky130_fd_sc_hd__and3_4
X_4281_ _4406_/B _4406_/C _4406_/D _4280_/B VGND VGND VPWR VPWR _4282_/D sky130_fd_sc_hd__a22o_2
XFILLER_86_419 VGND VGND VPWR VPWR sky130_fd_sc_hd__fill_1
X_6020_ _6021_/A _6021_/B _6021_/C _6021_/D VGND VGND VPWR VPWR _6020_/X sky130_fd_sc_hd__o22a_2
XFILLER_98_268 VGND VGND VPWR VPWR sky130_fd_sc_hd__decap_3
XFILLER_79_482 VGND VGND VPWR VPWR sky130_fd_sc_hd__decap_3
XFILLER_39_357 VGND VGND VPWR VPWR sky130_fd_sc_hd__fill_1
XFILLER_94_463 VGND VGND VPWR VPWR sky130_fd_sc_hd__decap_3
XFILLER_94_430 VGND VGND VPWR VPWR sky130_fd_sc_hd__decap_3
XFILLER_66_165 VGND VGND VPWR VPWR sky130_fd_sc_hd__decap_3
XFILLER_81_113 VGND VGND VPWR VPWR sky130_fd_sc_hd__decap_3
XFILLER_94_496 VGND VGND VPWR VPWR sky130_fd_sc_hd__fill_1
XFILLER_54_349 VGND VGND VPWR VPWR sky130_fd_sc_hd__decap_3
X_6922_ _6921_/A _6921_/C _6921_/B VGND VGND VPWR VPWR _6923_/C sky130_fd_sc_hd__o21ai_2
X_6853_ _6853_/A _6853_/B _6852_/X VGND VGND VPWR VPWR _6853_/X sky130_fd_sc_hd__or3b_2
XFILLER_50_533 VGND VGND VPWR VPWR sky130_fd_sc_hd__decap_3
X_5804_ _6514_/A _6514_/B _6515_/A VGND VGND VPWR VPWR _5804_/X sky130_fd_sc_hd__a21o_2
XFILLER_22_235 VGND VGND VPWR VPWR sky130_fd_sc_hd__decap_3
XFILLER_50_544 VGND VGND VPWR VPWR sky130_fd_sc_hd__decap_3
X_6784_ _6640_/X _6944_/B1 _6783_/X _6372_/B VGND VGND VPWR VPWR _6785_/C sky130_fd_sc_hd__a22oi_2
X_3996_ _6196_/A _3996_/B VGND VGND VPWR VPWR _4024_/A sky130_fd_sc_hd__nand2_2
X_5735_ _5735_/A _5735_/B VGND VGND VPWR VPWR _5769_/B sky130_fd_sc_hd__xor2_2
X_5666_ _5626_/A _5626_/C _5626_/B VGND VGND VPWR VPWR _5667_/C sky130_fd_sc_hd__a21o_2
XTAP_TAPCELL_ROW_20_425 VGND VPWR sky130_fd_sc_hd__tapvpwrvgnd_1
X_4617_ _4617_/A _4617_/B VGND VGND VPWR VPWR _4632_/A sky130_fd_sc_hd__nand2_2
X_5597_ _6109_/A _6401_/S _5598_/B VGND VGND VPWR VPWR _5597_/X sky130_fd_sc_hd__and3_2
XFILLER_1_106 VGND VGND VPWR VPWR sky130_fd_sc_hd__decap_3
X_4548_ _4549_/B _4897_/A _4549_/A VGND VGND VPWR VPWR _4550_/A sky130_fd_sc_hd__o21a_2
XFILLER_89_246 VGND VGND VPWR VPWR sky130_fd_sc_hd__decap_3
X_4479_ _4476_/A _4476_/B _4478_/B _4475_/X VGND VGND VPWR VPWR _4481_/B sky130_fd_sc_hd__a31o_2
XFILLER_77_408 VGND VGND VPWR VPWR sky130_fd_sc_hd__decap_3
X_6218_ _6218_/A VGND VGND VPWR VPWR _6218_/Y sky130_fd_sc_hd__inv_2
XFILLER_38_68 VGND VGND VPWR VPWR sky130_fd_sc_hd__decap_3
XFILLER_57_132 VGND VGND VPWR VPWR sky130_fd_sc_hd__decap_3
XFILLER_85_452 VGND VGND VPWR VPWR sky130_fd_sc_hd__decap_3
X_6149_ _6150_/A _6717_/A VGND VGND VPWR VPWR _6384_/B sky130_fd_sc_hd__nor2_2
XFILLER_57_165 VGND VGND VPWR VPWR sky130_fd_sc_hd__decap_3
XFILLER_57_187 VGND VGND VPWR VPWR sky130_fd_sc_hd__decap_3
XFILLER_72_102 VGND VGND VPWR VPWR sky130_fd_sc_hd__fill_2
XTAP_TAPCELL_ROW_56_801 VGND VPWR sky130_fd_sc_hd__tapvpwrvgnd_1
XTAP_TAPCELL_ROW_28_514 VGND VPWR sky130_fd_sc_hd__tapvpwrvgnd_1
XPHY_EDGE_ROW_79_Right_79 VGND VGND VPWR VPWR sky130_fd_sc_hd__decap_3
XFILLER_26_530 VGND VGND VPWR VPWR sky130_fd_sc_hd__fill_2
XFILLER_26_563 VGND VGND VPWR VPWR sky130_fd_sc_hd__decap_3
XFILLER_54_56 VGND VGND VPWR VPWR sky130_fd_sc_hd__decap_3
XFILLER_13_202 VGND VGND VPWR VPWR sky130_fd_sc_hd__fill_1
XFILLER_26_585 VGND VGND VPWR VPWR sky130_fd_sc_hd__decap_3
XFILLER_41_511 VGND VGND VPWR VPWR sky130_fd_sc_hd__fill_2
XFILLER_53_371 VGND VGND VPWR VPWR sky130_fd_sc_hd__decap_3
XFILLER_13_246 VGND VGND VPWR VPWR sky130_fd_sc_hd__decap_3
XTAP_TAPCELL_ROW_36_591 VGND VPWR sky130_fd_sc_hd__tapvpwrvgnd_1
XFILLER_70_22 VGND VGND VPWR VPWR sky130_fd_sc_hd__decap_3
XFILLER_5_401 VGND VGND VPWR VPWR sky130_fd_sc_hd__fill_2
XPHY_EDGE_ROW_88_Right_88 VGND VGND VPWR VPWR sky130_fd_sc_hd__decap_3
XFILLER_5_489 VGND VGND VPWR VPWR sky130_fd_sc_hd__decap_3
XFILLER_79_53 VGND VGND VPWR VPWR sky130_fd_sc_hd__decap_3
XFILLER_79_97 VGND VGND VPWR VPWR sky130_fd_sc_hd__decap_3
XFILLER_0_172 VGND VGND VPWR VPWR sky130_fd_sc_hd__fill_2
XFILLER_0_194 VGND VGND VPWR VPWR sky130_fd_sc_hd__fill_2
XFILLER_48_121 VGND VGND VPWR VPWR sky130_fd_sc_hd__fill_2
XFILLER_88_290 VGND VGND VPWR VPWR sky130_fd_sc_hd__decap_3
XPHY_EDGE_ROW_97_Right_97 VGND VGND VPWR VPWR sky130_fd_sc_hd__decap_3
XFILLER_95_249 VGND VGND VPWR VPWR sky130_fd_sc_hd__decap_3
XFILLER_36_305 VGND VGND VPWR VPWR sky130_fd_sc_hd__decap_3
XFILLER_48_154 VGND VGND VPWR VPWR sky130_fd_sc_hd__fill_1
XFILLER_91_400 VGND VGND VPWR VPWR sky130_fd_sc_hd__decap_3
XFILLER_29_390 VGND VGND VPWR VPWR sky130_fd_sc_hd__fill_2
XFILLER_91_455 VGND VGND VPWR VPWR sky130_fd_sc_hd__decap_3
XFILLER_17_541 VGND VGND VPWR VPWR sky130_fd_sc_hd__fill_1
XFILLER_91_477 VGND VGND VPWR VPWR sky130_fd_sc_hd__fill_2
XFILLER_44_360 VGND VGND VPWR VPWR sky130_fd_sc_hd__fill_1
XFILLER_44_382 VGND VGND VPWR VPWR sky130_fd_sc_hd__decap_3
XFILLER_71_190 VGND VGND VPWR VPWR sky130_fd_sc_hd__decap_3
X_3850_ _3851_/B _6182_/B VGND VGND VPWR VPWR _5949_/A sky130_fd_sc_hd__nand2_2
X_3781_ _3781_/A _3781_/B VGND VGND VPWR VPWR _3782_/C sky130_fd_sc_hd__xnor2_2
XFILLER_74_3 VGND VGND VPWR VPWR sky130_fd_sc_hd__decap_3
X_5520_ _5516_/X _5518_/Y _5520_/B1 _5471_/X VGND VGND VPWR VPWR _5820_/A sky130_fd_sc_hd__a211oi_2
XFILLER_8_272 VGND VGND VPWR VPWR sky130_fd_sc_hd__decap_3
X_5451_ _5451_/A _5451_/B _5451_/C VGND VGND VPWR VPWR _5458_/B sky130_fd_sc_hd__nand3_2
X_5382_ _5382_/A _5382_/B _5382_/C _5382_/D VGND VGND VPWR VPWR _5385_/A sky130_fd_sc_hd__and4_2
X_4402_ _4399_/X _4402_/B VGND VGND VPWR VPWR _4511_/B sky130_fd_sc_hd__and2b_2
XFILLER_5_72 VGND VGND VPWR VPWR sky130_fd_sc_hd__fill_2
X_4333_ _4333_/A _4333_/B VGND VGND VPWR VPWR _4341_/A sky130_fd_sc_hd__nor2_2
XFILLER_99_533 VGND VGND VPWR VPWR sky130_fd_sc_hd__decap_3
Xfanout207 _6338_/A VGND VGND VPWR VPWR _6336_/A sky130_fd_sc_hd__clkdlybuf4s25_1
Xfanout218 input63/X VGND VGND VPWR VPWR _6110_/B sky130_fd_sc_hd__buf_6
X_4264_ _4264_/A _4264_/B VGND VGND VPWR VPWR _4266_/B sky130_fd_sc_hd__nand2_2
X_6003_ _6003_/A _6003_/B VGND VGND VPWR VPWR _6011_/A sky130_fd_sc_hd__xnor2_2
XFILLER_39_143 VGND VGND VPWR VPWR sky130_fd_sc_hd__fill_1
XFILLER_86_249 VGND VGND VPWR VPWR sky130_fd_sc_hd__decap_3
X_4195_ _4195_/A _4195_/B VGND VGND VPWR VPWR _4197_/B sky130_fd_sc_hd__nand2_2
XFILLER_67_485 VGND VGND VPWR VPWR sky130_fd_sc_hd__decap_3
XFILLER_82_411 VGND VGND VPWR VPWR sky130_fd_sc_hd__decap_3
XFILLER_94_271 VGND VGND VPWR VPWR sky130_fd_sc_hd__decap_3
XFILLER_39_198 VGND VGND VPWR VPWR sky130_fd_sc_hd__decap_3
XFILLER_82_444 VGND VGND VPWR VPWR sky130_fd_sc_hd__decap_3
X_6905_ _5917_/X _5930_/A _5934_/C VGND VGND VPWR VPWR _6921_/C sky130_fd_sc_hd__a21oi_2
XFILLER_23_500 VGND VGND VPWR VPWR sky130_fd_sc_hd__decap_3
XFILLER_23_511 VGND VGND VPWR VPWR sky130_fd_sc_hd__decap_3
XFILLER_23_555 VGND VGND VPWR VPWR sky130_fd_sc_hd__decap_3
XFILLER_35_393 VGND VGND VPWR VPWR sky130_fd_sc_hd__decap_3
XFILLER_50_330 VGND VGND VPWR VPWR sky130_fd_sc_hd__decap_3
X_6836_ _6851_/B _6266_/X _6900_/A3 _6835_/Y _6834_/X VGND VGND VPWR VPWR _6836_/X
+ sky130_fd_sc_hd__a41o_2
XFILLER_10_205 VGND VGND VPWR VPWR sky130_fd_sc_hd__fill_1
XFILLER_50_374 VGND VGND VPWR VPWR sky130_fd_sc_hd__decap_3
X_6767_ _6767_/A _6767_/B VGND VGND VPWR VPWR _6767_/Y sky130_fd_sc_hd__nor2_2
XTAP_TAPCELL_ROW_33_561 VGND VPWR sky130_fd_sc_hd__tapvpwrvgnd_1
X_5718_ _5721_/A _5721_/B _5715_/Y VGND VGND VPWR VPWR _5720_/B sky130_fd_sc_hd__o21ai_2
X_3979_ _3909_/D _3977_/X _3978_/X VGND VGND VPWR VPWR _3980_/B sky130_fd_sc_hd__a21bo_2
X_6698_ _6698_/A _6698_/B VGND VGND VPWR VPWR _6698_/X sky130_fd_sc_hd__or2_2
X_5649_ _5539_/Y _5541_/Y _5647_/Y _5648_/X VGND VGND VPWR VPWR _5649_/Y sky130_fd_sc_hd__a211oi_2
XTAP_TAPCELL_ROW_79_1043 VGND VPWR sky130_fd_sc_hd__tapvpwrvgnd_1
XFILLER_6_6 VGND VGND VPWR VPWR sky130_fd_sc_hd__decap_3
XFILLER_58_452 VGND VGND VPWR VPWR sky130_fd_sc_hd__decap_3
XFILLER_92_208 VGND VGND VPWR VPWR sky130_fd_sc_hd__decap_3
XFILLER_65_44 VGND VGND VPWR VPWR sky130_fd_sc_hd__decap_3
XFILLER_85_293 VGND VGND VPWR VPWR sky130_fd_sc_hd__decap_3
XFILLER_45_146 VGND VGND VPWR VPWR sky130_fd_sc_hd__decap_3
XFILLER_65_88 VGND VGND VPWR VPWR sky130_fd_sc_hd__decap_3
XFILLER_73_455 VGND VGND VPWR VPWR sky130_fd_sc_hd__decap_3
XFILLER_14_522 VGND VGND VPWR VPWR sky130_fd_sc_hd__fill_2
XFILLER_26_360 VGND VGND VPWR VPWR sky130_fd_sc_hd__decap_3
XFILLER_26_371 VGND VGND VPWR VPWR sky130_fd_sc_hd__decap_3
XFILLER_60_127 VGND VGND VPWR VPWR sky130_fd_sc_hd__decap_3
XFILLER_73_488 VGND VGND VPWR VPWR sky130_fd_sc_hd__decap_3
XFILLER_14_533 VGND VGND VPWR VPWR sky130_fd_sc_hd__decap_3
XFILLER_81_32 VGND VGND VPWR VPWR sky130_fd_sc_hd__decap_3
XFILLER_81_54 VGND VGND VPWR VPWR sky130_fd_sc_hd__fill_2
XFILLER_81_76 VGND VGND VPWR VPWR sky130_fd_sc_hd__decap_3
XFILLER_41_396 VGND VGND VPWR VPWR sky130_fd_sc_hd__decap_3
XFILLER_5_220 VGND VGND VPWR VPWR sky130_fd_sc_hd__decap_3
XFILLER_30_80 VGND VGND VPWR VPWR sky130_fd_sc_hd__decap_3
XFILLER_30_91 VGND VGND VPWR VPWR sky130_fd_sc_hd__decap_3
XFILLER_49_430 VGND VGND VPWR VPWR sky130_fd_sc_hd__decap_3
XFILLER_68_249 VGND VGND VPWR VPWR sky130_fd_sc_hd__decap_3
XFILLER_49_452 VGND VGND VPWR VPWR sky130_fd_sc_hd__decap_3
XFILLER_83_208 VGND VGND VPWR VPWR sky130_fd_sc_hd__fill_2
Xinput7 A[15] VGND VGND VPWR VPWR input7/X sky130_fd_sc_hd__clkdlybuf4s25_1
XTAP_TAPCELL_ROW_67_918 VGND VPWR sky130_fd_sc_hd__tapvpwrvgnd_1
XFILLER_76_271 VGND VGND VPWR VPWR sky130_fd_sc_hd__fill_1
XFILLER_64_477 VGND VGND VPWR VPWR sky130_fd_sc_hd__decap_3
XFILLER_91_252 VGND VGND VPWR VPWR sky130_fd_sc_hd__fill_1
X_4951_ _4950_/A _4950_/C _4950_/B VGND VGND VPWR VPWR _4952_/B sky130_fd_sc_hd__a21o_4
XFILLER_17_393 VGND VGND VPWR VPWR sky130_fd_sc_hd__decap_3
XFILLER_44_190 VGND VGND VPWR VPWR sky130_fd_sc_hd__decap_3
X_4882_ _4883_/A _4883_/B _4883_/C VGND VGND VPWR VPWR _4882_/X sky130_fd_sc_hd__and3_2
X_3902_ _5995_/B _3969_/B _3969_/D _3969_/A VGND VGND VPWR VPWR _3903_/B sky130_fd_sc_hd__a22o_2
XFILLER_32_363 VGND VGND VPWR VPWR sky130_fd_sc_hd__fill_1
XFILLER_32_374 VGND VGND VPWR VPWR sky130_fd_sc_hd__fill_2
X_6621_ _6236_/B _6621_/A1 _6621_/A2 _6621_/A3 _6410_/S _6831_/S VGND VGND VPWR VPWR
+ _6621_/X sky130_fd_sc_hd__mux4_2
X_3833_ _3833_/A _3861_/A VGND VGND VPWR VPWR _3840_/A sky130_fd_sc_hd__nor2_2
XFILLER_20_525 VGND VGND VPWR VPWR sky130_fd_sc_hd__decap_3
XFILLER_20_547 VGND VGND VPWR VPWR sky130_fd_sc_hd__fill_1
XTAP_TAPCELL_ROW_30_531 VGND VPWR sky130_fd_sc_hd__tapvpwrvgnd_1
X_6552_ _6606_/A3 _6228_/A _6552_/A2 _6552_/A3 _6435_/S _6446_/A VGND VGND VPWR VPWR
+ _6552_/X sky130_fd_sc_hd__mux4_2
X_3764_ _3725_/X _3734_/Y _3747_/X _3762_/Y VGND VGND VPWR VPWR _3782_/B sky130_fd_sc_hd__a211o_2
X_6483_ _6897_/S _6482_/X _6473_/X _6464_/Y VGND VGND VPWR VPWR _6985_/B sky130_fd_sc_hd__a211o_2
X_5503_ _5503_/A _5503_/B VGND VGND VPWR VPWR _5525_/B sky130_fd_sc_hd__xnor2_2
X_3695_ _4551_/A _4407_/B VGND VGND VPWR VPWR _3699_/A sky130_fd_sc_hd__nand2_2
X_5434_ _5433_/A _5433_/B _5433_/C VGND VGND VPWR VPWR _5434_/Y sky130_fd_sc_hd__a21oi_2
X_5365_ wire471/A _5399_/B _5364_/B _5361_/X VGND VGND VPWR VPWR _5367_/B sky130_fd_sc_hd__a31oi_2
XFILLER_99_352 VGND VGND VPWR VPWR sky130_fd_sc_hd__decap_3
XFILLER_87_525 VGND VGND VPWR VPWR sky130_fd_sc_hd__decap_3
X_5296_ _5296_/A _5296_/B _5296_/C VGND VGND VPWR VPWR _5298_/A sky130_fd_sc_hd__and3_2
X_4316_ _4197_/Y _4206_/X _4313_/A _4313_/Y VGND VGND VPWR VPWR _4316_/X sky130_fd_sc_hd__o211a_2
XFILLER_99_396 VGND VGND VPWR VPWR sky130_fd_sc_hd__decap_3
XFILLER_59_249 VGND VGND VPWR VPWR sky130_fd_sc_hd__decap_3
XFILLER_87_558 VGND VGND VPWR VPWR sky130_fd_sc_hd__fill_2
X_4247_ _4246_/A _4246_/B _4246_/C VGND VGND VPWR VPWR _4249_/A sky130_fd_sc_hd__a21oi_2
XFILLER_74_219 VGND VGND VPWR VPWR sky130_fd_sc_hd__decap_3
X_4178_ _4178_/A _4178_/B VGND VGND VPWR VPWR _4189_/A sky130_fd_sc_hd__nor2_2
XFILLER_27_113 VGND VGND VPWR VPWR sky130_fd_sc_hd__decap_3
XFILLER_67_293 VGND VGND VPWR VPWR sky130_fd_sc_hd__decap_3
XTAP_TAPCELL_ROW_38_620 VGND VPWR sky130_fd_sc_hd__tapvpwrvgnd_1
XTAP_TAPCELL_ROW_2_234 VGND VPWR sky130_fd_sc_hd__tapvpwrvgnd_1
XFILLER_35_47 VGND VGND VPWR VPWR sky130_fd_sc_hd__fill_1
XFILLER_42_127 VGND VGND VPWR VPWR sky130_fd_sc_hd__decap_3
XFILLER_82_296 VGND VGND VPWR VPWR sky130_fd_sc_hd__decap_3
XFILLER_11_503 VGND VGND VPWR VPWR sky130_fd_sc_hd__fill_1
XFILLER_11_514 VGND VGND VPWR VPWR sky130_fd_sc_hd__decap_3
XFILLER_23_352 VGND VGND VPWR VPWR sky130_fd_sc_hd__fill_2
X_6819_ _6163_/Y _6819_/A2 _6807_/Y _6818_/Y VGND VGND VPWR VPWR _6819_/X sky130_fd_sc_hd__a31o_2
XFILLER_7_529 VGND VGND VPWR VPWR sky130_fd_sc_hd__decap_3
XFILLER_4_3 VGND VGND VPWR VPWR sky130_fd_sc_hd__fill_2
XFILLER_65_219 VGND VGND VPWR VPWR sky130_fd_sc_hd__decap_3
XFILLER_76_76 VGND VGND VPWR VPWR sky130_fd_sc_hd__decap_3
Xfanout593 input21/X VGND VGND VPWR VPWR _6205_/A sky130_fd_sc_hd__clkdlybuf4s25_1
XFILLER_93_517 VGND VGND VPWR VPWR sky130_fd_sc_hd__decap_3
XFILLER_58_271 VGND VGND VPWR VPWR sky130_fd_sc_hd__decap_3
XFILLER_73_241 VGND VGND VPWR VPWR sky130_fd_sc_hd__decap_3
XFILLER_33_127 VGND VGND VPWR VPWR sky130_fd_sc_hd__decap_3
XFILLER_46_499 VGND VGND VPWR VPWR sky130_fd_sc_hd__decap_3
XFILLER_61_436 VGND VGND VPWR VPWR sky130_fd_sc_hd__decap_3
XFILLER_73_274 VGND VGND VPWR VPWR sky130_fd_sc_hd__decap_3
XFILLER_73_296 VGND VGND VPWR VPWR sky130_fd_sc_hd__decap_3
XFILLER_61_447 VGND VGND VPWR VPWR sky130_fd_sc_hd__fill_1
XFILLER_61_458 VGND VGND VPWR VPWR sky130_fd_sc_hd__decap_3
XFILLER_92_64 VGND VGND VPWR VPWR sky130_fd_sc_hd__decap_3
XFILLER_14_374 VGND VGND VPWR VPWR sky130_fd_sc_hd__decap_3
XTAP_TAPCELL_ROW_72_976 VGND VPWR sky130_fd_sc_hd__tapvpwrvgnd_1
XTAP_TAPCELL_ROW_44_678 VGND VPWR sky130_fd_sc_hd__tapvpwrvgnd_1
XFILLER_25_91 VGND VGND VPWR VPWR sky130_fd_sc_hd__decap_3
XFILLER_6_595 VGND VGND VPWR VPWR sky130_fd_sc_hd__decap_3
XFILLER_37_3 VGND VGND VPWR VPWR sky130_fd_sc_hd__fill_1
X_5150_ _5150_/A _5150_/B VGND VGND VPWR VPWR _5161_/A sky130_fd_sc_hd__xnor2_2
XFILLER_96_300 VGND VGND VPWR VPWR sky130_fd_sc_hd__decap_3
XFILLER_69_547 VGND VGND VPWR VPWR sky130_fd_sc_hd__decap_3
XFILLER_69_569 VGND VGND VPWR VPWR sky130_fd_sc_hd__decap_3
X_5081_ _5081_/A _5081_/B _5081_/C VGND VGND VPWR VPWR _5166_/B sky130_fd_sc_hd__and3_4
X_4101_ _4103_/B _4103_/A VGND VGND VPWR VPWR _4101_/X sky130_fd_sc_hd__and2b_2
XFILLER_84_506 VGND VGND VPWR VPWR sky130_fd_sc_hd__decap_3
X_4032_ _4032_/A _4032_/B VGND VGND VPWR VPWR _4043_/B sky130_fd_sc_hd__xnor2_2
XFILLER_2_73 VGND VGND VPWR VPWR sky130_fd_sc_hd__decap_3
XFILLER_37_411 VGND VGND VPWR VPWR sky130_fd_sc_hd__decap_3
XFILLER_49_293 VGND VGND VPWR VPWR sky130_fd_sc_hd__decap_3
XFILLER_77_591 VGND VGND VPWR VPWR sky130_fd_sc_hd__decap_3
XFILLER_64_230 VGND VGND VPWR VPWR sky130_fd_sc_hd__decap_3
XFILLER_64_274 VGND VGND VPWR VPWR sky130_fd_sc_hd__decap_3
X_5983_ _5983_/A _5983_/B _5983_/C _5983_/D VGND VGND VPWR VPWR _5984_/D sky130_fd_sc_hd__nand4_2
X_4934_ _4934_/A _4934_/B VGND VGND VPWR VPWR _5015_/A sky130_fd_sc_hd__xor2_2
XFILLER_20_322 VGND VGND VPWR VPWR sky130_fd_sc_hd__fill_2
X_4865_ _4816_/Y _4818_/X _4862_/Y _4864_/X VGND VGND VPWR VPWR _4868_/A sky130_fd_sc_hd__a211o_2
X_6604_ _6111_/B _6331_/B _6797_/A2 _6138_/A VGND VGND VPWR VPWR _6604_/X sky130_fd_sc_hd__o2bb2a_2
X_4796_ _4793_/A _6315_/A _4795_/B _4792_/X VGND VGND VPWR VPWR _4800_/A sky130_fd_sc_hd__a31oi_2
X_3816_ _3814_/X _3816_/B VGND VGND VPWR VPWR _3817_/B sky130_fd_sc_hd__and2b_2
X_6535_ _5529_/Y _6891_/B1 _6506_/B _6381_/C _6534_/X VGND VGND VPWR VPWR _6536_/B
+ sky130_fd_sc_hd__o221a_2
X_3747_ _3747_/A _3747_/B _3747_/C VGND VGND VPWR VPWR _3747_/X sky130_fd_sc_hd__and3_2
XTAP_TAPCELL_ROW_76_1013 VGND VPWR sky130_fd_sc_hd__tapvpwrvgnd_1
X_6466_ _6381_/D _6223_/B wire152/A VGND VGND VPWR VPWR _6467_/B sky130_fd_sc_hd__o21ai_2
X_3678_ _3678_/A _3678_/B VGND VGND VPWR VPWR _3690_/A sky130_fd_sc_hd__nor2_2
X_6397_ _6205_/A _6196_/B _6397_/S VGND VGND VPWR VPWR _6397_/X sky130_fd_sc_hd__mux2_1
X_5417_ _5417_/A _5441_/B _5417_/C VGND VGND VPWR VPWR _5511_/B sky130_fd_sc_hd__and3_2
X_5348_ _5211_/A _5313_/B _5212_/A _5211_/D VGND VGND VPWR VPWR _5349_/C sky130_fd_sc_hd__a22o_2
XFILLER_87_322 VGND VGND VPWR VPWR sky130_fd_sc_hd__decap_3
XFILLER_87_333 VGND VGND VPWR VPWR sky130_fd_sc_hd__decap_3
XFILLER_75_528 VGND VGND VPWR VPWR sky130_fd_sc_hd__decap_3
XFILLER_87_388 VGND VGND VPWR VPWR sky130_fd_sc_hd__decap_3
X_5279_ _6212_/A _6761_/S _5269_/A _5267_/Y VGND VGND VPWR VPWR _5280_/B sky130_fd_sc_hd__o22a_2
XFILLER_28_400 VGND VGND VPWR VPWR sky130_fd_sc_hd__decap_3
XFILLER_87_399 VGND VGND VPWR VPWR sky130_fd_sc_hd__decap_3
XFILLER_28_466 VGND VGND VPWR VPWR sky130_fd_sc_hd__decap_3
XFILLER_83_561 VGND VGND VPWR VPWR sky130_fd_sc_hd__decap_3
XTAP_TAPCELL_ROW_87_1131 VGND VPWR sky130_fd_sc_hd__tapvpwrvgnd_1
XFILLER_15_105 VGND VGND VPWR VPWR sky130_fd_sc_hd__decap_3
XFILLER_28_477 VGND VGND VPWR VPWR sky130_fd_sc_hd__decap_3
XFILLER_43_414 VGND VGND VPWR VPWR sky130_fd_sc_hd__decap_3
XFILLER_70_200 VGND VGND VPWR VPWR sky130_fd_sc_hd__decap_3
XFILLER_70_233 VGND VGND VPWR VPWR sky130_fd_sc_hd__fill_1
XFILLER_23_160 VGND VGND VPWR VPWR sky130_fd_sc_hd__decap_3
XFILLER_70_299 VGND VGND VPWR VPWR sky130_fd_sc_hd__decap_3
XTAP_TAPCELL_ROW_41_648 VGND VPWR sky130_fd_sc_hd__tapvpwrvgnd_1
XFILLER_11_333 VGND VGND VPWR VPWR sky130_fd_sc_hd__decap_3
XFILLER_11_377 VGND VGND VPWR VPWR sky130_fd_sc_hd__decap_3
XFILLER_7_29 VGND VGND VPWR VPWR sky130_fd_sc_hd__decap_3
XFILLER_7_359 VGND VGND VPWR VPWR sky130_fd_sc_hd__decap_3
XFILLER_3_576 VGND VGND VPWR VPWR sky130_fd_sc_hd__fill_1
XFILLER_78_333 VGND VGND VPWR VPWR sky130_fd_sc_hd__fill_2
Xload_slew229 _6112_/B VGND VGND VPWR VPWR _6215_/B sky130_fd_sc_hd__buf_8
XFILLER_66_506 VGND VGND VPWR VPWR sky130_fd_sc_hd__decap_3
XFILLER_78_388 VGND VGND VPWR VPWR sky130_fd_sc_hd__decap_3
Xfanout390 _3923_/A VGND VGND VPWR VPWR _6100_/A sky130_fd_sc_hd__clkdlybuf4s25_1
XFILLER_19_444 VGND VGND VPWR VPWR sky130_fd_sc_hd__decap_3
XFILLER_93_358 VGND VGND VPWR VPWR sky130_fd_sc_hd__decap_3
XFILLER_34_414 VGND VGND VPWR VPWR sky130_fd_sc_hd__decap_3
XFILLER_61_200 VGND VGND VPWR VPWR sky130_fd_sc_hd__decap_3
XFILLER_34_447 VGND VGND VPWR VPWR sky130_fd_sc_hd__decap_3
XFILLER_21_119 VGND VGND VPWR VPWR sky130_fd_sc_hd__fill_1
XFILLER_61_299 VGND VGND VPWR VPWR sky130_fd_sc_hd__decap_3
X_4650_ _4685_/A _4687_/C _4925_/C _4685_/D VGND VGND VPWR VPWR _4653_/A sky130_fd_sc_hd__and4_2
Xinput10 A[18] VGND VGND VPWR VPWR input10/X sky130_fd_sc_hd__clkdlybuf4s25_1
Xinput21 A[28] VGND VGND VPWR VPWR input21/X sky130_fd_sc_hd__clkdlybuf4s25_1
X_3601_ _3602_/A _3602_/B VGND VGND VPWR VPWR _3824_/B sky130_fd_sc_hd__nand2_2
X_6320_ _3495_/Y _4989_/B _4805_/A VGND VGND VPWR VPWR _6320_/Y sky130_fd_sc_hd__o21ai_2
Xinput54 B[29] VGND VGND VPWR VPWR _6196_/A sky130_fd_sc_hd__clkdlybuf4s25_1
Xinput43 B[19] VGND VGND VPWR VPWR input43/X sky130_fd_sc_hd__clkdlybuf4s25_1
Xinput32 A[9] VGND VGND VPWR VPWR wire482/A sky130_fd_sc_hd__clkbuf_2
X_4581_ _4793_/A _6363_/A _6314_/B _5162_/A VGND VGND VPWR VPWR _4582_/B sky130_fd_sc_hd__a22o_2
Xinput65 opcode[0] VGND VGND VPWR VPWR _6338_/B sky130_fd_sc_hd__clkdlybuf4s25_1
X_3532_ _3532_/A _3532_/B VGND VGND VPWR VPWR _3729_/B sky130_fd_sc_hd__nor2_2
XFILLER_6_381 VGND VGND VPWR VPWR sky130_fd_sc_hd__decap_3
X_6251_ _3490_/Y wire183/A _6250_/X VGND VGND VPWR VPWR _6787_/B sky130_fd_sc_hd__a21oi_2
X_6182_ _6276_/A _6182_/B VGND VGND VPWR VPWR _6878_/A sky130_fd_sc_hd__or2_2
X_5202_ _5341_/B _5341_/C _5341_/D _5340_/A VGND VGND VPWR VPWR _5202_/Y sky130_fd_sc_hd__a22oi_2
X_5133_ _5133_/A _5133_/B _5133_/C VGND VGND VPWR VPWR _5142_/A sky130_fd_sc_hd__nand3_2
XFILLER_69_377 VGND VGND VPWR VPWR sky130_fd_sc_hd__decap_3
XFILLER_84_325 VGND VGND VPWR VPWR sky130_fd_sc_hd__decap_3
X_5064_ _4972_/Y _5062_/X _5064_/B1 _5045_/Y VGND VGND VPWR VPWR _5081_/B sky130_fd_sc_hd__o211ai_2
X_4015_ _4015_/A _4015_/B VGND VGND VPWR VPWR _4016_/C sky130_fd_sc_hd__xnor2_2
XFILLER_25_414 VGND VGND VPWR VPWR sky130_fd_sc_hd__decap_3
XFILLER_52_200 VGND VGND VPWR VPWR sky130_fd_sc_hd__decap_3
XFILLER_65_561 VGND VGND VPWR VPWR sky130_fd_sc_hd__decap_3
XFILLER_65_594 VGND VGND VPWR VPWR sky130_fd_sc_hd__decap_3
XFILLER_92_380 VGND VGND VPWR VPWR sky130_fd_sc_hd__decap_3
XFILLER_80_586 VGND VGND VPWR VPWR sky130_fd_sc_hd__fill_2
X_5966_ _3859_/A _3859_/B _3858_/A VGND VGND VPWR VPWR _5968_/A sky130_fd_sc_hd__a21o_2
XFILLER_33_480 VGND VGND VPWR VPWR sky130_fd_sc_hd__decap_3
X_5897_ _5888_/Y _5894_/X _4911_/A _4911_/Y VGND VGND VPWR VPWR _5897_/X sky130_fd_sc_hd__o211a_2
X_4917_ _4878_/Y _4880_/Y _4915_/Y _4916_/X VGND VGND VPWR VPWR _5913_/A sky130_fd_sc_hd__a211oi_2
XTAP_TAPCELL_ROW_82_1083 VGND VPWR sky130_fd_sc_hd__tapvpwrvgnd_1
X_4848_ _4848_/A _4848_/B _4848_/C VGND VGND VPWR VPWR _4848_/Y sky130_fd_sc_hd__nand3_2
XFILLER_32_48 VGND VGND VPWR VPWR sky130_fd_sc_hd__decap_3
XFILLER_20_185 VGND VGND VPWR VPWR sky130_fd_sc_hd__fill_2
X_4779_ _4747_/Y _4974_/C1 _4777_/Y _4778_/X VGND VGND VPWR VPWR _4806_/A sky130_fd_sc_hd__a211o_2
XFILLER_4_329 VGND VGND VPWR VPWR sky130_fd_sc_hd__decap_3
X_6518_ _6119_/Y _6130_/Y _6517_/Y VGND VGND VPWR VPWR _6540_/B sky130_fd_sc_hd__o21a_2
X_6449_ _6126_/A _6605_/A2 _6506_/B _6441_/A _6445_/X VGND VGND VPWR VPWR _6449_/X
+ sky130_fd_sc_hd__o221a_2
XFILLER_0_524 VGND VGND VPWR VPWR sky130_fd_sc_hd__decap_3
XTAP_TAPCELL_ROW_93_1190 VGND VPWR sky130_fd_sc_hd__tapvpwrvgnd_1
XFILLER_0_557 VGND VGND VPWR VPWR sky130_fd_sc_hd__decap_3
XFILLER_0_579 VGND VGND VPWR VPWR sky130_fd_sc_hd__decap_3
XFILLER_16_414 VGND VGND VPWR VPWR sky130_fd_sc_hd__decap_3
XFILLER_43_200 VGND VGND VPWR VPWR sky130_fd_sc_hd__decap_3
XFILLER_90_328 VGND VGND VPWR VPWR sky130_fd_sc_hd__decap_3
XTAP_TAPCELL_ROW_18_409 VGND VPWR sky130_fd_sc_hd__tapvpwrvgnd_1
XFILLER_16_436 VGND VGND VPWR VPWR sky130_fd_sc_hd__decap_3
XFILLER_43_222 VGND VGND VPWR VPWR sky130_fd_sc_hd__fill_2
XFILLER_71_520 VGND VGND VPWR VPWR sky130_fd_sc_hd__decap_3
XFILLER_73_55 VGND VGND VPWR VPWR sky130_fd_sc_hd__fill_1
XFILLER_83_391 VGND VGND VPWR VPWR sky130_fd_sc_hd__fill_1
XFILLER_43_244 VGND VGND VPWR VPWR sky130_fd_sc_hd__fill_1
XFILLER_71_553 VGND VGND VPWR VPWR sky130_fd_sc_hd__decap_3
XFILLER_71_564 VGND VGND VPWR VPWR sky130_fd_sc_hd__fill_1
XFILLER_73_66 VGND VGND VPWR VPWR sky130_fd_sc_hd__decap_3
XFILLER_71_597 VGND VGND VPWR VPWR sky130_fd_sc_hd__fill_1
XTAP_TAPCELL_ROW_54_784 VGND VPWR sky130_fd_sc_hd__tapvpwrvgnd_1
XTAP_TAPCELL_ROW_26_486 VGND VPWR sky130_fd_sc_hd__tapvpwrvgnd_1
XFILLER_11_130 VGND VGND VPWR VPWR sky130_fd_sc_hd__decap_3
XFILLER_24_491 VGND VGND VPWR VPWR sky130_fd_sc_hd__decap_3
XFILLER_98_85 VGND VGND VPWR VPWR sky130_fd_sc_hd__fill_2
XFILLER_21_6 VGND VGND VPWR VPWR sky130_fd_sc_hd__fill_2
XFILLER_39_517 VGND VGND VPWR VPWR sky130_fd_sc_hd__fill_2
XFILLER_66_303 VGND VGND VPWR VPWR sky130_fd_sc_hd__decap_3
XFILLER_39_539 VGND VGND VPWR VPWR sky130_fd_sc_hd__decap_3
XFILLER_66_336 VGND VGND VPWR VPWR sky130_fd_sc_hd__decap_3
XFILLER_93_111 VGND VGND VPWR VPWR sky130_fd_sc_hd__fill_1
XFILLER_81_317 VGND VGND VPWR VPWR sky130_fd_sc_hd__decap_3
XFILLER_62_520 VGND VGND VPWR VPWR sky130_fd_sc_hd__decap_3
XFILLER_74_380 VGND VGND VPWR VPWR sky130_fd_sc_hd__decap_3
X_5820_ _5820_/A _5820_/B VGND VGND VPWR VPWR _5820_/Y sky130_fd_sc_hd__nor2_2
XFILLER_34_288 VGND VGND VPWR VPWR sky130_fd_sc_hd__decap_3
XFILLER_62_586 VGND VGND VPWR VPWR sky130_fd_sc_hd__fill_2
X_5751_ _5755_/A _5755_/B VGND VGND VPWR VPWR _5752_/C sky130_fd_sc_hd__and2_2
X_4702_ _4700_/X _4702_/B VGND VGND VPWR VPWR _4709_/A sky130_fd_sc_hd__and2b_2
X_5682_ _5714_/B _5714_/A VGND VGND VPWR VPWR _5685_/B sky130_fd_sc_hd__and2b_2
X_4633_ _4638_/A _4638_/B VGND VGND VPWR VPWR _4642_/B sky130_fd_sc_hd__nand2b_2
Xmax_cap310 _4003_/C VGND VGND VPWR VPWR _6073_/A sky130_fd_sc_hd__buf_2
X_4564_ _4304_/X _4306_/Y _4565_/A _4563_/X VGND VGND VPWR VPWR _4565_/B sky130_fd_sc_hd__a211oi_2
X_6303_ _6608_/S _6767_/A VGND VGND VPWR VPWR _6303_/Y sky130_fd_sc_hd__nor2_2
X_3515_ _4290_/A _6924_/S _3514_/B _3511_/X VGND VGND VPWR VPWR _3517_/B sky130_fd_sc_hd__a31o_2
X_6234_ _6381_/B _6231_/B _6231_/C _6233_/B _6214_/X VGND VGND VPWR VPWR _6234_/X
+ sky130_fd_sc_hd__a311o_2
X_4495_ _4491_/Y _4883_/A _4471_/Y _4472_/X VGND VGND VPWR VPWR _4497_/B sky130_fd_sc_hd__a211o_4
XFILLER_89_439 VGND VGND VPWR VPWR sky130_fd_sc_hd__fill_2
X_6165_ _6842_/B _6166_/B VGND VGND VPWR VPWR _6266_/C sky130_fd_sc_hd__and2_2
Xload_slew582 _5547_/A VGND VGND VPWR VPWR _6224_/A sky130_fd_sc_hd__clkbuf_2
Xload_slew560 input27/X VGND VGND VPWR VPWR _4651_/A sky130_fd_sc_hd__buf_6
X_6096_ _6098_/A _6098_/B VGND VGND VPWR VPWR _6208_/A sky130_fd_sc_hd__nand2_2
X_5116_ _5300_/B _5188_/C _5290_/C _5341_/A VGND VGND VPWR VPWR _5117_/C sky130_fd_sc_hd__a22o_2
XFILLER_69_196 VGND VGND VPWR VPWR sky130_fd_sc_hd__decap_3
XFILLER_84_144 VGND VGND VPWR VPWR sky130_fd_sc_hd__decap_3
X_5047_ _5134_/A _5203_/D VGND VGND VPWR VPWR _5123_/A sky130_fd_sc_hd__nand2_2
XFILLER_38_583 VGND VGND VPWR VPWR sky130_fd_sc_hd__decap_3
XFILLER_72_306 VGND VGND VPWR VPWR sky130_fd_sc_hd__fill_2
XFILLER_72_328 VGND VGND VPWR VPWR sky130_fd_sc_hd__decap_3
XFILLER_84_188 VGND VGND VPWR VPWR sky130_fd_sc_hd__decap_3
XTAP_TAPCELL_ROW_84_1101 VGND VPWR sky130_fd_sc_hd__tapvpwrvgnd_1
XFILLER_38_594 VGND VGND VPWR VPWR sky130_fd_sc_hd__decap_3
XFILLER_65_380 VGND VGND VPWR VPWR sky130_fd_sc_hd__decap_3
XFILLER_25_244 VGND VGND VPWR VPWR sky130_fd_sc_hd__fill_2
XFILLER_53_564 VGND VGND VPWR VPWR sky130_fd_sc_hd__fill_1
X_6998_ _6203_/X _6996_/X _6291_/A _6997_/X VGND VGND VPWR VPWR _6998_/X sky130_fd_sc_hd__a2bb2o_4
XFILLER_13_417 VGND VGND VPWR VPWR sky130_fd_sc_hd__fill_1
XFILLER_13_428 VGND VGND VPWR VPWR sky130_fd_sc_hd__fill_1
XFILLER_40_203 VGND VGND VPWR VPWR sky130_fd_sc_hd__decap_3
XFILLER_40_225 VGND VGND VPWR VPWR sky130_fd_sc_hd__decap_3
XFILLER_53_597 VGND VGND VPWR VPWR sky130_fd_sc_hd__fill_1
XFILLER_80_383 VGND VGND VPWR VPWR sky130_fd_sc_hd__decap_3
X_5949_ _5949_/A _5949_/B VGND VGND VPWR VPWR _5950_/B sky130_fd_sc_hd__xor2_2
XTAP_TAPCELL_ROW_51_754 VGND VPWR sky130_fd_sc_hd__tapvpwrvgnd_1
XTAP_TAPCELL_ROW_23_456 VGND VPWR sky130_fd_sc_hd__tapvpwrvgnd_1
XFILLER_21_494 VGND VGND VPWR VPWR sky130_fd_sc_hd__fill_1
Xrebuffer732 _4416_/A1 VGND VGND VPWR VPWR _4415_/B1 sky130_fd_sc_hd__buf_2
Xrebuffer710 _5474_/B1 VGND VGND VPWR VPWR _5414_/C sky130_fd_sc_hd__buf_2
Xrebuffer743 _5458_/X VGND VGND VPWR VPWR _5829_/C1 sky130_fd_sc_hd__buf_4
Xrebuffer754 wire496/X VGND VGND VPWR VPWR _5992_/B sky130_fd_sc_hd__buf_2
Xrebuffer765 _4482_/A VGND VGND VPWR VPWR _4355_/A sky130_fd_sc_hd__buf_2
XFILLER_4_137 VGND VGND VPWR VPWR sky130_fd_sc_hd__decap_3
XFILLER_0_321 VGND VGND VPWR VPWR sky130_fd_sc_hd__decap_3
XFILLER_0_343 VGND VGND VPWR VPWR sky130_fd_sc_hd__decap_3
XFILLER_0_365 VGND VGND VPWR VPWR sky130_fd_sc_hd__fill_1
XFILLER_0_387 VGND VGND VPWR VPWR sky130_fd_sc_hd__decap_3
XFILLER_88_483 VGND VGND VPWR VPWR sky130_fd_sc_hd__fill_2
XTAP_TAPCELL_ROW_59_832 VGND VPWR sky130_fd_sc_hd__tapvpwrvgnd_1
XFILLER_75_122 VGND VGND VPWR VPWR sky130_fd_sc_hd__fill_1
XFILLER_75_144 VGND VGND VPWR VPWR sky130_fd_sc_hd__decap_3
XFILLER_84_32 VGND VGND VPWR VPWR sky130_fd_sc_hd__decap_3
XFILLER_29_561 VGND VGND VPWR VPWR sky130_fd_sc_hd__decap_3
XFILLER_63_317 VGND VGND VPWR VPWR sky130_fd_sc_hd__decap_3
XFILLER_75_155 VGND VGND VPWR VPWR sky130_fd_sc_hd__decap_3
XFILLER_44_531 VGND VGND VPWR VPWR sky130_fd_sc_hd__fill_1
XFILLER_44_542 VGND VGND VPWR VPWR sky130_fd_sc_hd__decap_3
XFILLER_56_380 VGND VGND VPWR VPWR sky130_fd_sc_hd__decap_3
XFILLER_84_98 VGND VGND VPWR VPWR sky130_fd_sc_hd__decap_3
XFILLER_16_244 VGND VGND VPWR VPWR sky130_fd_sc_hd__fill_1
XFILLER_17_81 VGND VGND VPWR VPWR sky130_fd_sc_hd__decap_3
XFILLER_16_288 VGND VGND VPWR VPWR sky130_fd_sc_hd__decap_3
XFILLER_71_372 VGND VGND VPWR VPWR sky130_fd_sc_hd__decap_3
XFILLER_31_247 VGND VGND VPWR VPWR sky130_fd_sc_hd__fill_2
XFILLER_12_472 VGND VGND VPWR VPWR sky130_fd_sc_hd__decap_3
XFILLER_8_421 VGND VGND VPWR VPWR sky130_fd_sc_hd__decap_3
XTAP_TAPCELL_ROW_100_1267 VGND VPWR sky130_fd_sc_hd__tapvpwrvgnd_1
XFILLER_12_483 VGND VGND VPWR VPWR sky130_fd_sc_hd__decap_3
XFILLER_76_7 VGND VGND VPWR VPWR sky130_fd_sc_hd__decap_3
XTAP_TAPCELL_ROW_100_1278 VGND VPWR sky130_fd_sc_hd__tapvpwrvgnd_1
XFILLER_69_6 VGND VGND VPWR VPWR sky130_fd_sc_hd__fill_2
XFILLER_3_181 VGND VGND VPWR VPWR sky130_fd_sc_hd__decap_3
X_4280_ _4406_/B _4280_/B _4406_/C _4406_/D VGND VGND VPWR VPWR _4283_/A sky130_fd_sc_hd__nand4_2
XFILLER_79_461 VGND VGND VPWR VPWR sky130_fd_sc_hd__decap_3
XFILLER_39_303 VGND VGND VPWR VPWR sky130_fd_sc_hd__decap_3
XFILLER_79_494 VGND VGND VPWR VPWR sky130_fd_sc_hd__decap_3
XFILLER_66_133 VGND VGND VPWR VPWR sky130_fd_sc_hd__decap_3
XFILLER_66_144 VGND VGND VPWR VPWR sky130_fd_sc_hd__decap_3
XFILLER_94_442 VGND VGND VPWR VPWR sky130_fd_sc_hd__decap_3
XFILLER_66_177 VGND VGND VPWR VPWR sky130_fd_sc_hd__decap_3
XFILLER_94_486 VGND VGND VPWR VPWR sky130_fd_sc_hd__fill_2
XFILLER_94_475 VGND VGND VPWR VPWR sky130_fd_sc_hd__fill_1
XFILLER_47_380 VGND VGND VPWR VPWR sky130_fd_sc_hd__decap_3
XFILLER_81_125 VGND VGND VPWR VPWR sky130_fd_sc_hd__decap_3
X_6921_ _6921_/A _6921_/B _6921_/C VGND VGND VPWR VPWR _6923_/B sky130_fd_sc_hd__or3_2
XFILLER_35_575 VGND VGND VPWR VPWR sky130_fd_sc_hd__decap_3
XFILLER_81_158 VGND VGND VPWR VPWR sky130_fd_sc_hd__decap_3
XFILLER_81_169 VGND VGND VPWR VPWR sky130_fd_sc_hd__decap_3
X_6852_ _6851_/B _6851_/C _6842_/A VGND VGND VPWR VPWR _6852_/X sky130_fd_sc_hd__a21bo_2
XFILLER_22_214 VGND VGND VPWR VPWR sky130_fd_sc_hd__decap_3
XFILLER_35_597 VGND VGND VPWR VPWR sky130_fd_sc_hd__fill_1
XFILLER_50_512 VGND VGND VPWR VPWR sky130_fd_sc_hd__fill_2
XFILLER_62_394 VGND VGND VPWR VPWR sky130_fd_sc_hd__decap_3
X_5803_ _6484_/A _6484_/B VGND VGND VPWR VPWR _6514_/B sky130_fd_sc_hd__or2_2
X_6783_ _6711_/X _6782_/X _6783_/S VGND VGND VPWR VPWR _6783_/X sky130_fd_sc_hd__mux2_1
X_3995_ _3995_/A _3995_/B VGND VGND VPWR VPWR _4000_/A sky130_fd_sc_hd__xnor2_2
XFILLER_22_269 VGND VGND VPWR VPWR sky130_fd_sc_hd__decap_3
X_5734_ _5734_/A _5791_/B VGND VGND VPWR VPWR _5735_/A sky130_fd_sc_hd__nand2_2
X_5665_ _5664_/B _5664_/C _5664_/A VGND VGND VPWR VPWR _5667_/B sky130_fd_sc_hd__a21bo_2
XTAP_TAPCELL_ROW_20_426 VGND VPWR sky130_fd_sc_hd__tapvpwrvgnd_1
X_4616_ _4634_/B _4636_/C _4616_/C _4616_/D VGND VGND VPWR VPWR _4619_/A sky130_fd_sc_hd__and4_2
X_5596_ _5596_/A _5596_/B VGND VGND VPWR VPWR _5598_/B sky130_fd_sc_hd__xor2_2
XFILLER_89_203 VGND VGND VPWR VPWR sky130_fd_sc_hd__decap_3
X_4547_ _4547_/A _4547_/B _4547_/C VGND VGND VPWR VPWR _4897_/A sky130_fd_sc_hd__and3_2
XFILLER_89_225 VGND VGND VPWR VPWR sky130_fd_sc_hd__decap_3
X_4478_ _4475_/X _4478_/B VGND VGND VPWR VPWR _4598_/B sky130_fd_sc_hd__and2b_2
XFILLER_89_258 VGND VGND VPWR VPWR sky130_fd_sc_hd__decap_3
X_6217_ input60/X _6217_/B VGND VGND VPWR VPWR _6218_/A sky130_fd_sc_hd__nand2b_2
XTAP_TAPCELL_ROW_90_1160 VGND VPWR sky130_fd_sc_hd__tapvpwrvgnd_1
XFILLER_38_25 VGND VGND VPWR VPWR sky130_fd_sc_hd__decap_3
XFILLER_38_36 VGND VGND VPWR VPWR sky130_fd_sc_hd__decap_3
XFILLER_57_111 VGND VGND VPWR VPWR sky130_fd_sc_hd__fill_1
XFILLER_85_420 VGND VGND VPWR VPWR sky130_fd_sc_hd__decap_3
X_6148_ _6244_/B _6148_/B VGND VGND VPWR VPWR _6717_/A sky130_fd_sc_hd__nor2_2
XFILLER_57_144 VGND VGND VPWR VPWR sky130_fd_sc_hd__decap_3
XFILLER_97_291 VGND VGND VPWR VPWR sky130_fd_sc_hd__decap_3
XFILLER_18_509 VGND VGND VPWR VPWR sky130_fd_sc_hd__decap_3
XFILLER_85_464 VGND VGND VPWR VPWR sky130_fd_sc_hd__decap_3
X_6079_ _6079_/A _6079_/B VGND VGND VPWR VPWR _6080_/B sky130_fd_sc_hd__or2_2
XTAP_TAPCELL_ROW_56_802 VGND VPWR sky130_fd_sc_hd__tapvpwrvgnd_1
XFILLER_57_199 VGND VGND VPWR VPWR sky130_fd_sc_hd__decap_3
XFILLER_72_136 VGND VGND VPWR VPWR sky130_fd_sc_hd__decap_3
XTAP_TAPCELL_ROW_28_515 VGND VPWR sky130_fd_sc_hd__tapvpwrvgnd_1
XFILLER_54_35 VGND VGND VPWR VPWR sky130_fd_sc_hd__decap_3
XFILLER_60_309 VGND VGND VPWR VPWR sky130_fd_sc_hd__decap_3
XFILLER_72_147 VGND VGND VPWR VPWR sky130_fd_sc_hd__decap_3
XFILLER_13_225 VGND VGND VPWR VPWR sky130_fd_sc_hd__decap_3
XFILLER_53_383 VGND VGND VPWR VPWR sky130_fd_sc_hd__decap_3
XFILLER_54_68 VGND VGND VPWR VPWR sky130_fd_sc_hd__decap_3
XTAP_TAPCELL_ROW_64_890 VGND VPWR sky130_fd_sc_hd__tapvpwrvgnd_1
XFILLER_13_258 VGND VGND VPWR VPWR sky130_fd_sc_hd__fill_1
XFILLER_41_545 VGND VGND VPWR VPWR sky130_fd_sc_hd__decap_3
XTAP_TAPCELL_ROW_36_592 VGND VPWR sky130_fd_sc_hd__tapvpwrvgnd_1
XFILLER_9_207 VGND VGND VPWR VPWR sky130_fd_sc_hd__fill_2
XFILLER_13_269 VGND VGND VPWR VPWR sky130_fd_sc_hd__decap_3
XFILLER_5_435 VGND VGND VPWR VPWR sky130_fd_sc_hd__decap_3
XFILLER_79_65 VGND VGND VPWR VPWR sky130_fd_sc_hd__decap_3
XFILLER_68_409 VGND VGND VPWR VPWR sky130_fd_sc_hd__decap_3
XFILLER_48_100 VGND VGND VPWR VPWR sky130_fd_sc_hd__decap_3
XFILLER_95_31 VGND VGND VPWR VPWR sky130_fd_sc_hd__decap_3
XFILLER_95_228 VGND VGND VPWR VPWR sky130_fd_sc_hd__decap_3
XFILLER_76_453 VGND VGND VPWR VPWR sky130_fd_sc_hd__decap_3
XFILLER_63_103 VGND VGND VPWR VPWR sky130_fd_sc_hd__fill_2
XFILLER_76_475 VGND VGND VPWR VPWR sky130_fd_sc_hd__fill_1
XFILLER_91_412 VGND VGND VPWR VPWR sky130_fd_sc_hd__decap_3
XFILLER_17_520 VGND VGND VPWR VPWR sky130_fd_sc_hd__decap_3
XFILLER_63_125 VGND VGND VPWR VPWR sky130_fd_sc_hd__decap_3
XFILLER_91_445 VGND VGND VPWR VPWR sky130_fd_sc_hd__decap_3
XFILLER_51_309 VGND VGND VPWR VPWR sky130_fd_sc_hd__fill_2
XFILLER_17_586 VGND VGND VPWR VPWR sky130_fd_sc_hd__decap_3
XFILLER_32_578 VGND VGND VPWR VPWR sky130_fd_sc_hd__decap_3
XFILLER_32_589 VGND VGND VPWR VPWR sky130_fd_sc_hd__decap_3
X_3780_ _3781_/A _3781_/B VGND VGND VPWR VPWR _3780_/Y sky130_fd_sc_hd__nand2b_2
XFILLER_8_251 VGND VGND VPWR VPWR sky130_fd_sc_hd__fill_1
X_5450_ _5458_/A VGND VGND VPWR VPWR _5450_/Y sky130_fd_sc_hd__inv_2
XFILLER_67_3 VGND VGND VPWR VPWR sky130_fd_sc_hd__decap_3
XFILLER_8_284 VGND VGND VPWR VPWR sky130_fd_sc_hd__fill_1
X_4401_ _4659_/A _4517_/C _4517_/D _4518_/A VGND VGND VPWR VPWR _4402_/B sky130_fd_sc_hd__a22o_2
X_5381_ _5381_/A _5620_/A _5381_/C VGND VGND VPWR VPWR _5381_/X sky130_fd_sc_hd__and3_2
X_4332_ _4592_/A _4457_/D _4214_/A _4212_/Y VGND VGND VPWR VPWR _4333_/B sky130_fd_sc_hd__o2bb2a_2
Xfanout208 _6338_/B VGND VGND VPWR VPWR _6353_/C sky130_fd_sc_hd__clkdlybuf4s25_1
X_4263_ _4263_/A _5976_/B _4387_/C _4387_/D VGND VGND VPWR VPWR _4266_/A sky130_fd_sc_hd__and4_2
XFILLER_99_578 VGND VGND VPWR VPWR sky130_fd_sc_hd__decap_3
XFILLER_86_206 VGND VGND VPWR VPWR sky130_fd_sc_hd__decap_3
XFILLER_86_228 VGND VGND VPWR VPWR sky130_fd_sc_hd__decap_3
X_6002_ _6002_/A1 _6008_/A _3993_/X _3992_/Y VGND VGND VPWR VPWR _6003_/B sky130_fd_sc_hd__a31o_2
X_4194_ _4142_/X _4143_/Y _4174_/Y _4192_/X VGND VGND VPWR VPWR _4195_/B sky130_fd_sc_hd__a211o_2
XFILLER_27_306 VGND VGND VPWR VPWR sky130_fd_sc_hd__decap_3
XFILLER_39_155 VGND VGND VPWR VPWR sky130_fd_sc_hd__fill_1
XFILLER_39_166 VGND VGND VPWR VPWR sky130_fd_sc_hd__fill_2
XFILLER_94_294 VGND VGND VPWR VPWR sky130_fd_sc_hd__decap_3
XFILLER_42_309 VGND VGND VPWR VPWR sky130_fd_sc_hd__decap_3
XFILLER_54_147 VGND VGND VPWR VPWR sky130_fd_sc_hd__decap_3
XFILLER_82_456 VGND VGND VPWR VPWR sky130_fd_sc_hd__decap_3
X_6904_ _6904_/A _6904_/B _6904_/C VGND VGND VPWR VPWR _6919_/C sky130_fd_sc_hd__or3_2
XFILLER_24_27 VGND VGND VPWR VPWR sky130_fd_sc_hd__fill_1
XFILLER_62_180 VGND VGND VPWR VPWR sky130_fd_sc_hd__decap_3
X_6835_ _6266_/A _6266_/B _6266_/C _6260_/B VGND VGND VPWR VPWR _6835_/Y sky130_fd_sc_hd__o211ai_2
X_6766_ _6448_/A _6765_/Y _6763_/X VGND VGND VPWR VPWR _6769_/B sky130_fd_sc_hd__o21ai_2
X_3978_ _3977_/A _3977_/B _5983_/B _3909_/D VGND VGND VPWR VPWR _3978_/X sky130_fd_sc_hd__a22o_2
XTAP_TAPCELL_ROW_61_860 VGND VPWR sky130_fd_sc_hd__tapvpwrvgnd_1
XTAP_TAPCELL_ROW_33_562 VGND VPWR sky130_fd_sc_hd__tapvpwrvgnd_1
XFILLER_50_386 VGND VGND VPWR VPWR sky130_fd_sc_hd__decap_3
X_5717_ _5717_/A _5717_/B VGND VGND VPWR VPWR _5721_/B sky130_fd_sc_hd__xor2_2
X_6697_ _3663_/A _6781_/A2 _6810_/B1 _6104_/X _6696_/X VGND VGND VPWR VPWR _6697_/X
+ sky130_fd_sc_hd__o221a_2
X_5648_ _5608_/Y _5646_/X _5645_/Y _5643_/Y VGND VGND VPWR VPWR _5648_/X sky130_fd_sc_hd__o211a_2
XTAP_TAPCELL_ROW_79_1044 VGND VPWR sky130_fd_sc_hd__tapvpwrvgnd_1
X_5579_ _5579_/A _5579_/B _5579_/C VGND VGND VPWR VPWR _5581_/C sky130_fd_sc_hd__or3_2
XFILLER_2_449 VGND VGND VPWR VPWR sky130_fd_sc_hd__fill_1
XFILLER_49_35 VGND VGND VPWR VPWR sky130_fd_sc_hd__decap_3
XFILLER_49_57 VGND VGND VPWR VPWR sky130_fd_sc_hd__fill_2
XFILLER_77_228 VGND VGND VPWR VPWR sky130_fd_sc_hd__fill_1
XFILLER_77_239 VGND VGND VPWR VPWR sky130_fd_sc_hd__decap_3
XFILLER_100_572 VGND VGND VPWR VPWR sky130_fd_sc_hd__decap_3
XFILLER_18_317 VGND VGND VPWR VPWR sky130_fd_sc_hd__decap_3
XTAP_TAPCELL_ROW_5_265 VGND VPWR sky130_fd_sc_hd__tapvpwrvgnd_1
XFILLER_100_583 VGND VGND VPWR VPWR sky130_fd_sc_hd__decap_3
XFILLER_45_125 VGND VGND VPWR VPWR sky130_fd_sc_hd__decap_3
XFILLER_58_486 VGND VGND VPWR VPWR sky130_fd_sc_hd__decap_3
XFILLER_73_412 VGND VGND VPWR VPWR sky130_fd_sc_hd__decap_3
XFILLER_73_445 VGND VGND VPWR VPWR sky130_fd_sc_hd__decap_3
XFILLER_45_169 VGND VGND VPWR VPWR sky130_fd_sc_hd__decap_3
XFILLER_73_467 VGND VGND VPWR VPWR sky130_fd_sc_hd__decap_3
XFILLER_26_383 VGND VGND VPWR VPWR sky130_fd_sc_hd__decap_3
XFILLER_14_545 VGND VGND VPWR VPWR sky130_fd_sc_hd__decap_3
XFILLER_53_180 VGND VGND VPWR VPWR sky130_fd_sc_hd__decap_3
XFILLER_14_589 VGND VGND VPWR VPWR sky130_fd_sc_hd__fill_1
XFILLER_41_353 VGND VGND VPWR VPWR sky130_fd_sc_hd__fill_1
XFILLER_14_71 VGND VGND VPWR VPWR sky130_fd_sc_hd__decap_3
XFILLER_81_88 VGND VGND VPWR VPWR sky130_fd_sc_hd__fill_1
XFILLER_5_276 VGND VGND VPWR VPWR sky130_fd_sc_hd__decap_3
XFILLER_1_471 VGND VGND VPWR VPWR sky130_fd_sc_hd__fill_2
XFILLER_68_206 VGND VGND VPWR VPWR sky130_fd_sc_hd__decap_3
XFILLER_1_493 VGND VGND VPWR VPWR sky130_fd_sc_hd__decap_3
XFILLER_64_401 VGND VGND VPWR VPWR sky130_fd_sc_hd__fill_1
Xinput8 A[16] VGND VGND VPWR VPWR input8/X sky130_fd_sc_hd__clkbuf_2
XTAP_TAPCELL_ROW_67_919 VGND VPWR sky130_fd_sc_hd__tapvpwrvgnd_1
XFILLER_24_309 VGND VGND VPWR VPWR sky130_fd_sc_hd__decap_3
XFILLER_91_231 VGND VGND VPWR VPWR sky130_fd_sc_hd__decap_3
XFILLER_17_350 VGND VGND VPWR VPWR sky130_fd_sc_hd__decap_3
XFILLER_51_128 VGND VGND VPWR VPWR sky130_fd_sc_hd__decap_3
XFILLER_64_489 VGND VGND VPWR VPWR sky130_fd_sc_hd__decap_3
XFILLER_91_297 VGND VGND VPWR VPWR sky130_fd_sc_hd__decap_3
X_4950_ _4950_/A _4950_/B _4950_/C VGND VGND VPWR VPWR _4950_/X sky130_fd_sc_hd__and3_2
X_4881_ _4494_/A _4494_/B _4494_/C VGND VGND VPWR VPWR _4883_/C sky130_fd_sc_hd__o21ai_2
X_3901_ _5995_/B _3969_/A _3969_/B _3969_/D VGND VGND VPWR VPWR _3901_/X sky130_fd_sc_hd__and4_2
X_6620_ _6411_/X _6545_/B _6428_/X _6431_/X _6414_/S _6589_/A VGND VGND VPWR VPWR
+ _6620_/X sky130_fd_sc_hd__mux4_2
X_3832_ _3831_/A _3831_/B _3831_/C VGND VGND VPWR VPWR _3861_/A sky130_fd_sc_hd__o21a_2
X_6551_ _6133_/A _6891_/B1 _6605_/A2 _6217_/B _6550_/Y VGND VGND VPWR VPWR _6561_/A
+ sky130_fd_sc_hd__o221a_2
X_5502_ _5502_/A _5582_/B _5503_/A VGND VGND VPWR VPWR _5502_/X sky130_fd_sc_hd__and3_2
X_3763_ _3747_/X _3762_/Y _3725_/X _3734_/Y VGND VGND VPWR VPWR _4077_/B sky130_fd_sc_hd__o211ai_2
XTAP_TAPCELL_ROW_30_532 VGND VPWR sky130_fd_sc_hd__tapvpwrvgnd_1
X_6482_ _6569_/A _6960_/A _6476_/Y _6481_/X _6638_/A VGND VGND VPWR VPWR _6482_/X
+ sky130_fd_sc_hd__a32o_2
X_3694_ _3618_/A _3617_/B _3617_/A VGND VGND VPWR VPWR _3701_/A sky130_fd_sc_hd__o21ba_2
X_5433_ _5433_/A _5433_/B _5433_/C VGND VGND VPWR VPWR _5433_/Y sky130_fd_sc_hd__nand3_2
X_5364_ _5361_/X _5364_/B _6109_/A _5399_/B VGND VGND VPWR VPWR _5404_/A sky130_fd_sc_hd__and4b_2
X_4315_ _4313_/A _4313_/Y _4197_/Y _4206_/X VGND VGND VPWR VPWR _4315_/X sky130_fd_sc_hd__a211o_2
XFILLER_59_217 VGND VGND VPWR VPWR sky130_fd_sc_hd__decap_3
XFILLER_59_228 VGND VGND VPWR VPWR sky130_fd_sc_hd__decap_3
XFILLER_87_537 VGND VGND VPWR VPWR sky130_fd_sc_hd__decap_3
X_5295_ _5295_/A _5295_/B VGND VGND VPWR VPWR _5296_/C sky130_fd_sc_hd__nor2_2
X_4246_ _4246_/A _4246_/B _4246_/C VGND VGND VPWR VPWR _4246_/Y sky130_fd_sc_hd__nand3_2
XFILLER_74_209 VGND VGND VPWR VPWR sky130_fd_sc_hd__decap_3
X_4177_ _4290_/A _4782_/B _3776_/C VGND VGND VPWR VPWR _4178_/B sky130_fd_sc_hd__a21oi_2
XFILLER_55_423 VGND VGND VPWR VPWR sky130_fd_sc_hd__decap_3
XFILLER_67_272 VGND VGND VPWR VPWR sky130_fd_sc_hd__fill_1
XFILLER_82_220 VGND VGND VPWR VPWR sky130_fd_sc_hd__decap_3
XTAP_TAPCELL_ROW_38_621 VGND VPWR sky130_fd_sc_hd__tapvpwrvgnd_1
XTAP_TAPCELL_ROW_2_235 VGND VPWR sky130_fd_sc_hd__tapvpwrvgnd_1
XFILLER_95_581 VGND VGND VPWR VPWR sky130_fd_sc_hd__fill_1
XFILLER_27_147 VGND VGND VPWR VPWR sky130_fd_sc_hd__fill_1
XFILLER_55_445 VGND VGND VPWR VPWR sky130_fd_sc_hd__decap_3
XFILLER_82_253 VGND VGND VPWR VPWR sky130_fd_sc_hd__decap_3
XFILLER_27_169 VGND VGND VPWR VPWR sky130_fd_sc_hd__decap_3
XFILLER_70_415 VGND VGND VPWR VPWR sky130_fd_sc_hd__decap_3
XFILLER_82_275 VGND VGND VPWR VPWR sky130_fd_sc_hd__decap_3
XFILLER_42_139 VGND VGND VPWR VPWR sky130_fd_sc_hd__fill_1
X_6818_ _6853_/A _6808_/Y _6812_/X _6817_/Y VGND VGND VPWR VPWR _6818_/Y sky130_fd_sc_hd__o211ai_2
XFILLER_11_526 VGND VGND VPWR VPWR sky130_fd_sc_hd__decap_3
XFILLER_50_183 VGND VGND VPWR VPWR sky130_fd_sc_hd__decap_3
XFILLER_11_559 VGND VGND VPWR VPWR sky130_fd_sc_hd__fill_1
X_6749_ _6758_/A _6797_/A2 _6781_/A2 _6100_/B _6748_/Y VGND VGND VPWR VPWR _6749_/X
+ sky130_fd_sc_hd__o221a_2
XFILLER_65_209 VGND VGND VPWR VPWR sky130_fd_sc_hd__decap_3
Xfanout561 _5382_/B VGND VGND VPWR VPWR _5341_/B sky130_fd_sc_hd__buf_6
Xfanout583 wire590/A VGND VGND VPWR VPWR _6552_/A3 sky130_fd_sc_hd__buf_4
XFILLER_93_529 VGND VGND VPWR VPWR sky130_fd_sc_hd__decap_3
XFILLER_58_283 VGND VGND VPWR VPWR sky130_fd_sc_hd__decap_3
XFILLER_86_592 VGND VGND VPWR VPWR sky130_fd_sc_hd__decap_3
Xfanout594 input20/X VGND VGND VPWR VPWR _4176_/A sky130_fd_sc_hd__clkdlybuf4s25_1
XFILLER_46_445 VGND VGND VPWR VPWR sky130_fd_sc_hd__decap_3
XFILLER_73_253 VGND VGND VPWR VPWR sky130_fd_sc_hd__decap_3
XFILLER_92_10 VGND VGND VPWR VPWR sky130_fd_sc_hd__decap_3
XFILLER_33_106 VGND VGND VPWR VPWR sky130_fd_sc_hd__decap_3
XFILLER_61_404 VGND VGND VPWR VPWR sky130_fd_sc_hd__fill_1
XFILLER_33_139 VGND VGND VPWR VPWR sky130_fd_sc_hd__decap_3
XFILLER_25_81 VGND VGND VPWR VPWR sky130_fd_sc_hd__decap_3
XTAP_TAPCELL_ROW_72_977 VGND VPWR sky130_fd_sc_hd__tapvpwrvgnd_1
XTAP_TAPCELL_ROW_44_679 VGND VPWR sky130_fd_sc_hd__tapvpwrvgnd_1
XFILLER_41_172 VGND VGND VPWR VPWR sky130_fd_sc_hd__decap_3
XFILLER_6_530 VGND VGND VPWR VPWR sky130_fd_sc_hd__fill_2
XFILLER_6_541 VGND VGND VPWR VPWR sky130_fd_sc_hd__decap_3
XFILLER_6_574 VGND VGND VPWR VPWR sky130_fd_sc_hd__decap_3
XFILLER_96_312 VGND VGND VPWR VPWR sky130_fd_sc_hd__decap_3
X_5080_ _5080_/A _5080_/B VGND VGND VPWR VPWR _5081_/C sky130_fd_sc_hd__xnor2_2
X_4100_ _4476_/A _4097_/B _4099_/B _4096_/X VGND VGND VPWR VPWR _4103_/B sky130_fd_sc_hd__a31oi_2
XFILLER_84_518 VGND VGND VPWR VPWR sky130_fd_sc_hd__decap_3
X_4031_ _4031_/A _4031_/B VGND VGND VPWR VPWR _4043_/A sky130_fd_sc_hd__xor2_2
XFILLER_49_261 VGND VGND VPWR VPWR sky130_fd_sc_hd__decap_3
XFILLER_77_570 VGND VGND VPWR VPWR sky130_fd_sc_hd__decap_3
XFILLER_64_242 VGND VGND VPWR VPWR sky130_fd_sc_hd__decap_3
XFILLER_52_415 VGND VGND VPWR VPWR sky130_fd_sc_hd__decap_3
XFILLER_64_253 VGND VGND VPWR VPWR sky130_fd_sc_hd__decap_3
XFILLER_92_595 VGND VGND VPWR VPWR sky130_fd_sc_hd__decap_3
X_5982_ _5983_/A _5983_/B _3909_/D _5983_/D VGND VGND VPWR VPWR _5984_/C sky130_fd_sc_hd__a22o_2
XFILLER_52_459 VGND VGND VPWR VPWR sky130_fd_sc_hd__fill_1
X_4933_ _4934_/A _4934_/B VGND VGND VPWR VPWR _4933_/Y sky130_fd_sc_hd__nand2_2
XFILLER_32_150 VGND VGND VPWR VPWR sky130_fd_sc_hd__decap_3
X_4864_ _4860_/A _4861_/Y _4813_/B _4816_/B VGND VGND VPWR VPWR _4864_/X sky130_fd_sc_hd__o211a_2
XTAP_TAPCELL_ROW_15_370 VGND VPWR sky130_fd_sc_hd__tapvpwrvgnd_1
XFILLER_20_356 VGND VGND VPWR VPWR sky130_fd_sc_hd__decap_3
X_6603_ _6657_/B _6602_/Y _6392_/Y VGND VGND VPWR VPWR _6611_/B sky130_fd_sc_hd__a21oi_2
X_4795_ _4792_/X _4795_/B VGND VGND VPWR VPWR _4983_/B sky130_fd_sc_hd__and2b_2
X_3815_ _5983_/D _3814_/C _3814_/D _5976_/D VGND VGND VPWR VPWR _3816_/B sky130_fd_sc_hd__a22o_2
X_6534_ _6498_/A _6813_/B _6532_/Y _6939_/S VGND VGND VPWR VPWR _6534_/X sky130_fd_sc_hd__o22a_2
X_3746_ _3723_/A _3723_/C _3723_/B VGND VGND VPWR VPWR _3747_/C sky130_fd_sc_hd__a21o_2
X_6465_ _6465_/A _6465_/B VGND VGND VPWR VPWR _6465_/X sky130_fd_sc_hd__or2_2
XTAP_TAPCELL_ROW_76_1014 VGND VPWR sky130_fd_sc_hd__tapvpwrvgnd_1
X_5416_ _5376_/X _5378_/Y _5414_/A _5414_/Y VGND VGND VPWR VPWR _5417_/C sky130_fd_sc_hd__o211ai_2
X_3677_ _3635_/Y _4075_/A VGND VGND VPWR VPWR _3733_/A sky130_fd_sc_hd__nand2b_2
X_6396_ _6394_/X _6395_/X _6456_/S VGND VGND VPWR VPWR _6396_/X sky130_fd_sc_hd__mux2_1
XFILLER_87_301 VGND VGND VPWR VPWR sky130_fd_sc_hd__decap_3
X_5347_ _5340_/A _5203_/D _5343_/B _5341_/X VGND VGND VPWR VPWR _5349_/B sky130_fd_sc_hd__a31o_2
XFILLER_87_345 VGND VGND VPWR VPWR sky130_fd_sc_hd__decap_3
X_5278_ _5278_/A _5367_/A VGND VGND VPWR VPWR _5283_/A sky130_fd_sc_hd__nor2_2
XFILLER_87_367 VGND VGND VPWR VPWR sky130_fd_sc_hd__decap_3
X_4229_ _4229_/A VGND VGND VPWR VPWR _4229_/Y sky130_fd_sc_hd__inv_2
XFILLER_28_412 VGND VGND VPWR VPWR sky130_fd_sc_hd__decap_3
XFILLER_46_25 VGND VGND VPWR VPWR sky130_fd_sc_hd__decap_3
XFILLER_68_592 VGND VGND VPWR VPWR sky130_fd_sc_hd__fill_1
XTAP_TAPCELL_ROW_87_1132 VGND VPWR sky130_fd_sc_hd__tapvpwrvgnd_1
XFILLER_15_117 VGND VGND VPWR VPWR sky130_fd_sc_hd__decap_3
XFILLER_28_489 VGND VGND VPWR VPWR sky130_fd_sc_hd__fill_1
XFILLER_43_426 VGND VGND VPWR VPWR sky130_fd_sc_hd__fill_1
XFILLER_83_573 VGND VGND VPWR VPWR sky130_fd_sc_hd__decap_3
XFILLER_55_297 VGND VGND VPWR VPWR sky130_fd_sc_hd__decap_3
XFILLER_70_212 VGND VGND VPWR VPWR sky130_fd_sc_hd__decap_3
XFILLER_70_256 VGND VGND VPWR VPWR sky130_fd_sc_hd__decap_3
XFILLER_11_312 VGND VGND VPWR VPWR sky130_fd_sc_hd__decap_3
XFILLER_23_172 VGND VGND VPWR VPWR sky130_fd_sc_hd__decap_3
XTAP_TAPCELL_ROW_41_649 VGND VPWR sky130_fd_sc_hd__tapvpwrvgnd_1
XFILLER_23_194 VGND VGND VPWR VPWR sky130_fd_sc_hd__decap_3
XFILLER_11_389 VGND VGND VPWR VPWR sky130_fd_sc_hd__decap_3
XTAP_TAPCELL_ROW_98_1250 VGND VPWR sky130_fd_sc_hd__tapvpwrvgnd_1
Xload_slew219 _6110_/B VGND VGND VPWR VPWR _5680_/B sky130_fd_sc_hd__buf_4
XFILLER_78_312 VGND VGND VPWR VPWR sky130_fd_sc_hd__decap_3
XFILLER_38_209 VGND VGND VPWR VPWR sky130_fd_sc_hd__decap_3
XFILLER_66_518 VGND VGND VPWR VPWR sky130_fd_sc_hd__fill_2
XFILLER_59_581 VGND VGND VPWR VPWR sky130_fd_sc_hd__fill_1
XFILLER_66_529 VGND VGND VPWR VPWR sky130_fd_sc_hd__decap_3
XFILLER_93_337 VGND VGND VPWR VPWR sky130_fd_sc_hd__decap_3
XTAP_TAPCELL_ROW_49_727 VGND VPWR sky130_fd_sc_hd__tapvpwrvgnd_1
XFILLER_46_275 VGND VGND VPWR VPWR sky130_fd_sc_hd__fill_1
XFILLER_74_562 VGND VGND VPWR VPWR sky130_fd_sc_hd__decap_3
XFILLER_36_91 VGND VGND VPWR VPWR sky130_fd_sc_hd__decap_3
XFILLER_61_234 VGND VGND VPWR VPWR sky130_fd_sc_hd__decap_3
XFILLER_74_595 VGND VGND VPWR VPWR sky130_fd_sc_hd__decap_3
XFILLER_61_256 VGND VGND VPWR VPWR sky130_fd_sc_hd__decap_3
XFILLER_61_278 VGND VGND VPWR VPWR sky130_fd_sc_hd__fill_2
Xinput11 A[19] VGND VGND VPWR VPWR input11/X sky130_fd_sc_hd__clkdlybuf4s25_1
Xinput22 A[29] VGND VGND VPWR VPWR _6196_/B sky130_fd_sc_hd__clkdlybuf4s25_1
X_4580_ _6248_/B _4785_/B VGND VGND VPWR VPWR _4783_/A sky130_fd_sc_hd__nand2_2
X_3600_ _3824_/A _3600_/B VGND VGND VPWR VPWR _3602_/B sky130_fd_sc_hd__and2_2
XTAP_TAPCELL_ROW_12_340 VGND VPWR sky130_fd_sc_hd__tapvpwrvgnd_1
Xinput55 B[2] VGND VGND VPWR VPWR input55/X sky130_fd_sc_hd__clkbuf_2
Xinput44 B[1] VGND VGND VPWR VPWR input44/X sky130_fd_sc_hd__clkdlybuf4s25_1
Xinput33 B[0] VGND VGND VPWR VPWR input33/X sky130_fd_sc_hd__dlymetal6s4s_1
X_3531_ _3531_/A _3531_/B _3767_/A VGND VGND VPWR VPWR _3532_/B sky130_fd_sc_hd__nor3_2
XFILLER_6_360 VGND VGND VPWR VPWR sky130_fd_sc_hd__decap_3
Xinput66 opcode[1] VGND VGND VPWR VPWR _6338_/A sky130_fd_sc_hd__clkdlybuf4s25_1
X_6250_ _6758_/C _6250_/B VGND VGND VPWR VPWR _6250_/X sky130_fd_sc_hd__and2_2
X_6181_ _6276_/A _6182_/B VGND VGND VPWR VPWR _6192_/A sky130_fd_sc_hd__nand2_2
X_5201_ _5341_/B _5340_/A _5341_/C _5341_/D VGND VGND VPWR VPWR _5204_/A sky130_fd_sc_hd__and4_2
XFILLER_69_334 VGND VGND VPWR VPWR sky130_fd_sc_hd__fill_2
X_5132_ _5056_/B _5056_/C _5056_/A VGND VGND VPWR VPWR _5133_/C sky130_fd_sc_hd__o21ai_2
XFILLER_29_209 VGND VGND VPWR VPWR sky130_fd_sc_hd__fill_2
XFILLER_69_389 VGND VGND VPWR VPWR sky130_fd_sc_hd__decap_3
X_5063_ _5061_/X _5045_/Y _5062_/X _4972_/Y VGND VGND VPWR VPWR _5081_/A sky130_fd_sc_hd__a211o_4
XFILLER_37_231 VGND VGND VPWR VPWR sky130_fd_sc_hd__fill_2
X_4014_ _5995_/B _5992_/A VGND VGND VPWR VPWR _4015_/B sky130_fd_sc_hd__nand2_2
XFILLER_16_39 VGND VGND VPWR VPWR sky130_fd_sc_hd__decap_3
XFILLER_52_212 VGND VGND VPWR VPWR sky130_fd_sc_hd__decap_3
XFILLER_52_234 VGND VGND VPWR VPWR sky130_fd_sc_hd__decap_3
XFILLER_80_521 VGND VGND VPWR VPWR sky130_fd_sc_hd__decap_3
XFILLER_92_392 VGND VGND VPWR VPWR sky130_fd_sc_hd__fill_2
XFILLER_52_256 VGND VGND VPWR VPWR sky130_fd_sc_hd__decap_3
X_5965_ _5965_/A _5965_/B VGND VGND VPWR VPWR _5972_/A sky130_fd_sc_hd__nor2_2
X_5896_ _5896_/A VGND VGND VPWR VPWR _5896_/Y sky130_fd_sc_hd__inv_2
X_4916_ _4913_/X _4916_/A2 _4871_/Y _4876_/C VGND VGND VPWR VPWR _4916_/X sky130_fd_sc_hd__o211a_2
XTAP_TAPCELL_ROW_82_1073 VGND VPWR sky130_fd_sc_hd__tapvpwrvgnd_1
XFILLER_20_131 VGND VGND VPWR VPWR sky130_fd_sc_hd__decap_3
XFILLER_33_492 VGND VGND VPWR VPWR sky130_fd_sc_hd__decap_3
X_4847_ _4848_/A _4848_/B _4848_/C VGND VGND VPWR VPWR _4847_/X sky130_fd_sc_hd__and3_2
XFILLER_20_197 VGND VGND VPWR VPWR sky130_fd_sc_hd__decap_3
X_4778_ _4775_/X _4776_/Y _4744_/B _4747_/B VGND VGND VPWR VPWR _4778_/X sky130_fd_sc_hd__o211a_2
X_6517_ _6119_/Y _6130_/Y _6778_/B1 VGND VGND VPWR VPWR _6517_/Y sky130_fd_sc_hd__a21oi_2
X_3729_ _3729_/A _3729_/B VGND VGND VPWR VPWR _3730_/C sky130_fd_sc_hd__xnor2_2
X_6448_ _6448_/A VGND VGND VPWR VPWR _6448_/Y sky130_fd_sc_hd__inv_2
XFILLER_0_503 VGND VGND VPWR VPWR sky130_fd_sc_hd__fill_1
X_6379_ _6378_/A _6378_/B _6375_/Y VGND VGND VPWR VPWR _6386_/C sky130_fd_sc_hd__o21ai_2
XFILLER_0_536 VGND VGND VPWR VPWR sky130_fd_sc_hd__decap_3
XTAP_TAPCELL_ROW_93_1191 VGND VPWR sky130_fd_sc_hd__tapvpwrvgnd_1
XFILLER_48_507 VGND VGND VPWR VPWR sky130_fd_sc_hd__decap_3
XFILLER_87_153 VGND VGND VPWR VPWR sky130_fd_sc_hd__decap_3
XFILLER_57_57 VGND VGND VPWR VPWR sky130_fd_sc_hd__decap_3
XFILLER_87_186 VGND VGND VPWR VPWR sky130_fd_sc_hd__decap_3
XFILLER_56_540 VGND VGND VPWR VPWR sky130_fd_sc_hd__decap_3
XFILLER_28_242 VGND VGND VPWR VPWR sky130_fd_sc_hd__decap_3
XFILLER_28_253 VGND VGND VPWR VPWR sky130_fd_sc_hd__fill_1
XFILLER_56_562 VGND VGND VPWR VPWR sky130_fd_sc_hd__decap_3
XFILLER_90_307 VGND VGND VPWR VPWR sky130_fd_sc_hd__fill_1
XFILLER_43_234 VGND VGND VPWR VPWR sky130_fd_sc_hd__decap_3
XFILLER_56_595 VGND VGND VPWR VPWR sky130_fd_sc_hd__decap_3
XFILLER_73_34 VGND VGND VPWR VPWR sky130_fd_sc_hd__decap_3
XTAP_TAPCELL_ROW_54_785 VGND VPWR sky130_fd_sc_hd__tapvpwrvgnd_1
XTAP_TAPCELL_ROW_26_487 VGND VPWR sky130_fd_sc_hd__tapvpwrvgnd_1
XFILLER_11_142 VGND VGND VPWR VPWR sky130_fd_sc_hd__decap_3
XFILLER_7_102 VGND VGND VPWR VPWR sky130_fd_sc_hd__decap_3
XFILLER_7_113 VGND VGND VPWR VPWR sky130_fd_sc_hd__fill_1
XFILLER_22_60 VGND VGND VPWR VPWR sky130_fd_sc_hd__decap_3
XFILLER_22_93 VGND VGND VPWR VPWR sky130_fd_sc_hd__fill_2
XFILLER_98_429 VGND VGND VPWR VPWR sky130_fd_sc_hd__decap_3
XFILLER_98_418 VGND VGND VPWR VPWR sky130_fd_sc_hd__fill_2
XFILLER_78_153 VGND VGND VPWR VPWR sky130_fd_sc_hd__decap_3
XFILLER_66_315 VGND VGND VPWR VPWR sky130_fd_sc_hd__decap_3
XFILLER_19_220 VGND VGND VPWR VPWR sky130_fd_sc_hd__decap_3
XFILLER_78_197 VGND VGND VPWR VPWR sky130_fd_sc_hd__decap_3
XFILLER_47_90 VGND VGND VPWR VPWR sky130_fd_sc_hd__decap_3
XFILLER_93_156 VGND VGND VPWR VPWR sky130_fd_sc_hd__decap_3
XFILLER_34_212 VGND VGND VPWR VPWR sky130_fd_sc_hd__decap_3
XFILLER_62_543 VGND VGND VPWR VPWR sky130_fd_sc_hd__decap_3
XFILLER_34_256 VGND VGND VPWR VPWR sky130_fd_sc_hd__decap_3
X_5750_ _5750_/A _5750_/B VGND VGND VPWR VPWR _5755_/B sky130_fd_sc_hd__xnor2_2
X_5681_ _5681_/A _5713_/B VGND VGND VPWR VPWR _5714_/B sky130_fd_sc_hd__nor2_2
X_4701_ _4700_/A _4700_/C _4700_/B VGND VGND VPWR VPWR _4702_/B sky130_fd_sc_hd__a21o_2
XFILLER_30_451 VGND VGND VPWR VPWR sky130_fd_sc_hd__decap_3
XFILLER_30_473 VGND VGND VPWR VPWR sky130_fd_sc_hd__decap_3
X_4632_ _4632_/A _4632_/B VGND VGND VPWR VPWR _4638_/B sky130_fd_sc_hd__xnor2_2
X_4563_ _4445_/B _4452_/X _4563_/B1 _4561_/Y VGND VGND VPWR VPWR _4563_/X sky130_fd_sc_hd__o211a_2
X_6302_ _6299_/X _6301_/X _6924_/S VGND VGND VPWR VPWR _6302_/X sky130_fd_sc_hd__mux2_1
X_4494_ _4494_/A _4494_/B _4494_/C VGND VGND VPWR VPWR _4883_/A sky130_fd_sc_hd__or3_4
X_3514_ _3511_/X _3514_/B VGND VGND VPWR VPWR _3521_/B sky130_fd_sc_hd__and2b_2
X_6233_ _6566_/A _6233_/B VGND VGND VPWR VPWR _6584_/B sky130_fd_sc_hd__nor2_2
XFILLER_69_131 VGND VGND VPWR VPWR sky130_fd_sc_hd__decap_3
Xload_slew550 _5529_/A VGND VGND VPWR VPWR _5701_/A sky130_fd_sc_hd__buf_6
X_6164_ _6087_/A _6824_/A2 _6082_/Y VGND VGND VPWR VPWR _6842_/C sky130_fd_sc_hd__a21o_2
XFILLER_57_304 VGND VGND VPWR VPWR sky130_fd_sc_hd__decap_3
XFILLER_69_175 VGND VGND VPWR VPWR sky130_fd_sc_hd__decap_3
X_6095_ _6095_/A _6095_/B VGND VGND VPWR VPWR _6209_/A sky130_fd_sc_hd__nand2_2
X_5115_ _5341_/B _5115_/B VGND VGND VPWR VPWR _5117_/B sky130_fd_sc_hd__and2_2
XFILLER_97_473 VGND VGND VPWR VPWR sky130_fd_sc_hd__fill_1
XFILLER_57_337 VGND VGND VPWR VPWR sky130_fd_sc_hd__decap_3
XFILLER_84_134 VGND VGND VPWR VPWR sky130_fd_sc_hd__decap_3
X_5046_ _5311_/A _5046_/B _5341_/C _5341_/D VGND VGND VPWR VPWR _5046_/X sky130_fd_sc_hd__and4_2
XFILLER_27_38 VGND VGND VPWR VPWR sky130_fd_sc_hd__decap_3
XFILLER_38_551 VGND VGND VPWR VPWR sky130_fd_sc_hd__fill_1
XFILLER_72_318 VGND VGND VPWR VPWR sky130_fd_sc_hd__decap_3
XFILLER_84_156 VGND VGND VPWR VPWR sky130_fd_sc_hd__decap_3
XFILLER_53_532 VGND VGND VPWR VPWR sky130_fd_sc_hd__decap_3
XTAP_TAPCELL_ROW_84_1102 VGND VPWR sky130_fd_sc_hd__tapvpwrvgnd_1
XFILLER_25_234 VGND VGND VPWR VPWR sky130_fd_sc_hd__decap_3
XFILLER_25_256 VGND VGND VPWR VPWR sky130_fd_sc_hd__decap_3
XFILLER_80_351 VGND VGND VPWR VPWR sky130_fd_sc_hd__decap_3
X_6997_ _6349_/Y _6350_/X _6997_/S VGND VGND VPWR VPWR _6997_/X sky130_fd_sc_hd__mux2_4
XFILLER_80_395 VGND VGND VPWR VPWR sky130_fd_sc_hd__decap_3
X_5948_ _5948_/A _6187_/B VGND VGND VPWR VPWR _5949_/B sky130_fd_sc_hd__nand2_2
XFILLER_21_440 VGND VGND VPWR VPWR sky130_fd_sc_hd__fill_2
XFILLER_40_237 VGND VGND VPWR VPWR sky130_fd_sc_hd__decap_3
XFILLER_40_259 VGND VGND VPWR VPWR sky130_fd_sc_hd__decap_3
XTAP_TAPCELL_ROW_51_755 VGND VPWR sky130_fd_sc_hd__tapvpwrvgnd_1
Xrebuffer700 _6992_/A VGND VGND VPWR VPWR output85/A sky130_fd_sc_hd__buf_6
X_5879_ _4883_/Y _4889_/B _5878_/Y _4553_/X VGND VGND VPWR VPWR _5882_/A sky130_fd_sc_hd__a211oi_2
XTAP_TAPCELL_ROW_23_457 VGND VPWR sky130_fd_sc_hd__tapvpwrvgnd_1
Xrebuffer711 _5413_/C VGND VGND VPWR VPWR _5474_/B1 sky130_fd_sc_hd__buf_2
Xrebuffer733 _4350_/X VGND VGND VPWR VPWR _4351_/A sky130_fd_sc_hd__buf_2
Xrebuffer744 _4736_/B VGND VGND VPWR VPWR _4754_/A sky130_fd_sc_hd__buf_2
Xrebuffer755 _5273_/C VGND VGND VPWR VPWR _5274_/B sky130_fd_sc_hd__buf_2
Xrebuffer766 _4914_/Y VGND VGND VPWR VPWR _4916_/A2 sky130_fd_sc_hd__buf_2
XFILLER_4_149 VGND VGND VPWR VPWR sky130_fd_sc_hd__decap_3
XFILLER_68_12 VGND VGND VPWR VPWR sky130_fd_sc_hd__fill_2
XFILLER_68_45 VGND VGND VPWR VPWR sky130_fd_sc_hd__decap_3
XFILLER_0_333 VGND VGND VPWR VPWR sky130_fd_sc_hd__decap_3
XFILLER_88_462 VGND VGND VPWR VPWR sky130_fd_sc_hd__decap_3
XFILLER_29_540 VGND VGND VPWR VPWR sky130_fd_sc_hd__fill_2
XFILLER_48_337 VGND VGND VPWR VPWR sky130_fd_sc_hd__decap_3
XFILLER_84_22 VGND VGND VPWR VPWR sky130_fd_sc_hd__decap_3
XTAP_TAPCELL_ROW_59_833 VGND VPWR sky130_fd_sc_hd__tapvpwrvgnd_1
XFILLER_75_167 VGND VGND VPWR VPWR sky130_fd_sc_hd__fill_1
XFILLER_75_178 VGND VGND VPWR VPWR sky130_fd_sc_hd__decap_3
XFILLER_29_595 VGND VGND VPWR VPWR sky130_fd_sc_hd__decap_3
XFILLER_56_392 VGND VGND VPWR VPWR sky130_fd_sc_hd__fill_2
XFILLER_84_66 VGND VGND VPWR VPWR sky130_fd_sc_hd__fill_1
XFILLER_16_256 VGND VGND VPWR VPWR sky130_fd_sc_hd__decap_3
XFILLER_71_384 VGND VGND VPWR VPWR sky130_fd_sc_hd__decap_3
XFILLER_12_451 VGND VGND VPWR VPWR sky130_fd_sc_hd__decap_3
XFILLER_8_411 VGND VGND VPWR VPWR sky130_fd_sc_hd__decap_3
XTAP_TAPCELL_ROW_100_1268 VGND VPWR sky130_fd_sc_hd__tapvpwrvgnd_1
XFILLER_12_495 VGND VGND VPWR VPWR sky130_fd_sc_hd__decap_3
XFILLER_8_455 VGND VGND VPWR VPWR sky130_fd_sc_hd__decap_3
XTAP_TAPCELL_ROW_100_1279 VGND VPWR sky130_fd_sc_hd__tapvpwrvgnd_1
XFILLER_8_477 VGND VGND VPWR VPWR sky130_fd_sc_hd__fill_2
XPHY_EDGE_ROW_89_Left_190 VGND VGND VPWR VPWR sky130_fd_sc_hd__decap_3
XFILLER_98_237 VGND VGND VPWR VPWR sky130_fd_sc_hd__fill_2
XFILLER_98_259 VGND VGND VPWR VPWR sky130_fd_sc_hd__decap_3
XFILLER_39_315 VGND VGND VPWR VPWR sky130_fd_sc_hd__decap_3
XFILLER_79_473 VGND VGND VPWR VPWR sky130_fd_sc_hd__decap_3
XFILLER_12_3 VGND VGND VPWR VPWR sky130_fd_sc_hd__decap_3
XFILLER_39_337 VGND VGND VPWR VPWR sky130_fd_sc_hd__fill_1
XFILLER_39_348 VGND VGND VPWR VPWR sky130_fd_sc_hd__decap_3
XFILLER_66_112 VGND VGND VPWR VPWR sky130_fd_sc_hd__fill_2
XFILLER_94_454 VGND VGND VPWR VPWR sky130_fd_sc_hd__decap_3
XFILLER_94_421 VGND VGND VPWR VPWR sky130_fd_sc_hd__decap_3
XFILLER_54_307 VGND VGND VPWR VPWR sky130_fd_sc_hd__fill_1
X_6920_ _6919_/B _6919_/C _6931_/A VGND VGND VPWR VPWR _6920_/Y sky130_fd_sc_hd__a21oi_2
XFILLER_35_543 VGND VGND VPWR VPWR sky130_fd_sc_hd__decap_3
X_6851_ _6842_/A _6851_/B _6851_/C VGND VGND VPWR VPWR _6853_/B sky130_fd_sc_hd__and3b_2
X_5802_ _6465_/A _6465_/B VGND VGND VPWR VPWR _6484_/B sky130_fd_sc_hd__nand2_2
XFILLER_22_226 VGND VGND VPWR VPWR sky130_fd_sc_hd__decap_3
X_6782_ _6093_/B _6024_/B _6025_/B _3923_/B _6405_/S _6876_/S1 VGND VGND VPWR VPWR
+ _6782_/X sky130_fd_sc_hd__mux4_2
X_3994_ _3992_/A _5994_/A _3993_/X VGND VGND VPWR VPWR _3995_/B sky130_fd_sc_hd__o21a_2
X_5733_ _5733_/A _5733_/B VGND VGND VPWR VPWR _5735_/B sky130_fd_sc_hd__nor2_2
X_5664_ _5664_/A _5664_/B _5664_/C VGND VGND VPWR VPWR _5700_/A sky130_fd_sc_hd__nand3_2
XTAP_TAPCELL_ROW_20_427 VGND VPWR sky130_fd_sc_hd__tapvpwrvgnd_1
X_5595_ _5594_/A _5634_/A VGND VGND VPWR VPWR _5596_/B sky130_fd_sc_hd__nand2b_2
X_4615_ _4615_/A _4615_/B VGND VGND VPWR VPWR _4643_/A sky130_fd_sc_hd__xnor2_2
X_4546_ _4544_/A _4544_/B _4544_/C VGND VGND VPWR VPWR _4547_/C sky130_fd_sc_hd__o21ai_2
XFILLER_89_215 VGND VGND VPWR VPWR sky130_fd_sc_hd__decap_3
XFILLER_89_237 VGND VGND VPWR VPWR sky130_fd_sc_hd__decap_3
Xmax_cap163 _6202_/Y VGND VGND VPWR VPWR fanout160/A sky130_fd_sc_hd__clkdlybuf4s25_1
X_4477_ _4593_/A _4593_/C _4593_/D _4592_/A VGND VGND VPWR VPWR _4478_/B sky130_fd_sc_hd__a22o_2
X_6216_ _6217_/B _6216_/B VGND VGND VPWR VPWR _6231_/B sky130_fd_sc_hd__nand2b_2
X_6147_ _6383_/A _6672_/B VGND VGND VPWR VPWR _6155_/C sky130_fd_sc_hd__nand2_2
XTAP_TAPCELL_ROW_90_1161 VGND VPWR sky130_fd_sc_hd__tapvpwrvgnd_1
XFILLER_57_123 VGND VGND VPWR VPWR sky130_fd_sc_hd__decap_3
XFILLER_85_432 VGND VGND VPWR VPWR sky130_fd_sc_hd__fill_1
Xload_slew380 _4592_/B VGND VGND VPWR VPWR _4476_/B sky130_fd_sc_hd__buf_4
XFILLER_97_281 VGND VGND VPWR VPWR sky130_fd_sc_hd__fill_2
XFILLER_57_156 VGND VGND VPWR VPWR sky130_fd_sc_hd__decap_3
XFILLER_57_178 VGND VGND VPWR VPWR sky130_fd_sc_hd__decap_3
X_6078_ _6079_/A _6265_/B VGND VGND VPWR VPWR _6168_/A sky130_fd_sc_hd__nand2_2
XTAP_TAPCELL_ROW_56_803 VGND VPWR sky130_fd_sc_hd__tapvpwrvgnd_1
XFILLER_26_521 VGND VGND VPWR VPWR sky130_fd_sc_hd__decap_3
XFILLER_85_498 VGND VGND VPWR VPWR sky130_fd_sc_hd__decap_3
X_5029_ _4940_/B _4940_/C _4940_/A VGND VGND VPWR VPWR _5030_/C sky130_fd_sc_hd__a21oi_2
XTAP_TAPCELL_ROW_28_516 VGND VPWR sky130_fd_sc_hd__tapvpwrvgnd_1
XFILLER_26_543 VGND VGND VPWR VPWR sky130_fd_sc_hd__decap_3
XFILLER_26_554 VGND VGND VPWR VPWR sky130_fd_sc_hd__decap_3
XFILLER_72_159 VGND VGND VPWR VPWR sky130_fd_sc_hd__decap_3
XFILLER_13_237 VGND VGND VPWR VPWR sky130_fd_sc_hd__decap_3
XTAP_TAPCELL_ROW_64_891 VGND VPWR sky130_fd_sc_hd__tapvpwrvgnd_1
XTAP_TAPCELL_ROW_36_593 VGND VPWR sky130_fd_sc_hd__tapvpwrvgnd_1
XFILLER_21_281 VGND VGND VPWR VPWR sky130_fd_sc_hd__decap_3
XFILLER_70_46 VGND VGND VPWR VPWR sky130_fd_sc_hd__fill_1
XFILLER_79_33 VGND VGND VPWR VPWR sky130_fd_sc_hd__fill_2
XFILLER_79_77 VGND VGND VPWR VPWR sky130_fd_sc_hd__decap_3
XFILLER_0_141 VGND VGND VPWR VPWR sky130_fd_sc_hd__decap_3
XFILLER_0_163 VGND VGND VPWR VPWR sky130_fd_sc_hd__decap_3
XFILLER_88_270 VGND VGND VPWR VPWR sky130_fd_sc_hd__decap_3
XTAP_TAPCELL_ROW_8_296 VGND VPWR sky130_fd_sc_hd__tapvpwrvgnd_1
XFILLER_48_112 VGND VGND VPWR VPWR sky130_fd_sc_hd__decap_3
XFILLER_48_134 VGND VGND VPWR VPWR sky130_fd_sc_hd__decap_3
XFILLER_48_167 VGND VGND VPWR VPWR sky130_fd_sc_hd__decap_3
XFILLER_63_137 VGND VGND VPWR VPWR sky130_fd_sc_hd__decap_3
XFILLER_91_468 VGND VGND VPWR VPWR sky130_fd_sc_hd__decap_3
XFILLER_71_181 VGND VGND VPWR VPWR sky130_fd_sc_hd__decap_3
XFILLER_12_270 VGND VGND VPWR VPWR sky130_fd_sc_hd__fill_2
XFILLER_81_6 VGND VGND VPWR VPWR sky130_fd_sc_hd__decap_3
X_4400_ _4524_/A _4518_/B VGND VGND VPWR VPWR _4511_/A sky130_fd_sc_hd__nand2_2
XFILLER_5_30 VGND VGND VPWR VPWR sky130_fd_sc_hd__fill_1
X_5380_ _5331_/A _5331_/C _6133_/A VGND VGND VPWR VPWR _5381_/C sky130_fd_sc_hd__o21ai_2
XFILLER_5_63 VGND VGND VPWR VPWR sky130_fd_sc_hd__decap_3
X_4331_ _4331_/A _4331_/B VGND VGND VPWR VPWR _4344_/A sky130_fd_sc_hd__xnor2_2
XFILLER_99_524 VGND VGND VPWR VPWR sky130_fd_sc_hd__decap_3
XFILLER_4_480 VGND VGND VPWR VPWR sky130_fd_sc_hd__fill_1
Xfanout209 _5321_/D VGND VGND VPWR VPWR _5341_/D sky130_fd_sc_hd__buf_4
X_4262_ _4262_/A _4262_/B VGND VGND VPWR VPWR _4269_/A sky130_fd_sc_hd__nand2_2
X_6001_ _6001_/A _6001_/B VGND VGND VPWR VPWR _6012_/A sky130_fd_sc_hd__xnor2_2
XFILLER_67_443 VGND VGND VPWR VPWR sky130_fd_sc_hd__decap_3
X_4193_ _4174_/Y _4192_/X _4142_/X _4143_/Y VGND VGND VPWR VPWR _4195_/A sky130_fd_sc_hd__o211ai_2
XFILLER_67_476 VGND VGND VPWR VPWR sky130_fd_sc_hd__decap_3
XFILLER_94_262 VGND VGND VPWR VPWR sky130_fd_sc_hd__decap_3
XFILLER_39_189 VGND VGND VPWR VPWR sky130_fd_sc_hd__decap_3
XFILLER_35_340 VGND VGND VPWR VPWR sky130_fd_sc_hd__decap_3
XFILLER_54_159 VGND VGND VPWR VPWR sky130_fd_sc_hd__decap_3
X_6903_ _6904_/B _6904_/C _6904_/A VGND VGND VPWR VPWR _6903_/Y sky130_fd_sc_hd__o21ai_2
XFILLER_35_362 VGND VGND VPWR VPWR sky130_fd_sc_hd__decap_3
XFILLER_23_546 VGND VGND VPWR VPWR sky130_fd_sc_hd__decap_3
XFILLER_50_321 VGND VGND VPWR VPWR sky130_fd_sc_hd__decap_3
XFILLER_62_192 VGND VGND VPWR VPWR sky130_fd_sc_hd__decap_3
X_6834_ _6930_/A _6834_/B _6834_/C _6834_/D VGND VGND VPWR VPWR _6834_/X sky130_fd_sc_hd__or4_2
XFILLER_50_365 VGND VGND VPWR VPWR sky130_fd_sc_hd__decap_3
X_6765_ _6779_/A _6765_/B VGND VGND VPWR VPWR _6765_/Y sky130_fd_sc_hd__nand2_2
X_3977_ _3977_/A _3977_/B _5983_/B VGND VGND VPWR VPWR _3977_/X sky130_fd_sc_hd__and3_2
XTAP_TAPCELL_ROW_61_861 VGND VPWR sky130_fd_sc_hd__tapvpwrvgnd_1
XTAP_TAPCELL_ROW_33_563 VGND VPWR sky130_fd_sc_hd__tapvpwrvgnd_1
XFILLER_31_590 VGND VGND VPWR VPWR sky130_fd_sc_hd__decap_3
X_5716_ _5716_/A _5716_/B VGND VGND VPWR VPWR _5721_/A sky130_fd_sc_hd__and2_2
X_6696_ _6104_/B _6717_/B _6797_/A2 _3663_/Y VGND VGND VPWR VPWR _6696_/X sky130_fd_sc_hd__o22a_2
X_5647_ _5643_/Y _5645_/Y _5646_/X _5608_/Y VGND VGND VPWR VPWR _5647_/Y sky130_fd_sc_hd__a211oi_2
XTAP_TAPCELL_ROW_79_1045 VGND VPWR sky130_fd_sc_hd__tapvpwrvgnd_1
X_5578_ _5692_/A _5656_/B VGND VGND VPWR VPWR _5657_/A sky130_fd_sc_hd__and2_2
X_4529_ _4529_/A _4529_/B _4529_/C VGND VGND VPWR VPWR _4859_/A sky130_fd_sc_hd__nand3_2
XFILLER_49_47 VGND VGND VPWR VPWR sky130_fd_sc_hd__decap_3
XFILLER_49_69 VGND VGND VPWR VPWR sky130_fd_sc_hd__decap_3
XFILLER_77_218 VGND VGND VPWR VPWR sky130_fd_sc_hd__decap_3
XFILLER_85_240 VGND VGND VPWR VPWR sky130_fd_sc_hd__decap_3
XTAP_TAPCELL_ROW_5_266 VGND VPWR sky130_fd_sc_hd__tapvpwrvgnd_1
XFILLER_100_595 VGND VGND VPWR VPWR sky130_fd_sc_hd__decap_3
XFILLER_65_35 VGND VGND VPWR VPWR sky130_fd_sc_hd__decap_3
XFILLER_65_57 VGND VGND VPWR VPWR sky130_fd_sc_hd__fill_2
XFILLER_85_284 VGND VGND VPWR VPWR sky130_fd_sc_hd__decap_3
XFILLER_45_137 VGND VGND VPWR VPWR sky130_fd_sc_hd__decap_3
XFILLER_65_79 VGND VGND VPWR VPWR sky130_fd_sc_hd__decap_3
XFILLER_73_479 VGND VGND VPWR VPWR sky130_fd_sc_hd__decap_3
XFILLER_26_395 VGND VGND VPWR VPWR sky130_fd_sc_hd__decap_3
XFILLER_41_321 VGND VGND VPWR VPWR sky130_fd_sc_hd__decap_3
XFILLER_53_192 VGND VGND VPWR VPWR sky130_fd_sc_hd__fill_1
XFILLER_81_67 VGND VGND VPWR VPWR sky130_fd_sc_hd__decap_3
XFILLER_5_200 VGND VGND VPWR VPWR sky130_fd_sc_hd__decap_3
XFILLER_1_461 VGND VGND VPWR VPWR sky130_fd_sc_hd__fill_2
XFILLER_49_421 VGND VGND VPWR VPWR sky130_fd_sc_hd__decap_3
XFILLER_76_251 VGND VGND VPWR VPWR sky130_fd_sc_hd__fill_1
XFILLER_76_262 VGND VGND VPWR VPWR sky130_fd_sc_hd__decap_3
Xinput9 A[17] VGND VGND VPWR VPWR input9/X sky130_fd_sc_hd__buf_1
XFILLER_64_468 VGND VGND VPWR VPWR sky130_fd_sc_hd__decap_3
XFILLER_91_243 VGND VGND VPWR VPWR sky130_fd_sc_hd__decap_3
XFILLER_17_384 VGND VGND VPWR VPWR sky130_fd_sc_hd__decap_3
X_4880_ _4830_/X _4834_/C _4878_/Y _4879_/X VGND VGND VPWR VPWR _4880_/Y sky130_fd_sc_hd__o211ai_2
X_3900_ _3900_/A _5976_/A VGND VGND VPWR VPWR _3904_/A sky130_fd_sc_hd__nand2_2
XFILLER_32_365 VGND VGND VPWR VPWR sky130_fd_sc_hd__decap_3
X_3831_ _3831_/A _3831_/B _3831_/C VGND VGND VPWR VPWR _3833_/A sky130_fd_sc_hd__nor3_2
X_6550_ _6550_/A _6550_/B VGND VGND VPWR VPWR _6550_/Y sky130_fd_sc_hd__nand2_2
X_3762_ _3760_/A _4155_/A _3761_/Y _3747_/X VGND VGND VPWR VPWR _3762_/Y sky130_fd_sc_hd__a211oi_2
X_5501_ _5501_/A _5501_/B VGND VGND VPWR VPWR _5503_/A sky130_fd_sc_hd__xor2_2
XTAP_TAPCELL_ROW_30_533 VGND VPWR sky130_fd_sc_hd__tapvpwrvgnd_1
XFILLER_9_561 VGND VGND VPWR VPWR sky130_fd_sc_hd__decap_3
X_6481_ _6477_/X _6478_/X _6480_/X _6479_/X wire299/X _6608_/S VGND VGND VPWR VPWR
+ _6481_/X sky130_fd_sc_hd__mux4_2
X_3693_ _3683_/A _3682_/B _3682_/A VGND VGND VPWR VPWR _3703_/A sky130_fd_sc_hd__o21ba_2
X_5432_ _5433_/A _5433_/B _5433_/C VGND VGND VPWR VPWR _5432_/X sky130_fd_sc_hd__and3_2
X_5363_ _5361_/A _5398_/C _5490_/D _5361_/B VGND VGND VPWR VPWR _5364_/B sky130_fd_sc_hd__a22o_2
XFILLER_99_321 VGND VGND VPWR VPWR sky130_fd_sc_hd__decap_3
X_4314_ _4313_/A _4313_/Y _4197_/Y _4206_/X VGND VGND VPWR VPWR _4314_/Y sky130_fd_sc_hd__a211oi_2
XFILLER_87_505 VGND VGND VPWR VPWR sky130_fd_sc_hd__decap_3
X_5294_ _5311_/A _5203_/D _5204_/A _5202_/Y VGND VGND VPWR VPWR _5295_/B sky130_fd_sc_hd__o2bb2a_2
XFILLER_87_549 VGND VGND VPWR VPWR sky130_fd_sc_hd__decap_3
X_4245_ _4246_/A _4246_/B _4246_/C VGND VGND VPWR VPWR _4249_/B sky130_fd_sc_hd__and3_2
XFILLER_67_240 VGND VGND VPWR VPWR sky130_fd_sc_hd__fill_1
XFILLER_67_251 VGND VGND VPWR VPWR sky130_fd_sc_hd__decap_3
X_4176_ _4176_/A _4589_/B VGND VGND VPWR VPWR _4191_/A sky130_fd_sc_hd__nand2_2
XFILLER_67_284 VGND VGND VPWR VPWR sky130_fd_sc_hd__fill_1
XTAP_TAPCELL_ROW_38_611 VGND VPWR sky130_fd_sc_hd__tapvpwrvgnd_1
XTAP_TAPCELL_ROW_2_236 VGND VPWR sky130_fd_sc_hd__tapvpwrvgnd_1
XFILLER_82_232 VGND VGND VPWR VPWR sky130_fd_sc_hd__decap_3
XFILLER_82_243 VGND VGND VPWR VPWR sky130_fd_sc_hd__fill_1
XFILLER_35_38 VGND VGND VPWR VPWR sky130_fd_sc_hd__decap_3
XFILLER_82_287 VGND VGND VPWR VPWR sky130_fd_sc_hd__decap_3
XFILLER_11_505 VGND VGND VPWR VPWR sky130_fd_sc_hd__decap_3
XFILLER_23_343 VGND VGND VPWR VPWR sky130_fd_sc_hd__decap_3
X_6817_ _6369_/Y _6524_/X _6816_/X VGND VGND VPWR VPWR _6817_/Y sky130_fd_sc_hd__a21oi_2
XFILLER_23_387 VGND VGND VPWR VPWR sky130_fd_sc_hd__decap_3
X_6748_ _6748_/A _6809_/B VGND VGND VPWR VPWR _6748_/Y sky130_fd_sc_hd__nand2_2
X_6679_ _6145_/B _6717_/B _6797_/A2 _3738_/Y VGND VGND VPWR VPWR _6679_/X sky130_fd_sc_hd__o22a_2
XFILLER_2_269 VGND VGND VPWR VPWR sky130_fd_sc_hd__decap_3
XFILLER_78_505 VGND VGND VPWR VPWR sky130_fd_sc_hd__decap_3
XFILLER_78_516 VGND VGND VPWR VPWR sky130_fd_sc_hd__decap_3
Xfanout551 input27/X VGND VGND VPWR VPWR _5765_/A sky130_fd_sc_hd__clkbuf_2
XFILLER_58_251 VGND VGND VPWR VPWR sky130_fd_sc_hd__fill_1
Xfanout562 _4687_/C VGND VGND VPWR VPWR _5382_/B sky130_fd_sc_hd__buf_6
Xfanout584 wire590/X VGND VGND VPWR VPWR _4630_/C sky130_fd_sc_hd__clkdlybuf4s25_1
XFILLER_93_508 VGND VGND VPWR VPWR sky130_fd_sc_hd__decap_3
XFILLER_46_413 VGND VGND VPWR VPWR sky130_fd_sc_hd__decap_3
XFILLER_46_424 VGND VGND VPWR VPWR sky130_fd_sc_hd__fill_1
XFILLER_58_262 VGND VGND VPWR VPWR sky130_fd_sc_hd__decap_3
Xfanout595 input20/X VGND VGND VPWR VPWR _6175_/B sky130_fd_sc_hd__clkdlybuf4s25_1
XFILLER_18_137 VGND VGND VPWR VPWR sky130_fd_sc_hd__decap_3
XFILLER_18_159 VGND VGND VPWR VPWR sky130_fd_sc_hd__fill_1
XFILLER_46_457 VGND VGND VPWR VPWR sky130_fd_sc_hd__decap_3
XFILLER_73_221 VGND VGND VPWR VPWR sky130_fd_sc_hd__decap_3
XFILLER_61_427 VGND VGND VPWR VPWR sky130_fd_sc_hd__decap_3
XFILLER_73_265 VGND VGND VPWR VPWR sky130_fd_sc_hd__decap_3
XFILLER_73_287 VGND VGND VPWR VPWR sky130_fd_sc_hd__decap_3
XFILLER_92_33 VGND VGND VPWR VPWR sky130_fd_sc_hd__decap_3
XFILLER_14_321 VGND VGND VPWR VPWR sky130_fd_sc_hd__decap_3
XFILLER_61_449 VGND VGND VPWR VPWR sky130_fd_sc_hd__decap_3
XFILLER_14_365 VGND VGND VPWR VPWR sky130_fd_sc_hd__decap_3
XFILLER_25_60 VGND VGND VPWR VPWR sky130_fd_sc_hd__decap_3
XTAP_TAPCELL_ROW_72_978 VGND VPWR sky130_fd_sc_hd__tapvpwrvgnd_1
XFILLER_14_387 VGND VGND VPWR VPWR sky130_fd_sc_hd__decap_3
XFILLER_10_560 VGND VGND VPWR VPWR sky130_fd_sc_hd__fill_2
XFILLER_41_70 VGND VGND VPWR VPWR sky130_fd_sc_hd__decap_3
XFILLER_41_92 VGND VGND VPWR VPWR sky130_fd_sc_hd__decap_3
XFILLER_6_586 VGND VGND VPWR VPWR sky130_fd_sc_hd__fill_2
XFILLER_44_6 VGND VGND VPWR VPWR sky130_fd_sc_hd__decap_3
XFILLER_69_538 VGND VGND VPWR VPWR sky130_fd_sc_hd__decap_3
XFILLER_96_324 VGND VGND VPWR VPWR sky130_fd_sc_hd__decap_3
XFILLER_2_20 VGND VGND VPWR VPWR sky130_fd_sc_hd__decap_3
XFILLER_49_240 VGND VGND VPWR VPWR sky130_fd_sc_hd__decap_3
X_4030_ _4030_/A _4030_/B VGND VGND VPWR VPWR _4035_/A sky130_fd_sc_hd__xor2_2
XPHY_EDGE_ROW_16_Left_117 VGND VGND VPWR VPWR sky130_fd_sc_hd__decap_3
XPHY_EDGE_ROW_10_Right_10 VGND VGND VPWR VPWR sky130_fd_sc_hd__decap_3
XFILLER_49_273 VGND VGND VPWR VPWR sky130_fd_sc_hd__decap_3
XFILLER_49_284 VGND VGND VPWR VPWR sky130_fd_sc_hd__decap_3
XFILLER_64_221 VGND VGND VPWR VPWR sky130_fd_sc_hd__decap_3
XFILLER_92_530 VGND VGND VPWR VPWR sky130_fd_sc_hd__fill_2
XFILLER_37_468 VGND VGND VPWR VPWR sky130_fd_sc_hd__fill_1
XFILLER_64_265 VGND VGND VPWR VPWR sky130_fd_sc_hd__decap_3
X_5981_ _6079_/A _5981_/B _5981_/C _5981_/D VGND VGND VPWR VPWR _5984_/B sky130_fd_sc_hd__nand4_2
X_4932_ _5017_/A _5017_/B VGND VGND VPWR VPWR _4934_/B sky130_fd_sc_hd__and2_2
XFILLER_60_460 VGND VGND VPWR VPWR sky130_fd_sc_hd__decap_3
X_6602_ _6608_/S _6602_/B VGND VGND VPWR VPWR _6602_/Y sky130_fd_sc_hd__nand2_2
X_4863_ _4813_/B _4816_/B _4860_/A _4861_/Y VGND VGND VPWR VPWR _4863_/X sky130_fd_sc_hd__a211o_2
XTAP_TAPCELL_ROW_15_371 VGND VPWR sky130_fd_sc_hd__tapvpwrvgnd_1
XPHY_EDGE_ROW_25_Left_126 VGND VGND VPWR VPWR sky130_fd_sc_hd__decap_3
X_4794_ _5068_/A _4978_/C _4978_/D _4979_/A VGND VGND VPWR VPWR _4795_/B sky130_fd_sc_hd__a22o_2
X_3814_ _5983_/D _5976_/D _3814_/C _3814_/D VGND VGND VPWR VPWR _3814_/X sky130_fd_sc_hd__and4_2
X_6533_ _6120_/B _6963_/A2 _6605_/A2 _6228_/A VGND VGND VPWR VPWR _6536_/A sky130_fd_sc_hd__o22a_2
X_3745_ _3669_/C _3736_/B _3744_/B _4134_/A _4134_/B VGND VGND VPWR VPWR _3747_/B
+ sky130_fd_sc_hd__a32o_2
X_6464_ _6897_/S _6779_/B VGND VGND VPWR VPWR _6464_/Y sky130_fd_sc_hd__nor2_2
XTAP_TAPCELL_ROW_76_1015 VGND VPWR sky130_fd_sc_hd__tapvpwrvgnd_1
X_5415_ _5414_/A _5414_/Y _5376_/X _5378_/Y VGND VGND VPWR VPWR _5441_/B sky130_fd_sc_hd__a211o_4
X_3676_ _3653_/Y _3675_/Y _3635_/Y _3636_/X VGND VGND VPWR VPWR _4075_/A sky130_fd_sc_hd__a211o_2
X_6395_ _6275_/B _6175_/B _6395_/S VGND VGND VPWR VPWR _6395_/X sky130_fd_sc_hd__mux2_1
X_5346_ _5346_/A _5346_/B VGND VGND VPWR VPWR _5351_/A sky130_fd_sc_hd__nand2_2
XFILLER_87_313 VGND VGND VPWR VPWR sky130_fd_sc_hd__decap_3
X_5277_ _5278_/A _5276_/Y _5277_/C _5399_/B VGND VGND VPWR VPWR _5367_/A sky130_fd_sc_hd__and4bb_2
XPHY_EDGE_ROW_34_Left_135 VGND VGND VPWR VPWR sky130_fd_sc_hd__decap_3
XFILLER_75_508 VGND VGND VPWR VPWR sky130_fd_sc_hd__fill_1
XFILLER_87_379 VGND VGND VPWR VPWR sky130_fd_sc_hd__decap_3
X_4228_ _4228_/A _4228_/B _4228_/C VGND VGND VPWR VPWR _4229_/A sky130_fd_sc_hd__and3_2
XFILLER_28_424 VGND VGND VPWR VPWR sky130_fd_sc_hd__decap_3
XFILLER_28_457 VGND VGND VPWR VPWR sky130_fd_sc_hd__decap_3
XFILLER_55_210 VGND VGND VPWR VPWR sky130_fd_sc_hd__fill_1
X_4159_ _4524_/A _4517_/C _4517_/D _4524_/B VGND VGND VPWR VPWR _4160_/B sky130_fd_sc_hd__a22o_2
XTAP_TAPCELL_ROW_87_1133 VGND VPWR sky130_fd_sc_hd__tapvpwrvgnd_1
XFILLER_43_405 VGND VGND VPWR VPWR sky130_fd_sc_hd__decap_3
XFILLER_55_254 VGND VGND VPWR VPWR sky130_fd_sc_hd__decap_3
XFILLER_55_276 VGND VGND VPWR VPWR sky130_fd_sc_hd__decap_3
XFILLER_70_224 VGND VGND VPWR VPWR sky130_fd_sc_hd__decap_3
XFILLER_83_596 VGND VGND VPWR VPWR sky130_fd_sc_hd__fill_2
XFILLER_70_246 VGND VGND VPWR VPWR sky130_fd_sc_hd__decap_3
XFILLER_70_268 VGND VGND VPWR VPWR sky130_fd_sc_hd__decap_3
XPHY_EDGE_ROW_43_Left_144 VGND VGND VPWR VPWR sky130_fd_sc_hd__decap_3
XFILLER_51_482 VGND VGND VPWR VPWR sky130_fd_sc_hd__fill_2
XFILLER_11_368 VGND VGND VPWR VPWR sky130_fd_sc_hd__decap_3
XTAP_TAPCELL_ROW_98_1251 VGND VPWR sky130_fd_sc_hd__tapvpwrvgnd_1
XFILLER_3_501 VGND VGND VPWR VPWR sky130_fd_sc_hd__decap_3
XPHY_EDGE_ROW_52_Left_153 VGND VGND VPWR VPWR sky130_fd_sc_hd__decap_3
XFILLER_78_324 VGND VGND VPWR VPWR sky130_fd_sc_hd__decap_3
XFILLER_87_44 VGND VGND VPWR VPWR sky130_fd_sc_hd__decap_3
XFILLER_78_346 VGND VGND VPWR VPWR sky130_fd_sc_hd__decap_3
XFILLER_78_368 VGND VGND VPWR VPWR sky130_fd_sc_hd__decap_3
XFILLER_87_99 VGND VGND VPWR VPWR sky130_fd_sc_hd__decap_3
XFILLER_93_305 VGND VGND VPWR VPWR sky130_fd_sc_hd__decap_3
XFILLER_93_327 VGND VGND VPWR VPWR sky130_fd_sc_hd__decap_3
Xfanout370 _5983_/A VGND VGND VPWR VPWR _3977_/B sky130_fd_sc_hd__clkbuf_4
Xfanout381 _5976_/C VGND VGND VPWR VPWR _3639_/B sky130_fd_sc_hd__clkbuf_2
Xfanout392 _4264_/A VGND VGND VPWR VPWR _5151_/B sky130_fd_sc_hd__buf_6
XTAP_TAPCELL_ROW_49_728 VGND VPWR sky130_fd_sc_hd__tapvpwrvgnd_1
XFILLER_19_435 VGND VGND VPWR VPWR sky130_fd_sc_hd__decap_3
XFILLER_46_221 VGND VGND VPWR VPWR sky130_fd_sc_hd__decap_3
XFILLER_74_530 VGND VGND VPWR VPWR sky130_fd_sc_hd__fill_2
XFILLER_93_349 VGND VGND VPWR VPWR sky130_fd_sc_hd__decap_3
XFILLER_19_479 VGND VGND VPWR VPWR sky130_fd_sc_hd__decap_3
XFILLER_34_405 VGND VGND VPWR VPWR sky130_fd_sc_hd__decap_3
XFILLER_27_490 VGND VGND VPWR VPWR sky130_fd_sc_hd__decap_3
XFILLER_36_70 VGND VGND VPWR VPWR sky130_fd_sc_hd__decap_3
XPHY_EDGE_ROW_61_Left_162 VGND VGND VPWR VPWR sky130_fd_sc_hd__decap_3
XFILLER_61_246 VGND VGND VPWR VPWR sky130_fd_sc_hd__fill_1
XFILLER_61_268 VGND VGND VPWR VPWR sky130_fd_sc_hd__decap_3
XFILLER_52_91 VGND VGND VPWR VPWR sky130_fd_sc_hd__decap_3
Xinput12 A[1] VGND VGND VPWR VPWR input12/X sky130_fd_sc_hd__buf_6
XTAP_TAPCELL_ROW_12_341 VGND VPWR sky130_fd_sc_hd__tapvpwrvgnd_1
Xinput45 B[20] VGND VGND VPWR VPWR input45/X sky130_fd_sc_hd__dlymetal6s2s_1
Xinput34 B[10] VGND VGND VPWR VPWR _6016_/A sky130_fd_sc_hd__clkbuf_2
Xinput23 A[2] VGND VGND VPWR VPWR wire590/A sky130_fd_sc_hd__buf_4
X_3530_ _3868_/A _3765_/B VGND VGND VPWR VPWR _3729_/A sky130_fd_sc_hd__nand2_2
Xinput67 opcode[2] VGND VGND VPWR VPWR input67/X sky130_fd_sc_hd__clkdlybuf4s25_1
Xinput56 B[30] VGND VGND VPWR VPWR _6286_/A sky130_fd_sc_hd__clkdlybuf4s25_1
XPHY_EDGE_ROW_70_Left_171 VGND VGND VPWR VPWR sky130_fd_sc_hd__decap_3
XFILLER_42_3 VGND VGND VPWR VPWR sky130_fd_sc_hd__fill_1
XFILLER_69_302 VGND VGND VPWR VPWR sky130_fd_sc_hd__decap_3
X_6180_ _6180_/A _6919_/B VGND VGND VPWR VPWR _6904_/A sky130_fd_sc_hd__nand2_2
X_5200_ _5200_/A _5200_/B _5200_/C VGND VGND VPWR VPWR _5200_/Y sky130_fd_sc_hd__nand3_4
X_5131_ _5209_/A _5203_/D _5130_/B _5127_/X VGND VGND VPWR VPWR _5133_/B sky130_fd_sc_hd__a31o_2
X_5062_ _4956_/X _4971_/Y _5045_/A _4970_/A VGND VGND VPWR VPWR _5062_/X sky130_fd_sc_hd__o211a_4
XFILLER_84_305 VGND VGND VPWR VPWR sky130_fd_sc_hd__decap_3
X_4013_ _4013_/A _4013_/B VGND VGND VPWR VPWR _4015_/A sky130_fd_sc_hd__nor2_2
XFILLER_37_221 VGND VGND VPWR VPWR sky130_fd_sc_hd__decap_3
XFILLER_37_265 VGND VGND VPWR VPWR sky130_fd_sc_hd__fill_2
XFILLER_25_449 VGND VGND VPWR VPWR sky130_fd_sc_hd__decap_3
XFILLER_52_224 VGND VGND VPWR VPWR sky130_fd_sc_hd__decap_3
XFILLER_80_533 VGND VGND VPWR VPWR sky130_fd_sc_hd__decap_3
XFILLER_92_371 VGND VGND VPWR VPWR sky130_fd_sc_hd__decap_3
X_5964_ _3946_/A _3946_/B _3940_/B VGND VGND VPWR VPWR _5969_/B sky130_fd_sc_hd__a21oi_2
XFILLER_40_419 VGND VGND VPWR VPWR sky130_fd_sc_hd__fill_1
X_5895_ _4911_/A _4911_/Y _5888_/Y _5894_/X VGND VGND VPWR VPWR _5896_/A sky130_fd_sc_hd__a211oi_2
X_4915_ _4871_/Y _4876_/C _4913_/X _4914_/Y VGND VGND VPWR VPWR _4915_/Y sky130_fd_sc_hd__a211oi_4
XTAP_TAPCELL_ROW_82_1074 VGND VPWR sky130_fd_sc_hd__tapvpwrvgnd_1
X_4846_ _4845_/A _4845_/B _4845_/C VGND VGND VPWR VPWR _4848_/C sky130_fd_sc_hd__o21ai_2
X_6516_ _6777_/A _6516_/B VGND VGND VPWR VPWR _6540_/A sky130_fd_sc_hd__nor2_2
X_4777_ _4744_/B _4747_/B _4775_/X _4776_/Y VGND VGND VPWR VPWR _4777_/Y sky130_fd_sc_hd__a211oi_2
XFILLER_4_309 VGND VGND VPWR VPWR sky130_fd_sc_hd__decap_3
X_3728_ _3705_/Y _3706_/X _3710_/Y _3725_/X VGND VGND VPWR VPWR _3730_/B sky130_fd_sc_hd__o211ai_2
X_6447_ _6447_/A _6447_/B VGND VGND VPWR VPWR _6448_/A sky130_fd_sc_hd__or2_2
X_3659_ _3678_/B _3659_/B VGND VGND VPWR VPWR _3672_/A sky130_fd_sc_hd__nor2_2
X_6378_ _6378_/A _6378_/B VGND VGND VPWR VPWR _6655_/B sky130_fd_sc_hd__nor2_2
X_5329_ _5329_/A _5383_/B VGND VGND VPWR VPWR _6133_/A sky130_fd_sc_hd__nand2_2
XTAP_TAPCELL_ROW_93_1192 VGND VPWR sky130_fd_sc_hd__tapvpwrvgnd_1
XFILLER_0_548 VGND VGND VPWR VPWR sky130_fd_sc_hd__decap_3
XFILLER_87_121 VGND VGND VPWR VPWR sky130_fd_sc_hd__decap_3
XFILLER_87_165 VGND VGND VPWR VPWR sky130_fd_sc_hd__decap_3
XFILLER_87_198 VGND VGND VPWR VPWR sky130_fd_sc_hd__decap_3
XFILLER_16_405 VGND VGND VPWR VPWR sky130_fd_sc_hd__decap_3
XFILLER_56_552 VGND VGND VPWR VPWR sky130_fd_sc_hd__decap_3
XFILLER_90_319 VGND VGND VPWR VPWR sky130_fd_sc_hd__decap_3
XFILLER_28_276 VGND VGND VPWR VPWR sky130_fd_sc_hd__fill_1
XFILLER_71_511 VGND VGND VPWR VPWR sky130_fd_sc_hd__decap_3
XFILLER_83_371 VGND VGND VPWR VPWR sky130_fd_sc_hd__decap_3
XFILLER_73_57 VGND VGND VPWR VPWR sky130_fd_sc_hd__decap_3
XFILLER_71_588 VGND VGND VPWR VPWR sky130_fd_sc_hd__decap_3
XTAP_TAPCELL_ROW_54_786 VGND VPWR sky130_fd_sc_hd__tapvpwrvgnd_1
XTAP_TAPCELL_ROW_26_488 VGND VPWR sky130_fd_sc_hd__tapvpwrvgnd_1
XFILLER_51_290 VGND VGND VPWR VPWR sky130_fd_sc_hd__decap_3
XFILLER_11_176 VGND VGND VPWR VPWR sky130_fd_sc_hd__fill_2
XFILLER_22_72 VGND VGND VPWR VPWR sky130_fd_sc_hd__decap_3
XFILLER_7_158 VGND VGND VPWR VPWR sky130_fd_sc_hd__decap_3
XFILLER_7_169 VGND VGND VPWR VPWR sky130_fd_sc_hd__decap_3
XFILLER_98_65 VGND VGND VPWR VPWR sky130_fd_sc_hd__decap_3
XFILLER_98_54 VGND VGND VPWR VPWR sky130_fd_sc_hd__decap_3
XFILLER_3_375 VGND VGND VPWR VPWR sky130_fd_sc_hd__decap_3
XFILLER_39_508 VGND VGND VPWR VPWR sky130_fd_sc_hd__decap_3
XFILLER_66_327 VGND VGND VPWR VPWR sky130_fd_sc_hd__decap_3
XFILLER_93_102 VGND VGND VPWR VPWR sky130_fd_sc_hd__decap_3
XFILLER_93_113 VGND VGND VPWR VPWR sky130_fd_sc_hd__fill_2
XFILLER_81_308 VGND VGND VPWR VPWR sky130_fd_sc_hd__decap_3
XFILLER_34_224 VGND VGND VPWR VPWR sky130_fd_sc_hd__fill_1
XFILLER_62_533 VGND VGND VPWR VPWR sky130_fd_sc_hd__decap_3
XFILLER_74_371 VGND VGND VPWR VPWR sky130_fd_sc_hd__decap_3
XTAP_TAPCELL_ROW_17_400 VGND VPWR sky130_fd_sc_hd__tapvpwrvgnd_1
XFILLER_22_408 VGND VGND VPWR VPWR sky130_fd_sc_hd__decap_3
XFILLER_62_555 VGND VGND VPWR VPWR sky130_fd_sc_hd__decap_3
XFILLER_34_279 VGND VGND VPWR VPWR sky130_fd_sc_hd__decap_3
X_5680_ _5680_/A _5680_/B _5680_/C _5680_/D VGND VGND VPWR VPWR _5713_/B sky130_fd_sc_hd__and4_2
X_4700_ _4700_/A _4700_/B _4700_/C VGND VGND VPWR VPWR _4700_/X sky130_fd_sc_hd__and3_2
XFILLER_30_463 VGND VGND VPWR VPWR sky130_fd_sc_hd__fill_2
X_4631_ _4631_/A _4922_/A VGND VGND VPWR VPWR _4638_/A sky130_fd_sc_hd__nor2_2
XFILLER_30_496 VGND VGND VPWR VPWR sky130_fd_sc_hd__decap_3
X_4562_ _4563_/B1 _4561_/Y _4445_/B _4452_/X VGND VGND VPWR VPWR _4565_/A sky130_fd_sc_hd__a211oi_2
X_6301_ _3585_/A _6639_/A0 _5981_/B _5992_/B _6958_/S0 _6893_/S VGND VGND VPWR VPWR
+ _6301_/X sky130_fd_sc_hd__mux4_2
Xwire590 wire590/A VGND VGND VPWR VPWR wire590/X sky130_fd_sc_hd__buf_8
X_4493_ _4493_/A _4493_/B VGND VGND VPWR VPWR _4494_/C sky130_fd_sc_hd__xnor2_2
X_3513_ _4551_/A _6929_/A _3869_/D _4432_/A VGND VGND VPWR VPWR _3514_/B sky130_fd_sc_hd__a22o_2
X_6232_ input61/X _6232_/B VGND VGND VPWR VPWR _6233_/B sky130_fd_sc_hd__and2b_2
XFILLER_69_143 VGND VGND VPWR VPWR sky130_fd_sc_hd__decap_3
Xload_slew540 _3550_/B VGND VGND VPWR VPWR _4482_/A sky130_fd_sc_hd__buf_6
X_6163_ _6088_/X _6161_/A _6161_/B _6796_/A _6808_/A VGND VGND VPWR VPWR _6163_/Y
+ sky130_fd_sc_hd__o311ai_1
XFILLER_97_452 VGND VGND VPWR VPWR sky130_fd_sc_hd__fill_1
XFILLER_69_165 VGND VGND VPWR VPWR sky130_fd_sc_hd__decap_3
X_6094_ _6095_/A _6095_/B VGND VGND VPWR VPWR _6787_/A sky130_fd_sc_hd__and2_2
X_5114_ _5341_/A _5300_/B _5188_/C _5290_/C VGND VGND VPWR VPWR _5117_/A sky130_fd_sc_hd__nand4_2
XFILLER_38_530 VGND VGND VPWR VPWR sky130_fd_sc_hd__fill_2
XFILLER_57_349 VGND VGND VPWR VPWR sky130_fd_sc_hd__decap_3
XFILLER_69_187 VGND VGND VPWR VPWR sky130_fd_sc_hd__decap_3
X_5045_ _5045_/A _5045_/B _5045_/C VGND VGND VPWR VPWR _5045_/Y sky130_fd_sc_hd__nand3_2
XFILLER_53_500 VGND VGND VPWR VPWR sky130_fd_sc_hd__decap_3
XFILLER_53_511 VGND VGND VPWR VPWR sky130_fd_sc_hd__decap_3
XFILLER_65_393 VGND VGND VPWR VPWR sky130_fd_sc_hd__decap_3
XTAP_TAPCELL_ROW_84_1103 VGND VPWR sky130_fd_sc_hd__tapvpwrvgnd_1
X_6996_ _6999_/A _6331_/A _6997_/S VGND VGND VPWR VPWR _6996_/X sky130_fd_sc_hd__mux2_4
XFILLER_13_408 VGND VGND VPWR VPWR sky130_fd_sc_hd__decap_3
XFILLER_80_363 VGND VGND VPWR VPWR sky130_fd_sc_hd__fill_1
XFILLER_80_374 VGND VGND VPWR VPWR sky130_fd_sc_hd__decap_3
X_5947_ _5947_/A _6275_/B VGND VGND VPWR VPWR _5950_/A sky130_fd_sc_hd__nand2_2
XFILLER_40_249 VGND VGND VPWR VPWR sky130_fd_sc_hd__decap_3
XTAP_TAPCELL_ROW_51_756 VGND VPWR sky130_fd_sc_hd__tapvpwrvgnd_1
X_5878_ _4554_/A _4554_/B _4554_/C VGND VGND VPWR VPWR _5878_/Y sky130_fd_sc_hd__a21oi_2
XTAP_TAPCELL_ROW_23_458 VGND VPWR sky130_fd_sc_hd__tapvpwrvgnd_1
XFILLER_21_474 VGND VGND VPWR VPWR sky130_fd_sc_hd__decap_3
Xrebuffer712 _5147_/C1 VGND VGND VPWR VPWR _5064_/B1 sky130_fd_sc_hd__buf_2
Xrebuffer701 _6997_/S VGND VGND VPWR VPWR _6995_/A sky130_fd_sc_hd__buf_6
X_4829_ _4828_/A _4828_/B _4828_/C VGND VGND VPWR VPWR _4830_/C sky130_fd_sc_hd__a21o_2
XFILLER_4_106 VGND VGND VPWR VPWR sky130_fd_sc_hd__decap_3
Xrebuffer734 _5275_/B VGND VGND VPWR VPWR _5276_/B2 sky130_fd_sc_hd__buf_2
Xrebuffer745 _5138_/B2 VGND VGND VPWR VPWR _5211_/A sky130_fd_sc_hd__buf_2
Xrebuffer756 _5462_/B VGND VGND VPWR VPWR _5848_/B sky130_fd_sc_hd__buf_2
Xrebuffer767 _4719_/A VGND VGND VPWR VPWR _4949_/A1 sky130_fd_sc_hd__buf_2
XTAP_TAPCELL_ROW_95_1210 VGND VPWR sky130_fd_sc_hd__tapvpwrvgnd_1
XFILLER_4_128 VGND VGND VPWR VPWR sky130_fd_sc_hd__decap_3
XFILLER_0_312 VGND VGND VPWR VPWR sky130_fd_sc_hd__decap_3
XFILLER_88_430 VGND VGND VPWR VPWR sky130_fd_sc_hd__decap_3
XFILLER_0_378 VGND VGND VPWR VPWR sky130_fd_sc_hd__decap_3
XFILLER_48_305 VGND VGND VPWR VPWR sky130_fd_sc_hd__decap_3
XFILLER_68_79 VGND VGND VPWR VPWR sky130_fd_sc_hd__decap_3
XFILLER_88_474 VGND VGND VPWR VPWR sky130_fd_sc_hd__fill_2
XFILLER_75_113 VGND VGND VPWR VPWR sky130_fd_sc_hd__fill_1
XFILLER_75_135 VGND VGND VPWR VPWR sky130_fd_sc_hd__decap_3
XFILLER_88_496 VGND VGND VPWR VPWR sky130_fd_sc_hd__fill_2
XTAP_TAPCELL_ROW_59_834 VGND VPWR sky130_fd_sc_hd__tapvpwrvgnd_1
XFILLER_63_308 VGND VGND VPWR VPWR sky130_fd_sc_hd__decap_3
XFILLER_16_213 VGND VGND VPWR VPWR sky130_fd_sc_hd__decap_3
XFILLER_44_500 VGND VGND VPWR VPWR sky130_fd_sc_hd__decap_3
XFILLER_44_533 VGND VGND VPWR VPWR sky130_fd_sc_hd__decap_3
XFILLER_56_360 VGND VGND VPWR VPWR sky130_fd_sc_hd__decap_3
XFILLER_56_371 VGND VGND VPWR VPWR sky130_fd_sc_hd__decap_3
XFILLER_90_105 VGND VGND VPWR VPWR sky130_fd_sc_hd__decap_3
XFILLER_17_72 VGND VGND VPWR VPWR sky130_fd_sc_hd__decap_3
XFILLER_16_279 VGND VGND VPWR VPWR sky130_fd_sc_hd__fill_1
XFILLER_12_430 VGND VGND VPWR VPWR sky130_fd_sc_hd__decap_3
XFILLER_31_238 VGND VGND VPWR VPWR sky130_fd_sc_hd__decap_3
XFILLER_12_463 VGND VGND VPWR VPWR sky130_fd_sc_hd__decap_3
XFILLER_33_93 VGND VGND VPWR VPWR sky130_fd_sc_hd__fill_2
XTAP_TAPCELL_ROW_100_1269 VGND VPWR sky130_fd_sc_hd__tapvpwrvgnd_1
XFILLER_8_467 VGND VGND VPWR VPWR sky130_fd_sc_hd__decap_3
XFILLER_98_227 VGND VGND VPWR VPWR sky130_fd_sc_hd__decap_3
XFILLER_79_441 VGND VGND VPWR VPWR sky130_fd_sc_hd__decap_3
XFILLER_79_452 VGND VGND VPWR VPWR sky130_fd_sc_hd__decap_3
XFILLER_79_485 VGND VGND VPWR VPWR sky130_fd_sc_hd__decap_3
XFILLER_94_411 VGND VGND VPWR VPWR sky130_fd_sc_hd__decap_3
XFILLER_94_433 VGND VGND VPWR VPWR sky130_fd_sc_hd__decap_3
XFILLER_66_168 VGND VGND VPWR VPWR sky130_fd_sc_hd__decap_3
XFILLER_94_477 VGND VGND VPWR VPWR sky130_fd_sc_hd__decap_3
XFILLER_94_466 VGND VGND VPWR VPWR sky130_fd_sc_hd__decap_3
XFILLER_35_511 VGND VGND VPWR VPWR sky130_fd_sc_hd__decap_3
XFILLER_47_371 VGND VGND VPWR VPWR sky130_fd_sc_hd__decap_3
XFILLER_81_116 VGND VGND VPWR VPWR sky130_fd_sc_hd__decap_3
XFILLER_35_555 VGND VGND VPWR VPWR sky130_fd_sc_hd__decap_3
XFILLER_47_393 VGND VGND VPWR VPWR sky130_fd_sc_hd__decap_3
XFILLER_62_330 VGND VGND VPWR VPWR sky130_fd_sc_hd__decap_3
X_6850_ _6363_/Y _6571_/X _6578_/X _6365_/Y VGND VGND VPWR VPWR _6854_/C sky130_fd_sc_hd__a22o_2
X_6781_ _6093_/B _6781_/A2 _6810_/B1 _6209_/A _6780_/X VGND VGND VPWR VPWR _6785_/B
+ sky130_fd_sc_hd__o221a_2
X_5801_ _5801_/A _5801_/B VGND VGND VPWR VPWR _6465_/B sky130_fd_sc_hd__nor2_2
XPHY_EDGE_ROW_8_Right_8 VGND VGND VPWR VPWR sky130_fd_sc_hd__decap_3
XFILLER_22_238 VGND VGND VPWR VPWR sky130_fd_sc_hd__fill_2
XFILLER_50_536 VGND VGND VPWR VPWR sky130_fd_sc_hd__decap_3
XFILLER_50_547 VGND VGND VPWR VPWR sky130_fd_sc_hd__decap_3
X_5732_ _5732_/A _5732_/B _5732_/C VGND VGND VPWR VPWR _5733_/B sky130_fd_sc_hd__and3_2
X_3993_ _3993_/A1 _6073_/A _3991_/B _6175_/A VGND VGND VPWR VPWR _3993_/X sky130_fd_sc_hd__a22o_2
XFILLER_30_271 VGND VGND VPWR VPWR sky130_fd_sc_hd__decap_3
X_5663_ _5695_/A _5695_/C _5725_/C _6123_/A VGND VGND VPWR VPWR _5664_/C sky130_fd_sc_hd__a22o_2
XTAP_TAPCELL_ROW_20_428 VGND VPWR sky130_fd_sc_hd__tapvpwrvgnd_1
X_5594_ _5594_/A _5594_/B _5594_/C VGND VGND VPWR VPWR _5634_/A sky130_fd_sc_hd__or3_4
X_4614_ _4612_/X _4614_/B VGND VGND VPWR VPWR _4615_/B sky130_fd_sc_hd__and2b_2
X_4545_ _6264_/B _6569_/B VGND VGND VPWR VPWR _4547_/B sky130_fd_sc_hd__nor2_2
Xmax_cap120 _5144_/Y VGND VGND VPWR VPWR _5220_/A1 sky130_fd_sc_hd__buf_6
XFILLER_1_109 VGND VGND VPWR VPWR sky130_fd_sc_hd__decap_3
Xmax_cap164 _6126_/Y VGND VGND VPWR VPWR _6441_/A sky130_fd_sc_hd__buf_2
X_4476_ _4476_/A _4476_/B VGND VGND VPWR VPWR _4598_/A sky130_fd_sc_hd__nand2_2
XPHY_EDGE_ROW_8_Left_109 VGND VGND VPWR VPWR sky130_fd_sc_hd__decap_3
XFILLER_89_249 VGND VGND VPWR VPWR sky130_fd_sc_hd__decap_3
X_6215_ _6621_/A2 _6215_/B VGND VGND VPWR VPWR _6215_/Y sky130_fd_sc_hd__nand2b_2
XPHY_EDGE_ROW_39_Right_39 VGND VGND VPWR VPWR sky130_fd_sc_hd__decap_3
XFILLER_57_102 VGND VGND VPWR VPWR sky130_fd_sc_hd__decap_3
XFILLER_85_411 VGND VGND VPWR VPWR sky130_fd_sc_hd__decap_3
X_6146_ _6672_/A _6672_/B VGND VGND VPWR VPWR _6146_/Y sky130_fd_sc_hd__nand2_2
XTAP_TAPCELL_ROW_90_1162 VGND VPWR sky130_fd_sc_hd__tapvpwrvgnd_1
XFILLER_57_135 VGND VGND VPWR VPWR sky130_fd_sc_hd__decap_3
XFILLER_45_308 VGND VGND VPWR VPWR sky130_fd_sc_hd__fill_1
XFILLER_85_455 VGND VGND VPWR VPWR sky130_fd_sc_hd__decap_3
X_6077_ _6077_/A _6263_/B VGND VGND VPWR VPWR _6170_/B sky130_fd_sc_hd__or2_2
XTAP_TAPCELL_ROW_56_804 VGND VPWR sky130_fd_sc_hd__tapvpwrvgnd_1
X_5028_ _5102_/A _5102_/B VGND VGND VPWR VPWR _5030_/B sky130_fd_sc_hd__or2_2
XTAP_TAPCELL_ROW_28_506 VGND VPWR sky130_fd_sc_hd__tapvpwrvgnd_1
XFILLER_54_26 VGND VGND VPWR VPWR sky130_fd_sc_hd__fill_2
XFILLER_26_566 VGND VGND VPWR VPWR sky130_fd_sc_hd__decap_3
XFILLER_41_503 VGND VGND VPWR VPWR sky130_fd_sc_hd__fill_1
XFILLER_53_352 VGND VGND VPWR VPWR sky130_fd_sc_hd__fill_1
XFILLER_53_374 VGND VGND VPWR VPWR sky130_fd_sc_hd__decap_3
XFILLER_54_59 VGND VGND VPWR VPWR sky130_fd_sc_hd__decap_3
XFILLER_13_249 VGND VGND VPWR VPWR sky130_fd_sc_hd__decap_3
X_6979_ _6313_/Y _6337_/Y _6979_/B1 _6970_/A _6978_/X VGND VGND VPWR VPWR _6979_/Y
+ sky130_fd_sc_hd__o221ai_2
XTAP_TAPCELL_ROW_64_892 VGND VPWR sky130_fd_sc_hd__tapvpwrvgnd_1
XTAP_TAPCELL_ROW_36_594 VGND VPWR sky130_fd_sc_hd__tapvpwrvgnd_1
XPHY_EDGE_ROW_48_Right_48 VGND VGND VPWR VPWR sky130_fd_sc_hd__decap_3
XFILLER_70_25 VGND VGND VPWR VPWR sky130_fd_sc_hd__decap_3
XPHY_EDGE_ROW_57_Right_57 VGND VGND VPWR VPWR sky130_fd_sc_hd__decap_3
XFILLER_0_131 VGND VGND VPWR VPWR sky130_fd_sc_hd__fill_1
XTAP_TAPCELL_ROW_8_297 VGND VPWR sky130_fd_sc_hd__tapvpwrvgnd_1
XFILLER_0_197 VGND VGND VPWR VPWR sky130_fd_sc_hd__fill_2
XFILLER_76_444 VGND VGND VPWR VPWR sky130_fd_sc_hd__decap_3
XFILLER_88_293 VGND VGND VPWR VPWR sky130_fd_sc_hd__decap_3
XFILLER_91_403 VGND VGND VPWR VPWR sky130_fd_sc_hd__decap_3
XFILLER_17_500 VGND VGND VPWR VPWR sky130_fd_sc_hd__decap_3
XFILLER_17_511 VGND VGND VPWR VPWR sky130_fd_sc_hd__decap_3
XFILLER_28_82 VGND VGND VPWR VPWR sky130_fd_sc_hd__fill_2
XFILLER_48_179 VGND VGND VPWR VPWR sky130_fd_sc_hd__fill_2
XFILLER_91_436 VGND VGND VPWR VPWR sky130_fd_sc_hd__decap_3
XFILLER_29_393 VGND VGND VPWR VPWR sky130_fd_sc_hd__decap_3
XFILLER_91_458 VGND VGND VPWR VPWR sky130_fd_sc_hd__decap_3
XPHY_EDGE_ROW_66_Right_66 VGND VGND VPWR VPWR sky130_fd_sc_hd__decap_3
XFILLER_44_385 VGND VGND VPWR VPWR sky130_fd_sc_hd__fill_2
XFILLER_44_70 VGND VGND VPWR VPWR sky130_fd_sc_hd__decap_3
XFILLER_32_569 VGND VGND VPWR VPWR sky130_fd_sc_hd__decap_3
XFILLER_74_6 VGND VGND VPWR VPWR sky130_fd_sc_hd__decap_3
XFILLER_8_242 VGND VGND VPWR VPWR sky130_fd_sc_hd__decap_3
XFILLER_8_253 VGND VGND VPWR VPWR sky130_fd_sc_hd__decap_3
XFILLER_60_91 VGND VGND VPWR VPWR sky130_fd_sc_hd__fill_1
XFILLER_8_275 VGND VGND VPWR VPWR sky130_fd_sc_hd__decap_3
XPHY_EDGE_ROW_75_Right_75 VGND VGND VPWR VPWR sky130_fd_sc_hd__decap_3
X_4330_ _4228_/B _4223_/B _4223_/C VGND VGND VPWR VPWR _4348_/B sky130_fd_sc_hd__o21ai_2
XFILLER_99_536 VGND VGND VPWR VPWR sky130_fd_sc_hd__decap_3
X_4261_ _4518_/A _4264_/B _4150_/A _4149_/D VGND VGND VPWR VPWR _4262_/B sky130_fd_sc_hd__a22o_2
XFILLER_99_569 VGND VGND VPWR VPWR sky130_fd_sc_hd__decap_3
X_6000_ _6000_/A _6000_/B VGND VGND VPWR VPWR _6001_/B sky130_fd_sc_hd__xnor2_2
X_4192_ _4192_/A _4192_/B _4192_/C VGND VGND VPWR VPWR _4192_/X sky130_fd_sc_hd__and3_2
XFILLER_67_488 VGND VGND VPWR VPWR sky130_fd_sc_hd__fill_1
XFILLER_82_414 VGND VGND VPWR VPWR sky130_fd_sc_hd__decap_3
XPHY_EDGE_ROW_84_Right_84 VGND VGND VPWR VPWR sky130_fd_sc_hd__decap_3
XFILLER_94_285 VGND VGND VPWR VPWR sky130_fd_sc_hd__decap_3
XFILLER_94_274 VGND VGND VPWR VPWR sky130_fd_sc_hd__decap_3
XFILLER_82_447 VGND VGND VPWR VPWR sky130_fd_sc_hd__decap_3
X_6902_ _6902_/A _6902_/B VGND VGND VPWR VPWR _6904_/C sky130_fd_sc_hd__nor2_2
XFILLER_23_503 VGND VGND VPWR VPWR sky130_fd_sc_hd__fill_1
XFILLER_23_514 VGND VGND VPWR VPWR sky130_fd_sc_hd__decap_3
XFILLER_50_300 VGND VGND VPWR VPWR sky130_fd_sc_hd__decap_3
X_6833_ _6767_/B _6692_/X _6832_/X _6746_/A _6830_/Y VGND VGND VPWR VPWR _6834_/D
+ sky130_fd_sc_hd__o221a_2
XFILLER_24_29 VGND VGND VPWR VPWR sky130_fd_sc_hd__fill_1
XFILLER_50_333 VGND VGND VPWR VPWR sky130_fd_sc_hd__decap_3
XFILLER_62_171 VGND VGND VPWR VPWR sky130_fd_sc_hd__decap_3
XFILLER_90_480 VGND VGND VPWR VPWR sky130_fd_sc_hd__decap_3
XFILLER_23_558 VGND VGND VPWR VPWR sky130_fd_sc_hd__fill_2
X_6764_ _6764_/A _6767_/A VGND VGND VPWR VPWR _6875_/B sky130_fd_sc_hd__nor2_2
X_3976_ _5983_/D _3976_/B VGND VGND VPWR VPWR _3980_/A sky130_fd_sc_hd__nand2_2
XTAP_TAPCELL_ROW_61_862 VGND VPWR sky130_fd_sc_hd__tapvpwrvgnd_1
XFILLER_50_377 VGND VGND VPWR VPWR sky130_fd_sc_hd__decap_3
X_6695_ _6638_/A _6694_/X _6693_/Y VGND VGND VPWR VPWR _6695_/Y sky130_fd_sc_hd__a21boi_2
X_5715_ _5717_/A _5717_/B VGND VGND VPWR VPWR _5715_/Y sky130_fd_sc_hd__nand2b_2
XTAP_TAPCELL_ROW_33_564 VGND VPWR sky130_fd_sc_hd__tapvpwrvgnd_1
X_5646_ _5608_/A _5608_/B _5602_/X VGND VGND VPWR VPWR _5646_/X sky130_fd_sc_hd__o21ba_2
XTAP_TAPCELL_ROW_79_1046 VGND VPWR sky130_fd_sc_hd__tapvpwrvgnd_1
XPHY_EDGE_ROW_93_Right_93 VGND VGND VPWR VPWR sky130_fd_sc_hd__decap_3
X_5577_ _5577_/A _5577_/B VGND VGND VPWR VPWR _5656_/B sky130_fd_sc_hd__xnor2_2
XFILLER_2_418 VGND VGND VPWR VPWR sky130_fd_sc_hd__fill_2
X_4528_ _4523_/A _4523_/C _4523_/B VGND VGND VPWR VPWR _4529_/C sky130_fd_sc_hd__a21o_2
XFILLER_49_26 VGND VGND VPWR VPWR sky130_fd_sc_hd__fill_2
X_4459_ _4600_/A _4460_/B VGND VGND VPWR VPWR _4464_/B sky130_fd_sc_hd__nand2_2
XFILLER_98_580 VGND VGND VPWR VPWR sky130_fd_sc_hd__decap_3
XFILLER_58_455 VGND VGND VPWR VPWR sky130_fd_sc_hd__decap_3
XFILLER_85_252 VGND VGND VPWR VPWR sky130_fd_sc_hd__decap_3
X_6129_ _6506_/A _6129_/B VGND VGND VPWR VPWR _6129_/X sky130_fd_sc_hd__or2_2
XTAP_TAPCELL_ROW_69_940 VGND VPWR sky130_fd_sc_hd__tapvpwrvgnd_1
XTAP_TAPCELL_ROW_5_267 VGND VPWR sky130_fd_sc_hd__tapvpwrvgnd_1
XFILLER_45_116 VGND VGND VPWR VPWR sky130_fd_sc_hd__decap_3
XFILLER_58_477 VGND VGND VPWR VPWR sky130_fd_sc_hd__decap_3
XFILLER_65_47 VGND VGND VPWR VPWR sky130_fd_sc_hd__decap_3
XFILLER_45_149 VGND VGND VPWR VPWR sky130_fd_sc_hd__decap_3
XFILLER_73_458 VGND VGND VPWR VPWR sky130_fd_sc_hd__decap_3
XFILLER_85_296 VGND VGND VPWR VPWR sky130_fd_sc_hd__decap_3
XFILLER_26_352 VGND VGND VPWR VPWR sky130_fd_sc_hd__decap_3
XFILLER_26_363 VGND VGND VPWR VPWR sky130_fd_sc_hd__fill_1
XFILLER_26_374 VGND VGND VPWR VPWR sky130_fd_sc_hd__decap_3
XFILLER_14_536 VGND VGND VPWR VPWR sky130_fd_sc_hd__decap_3
XFILLER_81_35 VGND VGND VPWR VPWR sky130_fd_sc_hd__decap_3
XFILLER_81_57 VGND VGND VPWR VPWR sky130_fd_sc_hd__fill_1
XFILLER_14_40 VGND VGND VPWR VPWR sky130_fd_sc_hd__decap_3
XFILLER_14_62 VGND VGND VPWR VPWR sky130_fd_sc_hd__decap_3
XFILLER_81_79 VGND VGND VPWR VPWR sky130_fd_sc_hd__decap_3
XFILLER_14_95 VGND VGND VPWR VPWR sky130_fd_sc_hd__decap_3
XFILLER_30_50 VGND VGND VPWR VPWR sky130_fd_sc_hd__decap_3
XFILLER_5_223 VGND VGND VPWR VPWR sky130_fd_sc_hd__fill_1
XFILLER_30_83 VGND VGND VPWR VPWR sky130_fd_sc_hd__fill_1
XFILLER_5_267 VGND VGND VPWR VPWR sky130_fd_sc_hd__decap_3
XFILLER_30_94 VGND VGND VPWR VPWR sky130_fd_sc_hd__decap_3
XFILLER_49_433 VGND VGND VPWR VPWR sky130_fd_sc_hd__fill_1
XFILLER_89_591 VGND VGND VPWR VPWR sky130_fd_sc_hd__decap_3
XFILLER_49_455 VGND VGND VPWR VPWR sky130_fd_sc_hd__decap_3
XFILLER_76_230 VGND VGND VPWR VPWR sky130_fd_sc_hd__decap_3
XFILLER_91_222 VGND VGND VPWR VPWR sky130_fd_sc_hd__fill_2
XFILLER_17_396 VGND VGND VPWR VPWR sky130_fd_sc_hd__decap_3
XFILLER_44_193 VGND VGND VPWR VPWR sky130_fd_sc_hd__decap_3
X_3830_ _3830_/A _3830_/B VGND VGND VPWR VPWR _3831_/C sky130_fd_sc_hd__xnor2_2
XFILLER_20_528 VGND VGND VPWR VPWR sky130_fd_sc_hd__decap_3
X_3761_ _3747_/A _3747_/C _3747_/B VGND VGND VPWR VPWR _3761_/Y sky130_fd_sc_hd__a21oi_2
X_5500_ _5501_/B _5501_/A VGND VGND VPWR VPWR _5500_/X sky130_fd_sc_hd__and2_2
XTAP_TAPCELL_ROW_30_534 VGND VPWR sky130_fd_sc_hd__tapvpwrvgnd_1
XFILLER_72_3 VGND VGND VPWR VPWR sky130_fd_sc_hd__fill_2
X_6480_ _6552_/A3 _6552_/A2 _6228_/A _6606_/A3 _6439_/B _6478_/S VGND VGND VPWR VPWR
+ _6480_/X sky130_fd_sc_hd__mux4_2
X_3692_ _3632_/A _3632_/B _3630_/X VGND VGND VPWR VPWR _3704_/A sky130_fd_sc_hd__a21o_2
X_5431_ _5431_/A _5431_/B VGND VGND VPWR VPWR _5433_/C sky130_fd_sc_hd__xnor2_4
X_5362_ _5361_/A _5398_/C _5490_/D _5361_/B VGND VGND VPWR VPWR _5362_/Y sky130_fd_sc_hd__a22oi_2
XFILLER_99_300 VGND VGND VPWR VPWR sky130_fd_sc_hd__decap_3
X_4313_ _4313_/A _4313_/B _4313_/C _4313_/D VGND VGND VPWR VPWR _4313_/Y sky130_fd_sc_hd__nand4_2
XFILLER_87_528 VGND VGND VPWR VPWR sky130_fd_sc_hd__decap_3
X_5293_ _5292_/A _5292_/C _5345_/A VGND VGND VPWR VPWR _5296_/B sky130_fd_sc_hd__o21ai_2
XFILLER_99_355 VGND VGND VPWR VPWR sky130_fd_sc_hd__decap_3
X_4244_ _4243_/B _4243_/C _4243_/A VGND VGND VPWR VPWR _4246_/C sky130_fd_sc_hd__a21bo_4
XFILLER_99_399 VGND VGND VPWR VPWR sky130_fd_sc_hd__decap_3
X_4175_ _3762_/Y _4144_/X _4156_/Y _4172_/X VGND VGND VPWR VPWR _4192_/B sky130_fd_sc_hd__o211ai_2
XFILLER_95_561 VGND VGND VPWR VPWR sky130_fd_sc_hd__fill_1
XFILLER_95_550 VGND VGND VPWR VPWR sky130_fd_sc_hd__fill_1
XFILLER_27_116 VGND VGND VPWR VPWR sky130_fd_sc_hd__decap_3
XFILLER_82_200 VGND VGND VPWR VPWR sky130_fd_sc_hd__fill_1
XFILLER_82_211 VGND VGND VPWR VPWR sky130_fd_sc_hd__decap_3
XTAP_TAPCELL_ROW_66_910 VGND VPWR sky130_fd_sc_hd__tapvpwrvgnd_1
XTAP_TAPCELL_ROW_38_612 VGND VPWR sky130_fd_sc_hd__tapvpwrvgnd_1
XTAP_TAPCELL_ROW_2_237 VGND VPWR sky130_fd_sc_hd__tapvpwrvgnd_1
XFILLER_67_296 VGND VGND VPWR VPWR sky130_fd_sc_hd__decap_3
XFILLER_35_17 VGND VGND VPWR VPWR sky130_fd_sc_hd__fill_1
XFILLER_23_311 VGND VGND VPWR VPWR sky130_fd_sc_hd__decap_3
XFILLER_82_299 VGND VGND VPWR VPWR sky130_fd_sc_hd__decap_3
X_6816_ _6767_/B _6674_/X _6815_/X _6746_/A _6813_/Y VGND VGND VPWR VPWR _6816_/X
+ sky130_fd_sc_hd__o221a_2
XFILLER_11_517 VGND VGND VPWR VPWR sky130_fd_sc_hd__decap_3
XFILLER_50_174 VGND VGND VPWR VPWR sky130_fd_sc_hd__decap_3
X_6747_ _6767_/B _6607_/X _6743_/X _6746_/X VGND VGND VPWR VPWR _6747_/X sky130_fd_sc_hd__o211a_2
XFILLER_51_38 VGND VGND VPWR VPWR sky130_fd_sc_hd__decap_3
X_3959_ _3990_/A _6178_/A _3958_/B _3955_/X VGND VGND VPWR VPWR _3966_/A sky130_fd_sc_hd__a31o_2
X_6678_ _6678_/A _6678_/B VGND VGND VPWR VPWR _6680_/C sky130_fd_sc_hd__or2_2
X_5629_ _5629_/A _5629_/B _5629_/C VGND VGND VPWR VPWR _5632_/A sky130_fd_sc_hd__and3_2
XFILLER_2_237 VGND VGND VPWR VPWR sky130_fd_sc_hd__decap_3
Xfanout541 _3544_/A VGND VGND VPWR VPWR fanout541/X sky130_fd_sc_hd__clkdlybuf4s25_1
XFILLER_58_230 VGND VGND VPWR VPWR sky130_fd_sc_hd__decap_3
Xfanout563 wire573/A VGND VGND VPWR VPWR _4687_/C sky130_fd_sc_hd__buf_6
Xfanout574 input25/X VGND VGND VPWR VPWR _6731_/A sky130_fd_sc_hd__clkdlybuf4s25_1
XFILLER_100_360 VGND VGND VPWR VPWR sky130_fd_sc_hd__decap_3
XFILLER_18_105 VGND VGND VPWR VPWR sky130_fd_sc_hd__fill_2
XFILLER_58_274 VGND VGND VPWR VPWR sky130_fd_sc_hd__decap_3
XFILLER_73_200 VGND VGND VPWR VPWR sky130_fd_sc_hd__decap_3
XFILLER_76_79 VGND VGND VPWR VPWR sky130_fd_sc_hd__decap_3
XFILLER_86_561 VGND VGND VPWR VPWR sky130_fd_sc_hd__decap_3
Xfanout596 _6673_/A2 VGND VGND VPWR VPWR _5277_/C sky130_fd_sc_hd__buf_6
XFILLER_100_393 VGND VGND VPWR VPWR sky130_fd_sc_hd__decap_3
XFILLER_73_233 VGND VGND VPWR VPWR sky130_fd_sc_hd__decap_3
XFILLER_73_244 VGND VGND VPWR VPWR sky130_fd_sc_hd__decap_3
XFILLER_73_277 VGND VGND VPWR VPWR sky130_fd_sc_hd__decap_3
XFILLER_61_439 VGND VGND VPWR VPWR sky130_fd_sc_hd__decap_3
XFILLER_73_299 VGND VGND VPWR VPWR sky130_fd_sc_hd__fill_1
XFILLER_92_67 VGND VGND VPWR VPWR sky130_fd_sc_hd__decap_3
XTAP_TAPCELL_ROW_72_968 VGND VPWR sky130_fd_sc_hd__tapvpwrvgnd_1
XFILLER_14_377 VGND VGND VPWR VPWR sky130_fd_sc_hd__fill_1
XFILLER_14_399 VGND VGND VPWR VPWR sky130_fd_sc_hd__decap_3
XFILLER_25_94 VGND VGND VPWR VPWR sky130_fd_sc_hd__decap_3
XFILLER_6_521 VGND VGND VPWR VPWR sky130_fd_sc_hd__decap_3
XFILLER_69_517 VGND VGND VPWR VPWR sky130_fd_sc_hd__decap_3
XFILLER_96_303 VGND VGND VPWR VPWR sky130_fd_sc_hd__decap_3
XFILLER_84_509 VGND VGND VPWR VPWR sky130_fd_sc_hd__decap_3
XFILLER_49_252 VGND VGND VPWR VPWR sky130_fd_sc_hd__decap_3
XFILLER_64_200 VGND VGND VPWR VPWR sky130_fd_sc_hd__decap_3
XFILLER_77_561 VGND VGND VPWR VPWR sky130_fd_sc_hd__decap_3
XFILLER_37_447 VGND VGND VPWR VPWR sky130_fd_sc_hd__fill_1
XFILLER_49_296 VGND VGND VPWR VPWR sky130_fd_sc_hd__decap_3
XFILLER_64_233 VGND VGND VPWR VPWR sky130_fd_sc_hd__decap_3
XFILLER_77_594 VGND VGND VPWR VPWR sky130_fd_sc_hd__decap_3
XFILLER_52_406 VGND VGND VPWR VPWR sky130_fd_sc_hd__decap_3
XFILLER_64_277 VGND VGND VPWR VPWR sky130_fd_sc_hd__decap_3
X_5980_ _6079_/A _5981_/B _5981_/C _3972_/A VGND VGND VPWR VPWR _5984_/A sky130_fd_sc_hd__a22o_2
XFILLER_64_299 VGND VGND VPWR VPWR sky130_fd_sc_hd__decap_3
X_4931_ _4931_/A _4931_/B VGND VGND VPWR VPWR _5017_/B sky130_fd_sc_hd__nor2_2
XFILLER_32_141 VGND VGND VPWR VPWR sky130_fd_sc_hd__decap_3
X_4862_ _4813_/B _4816_/B _4860_/A _4861_/Y VGND VGND VPWR VPWR _4862_/Y sky130_fd_sc_hd__a211oi_2
X_6601_ _6381_/A _6137_/B _6778_/B1 VGND VGND VPWR VPWR _6601_/Y sky130_fd_sc_hd__a21oi_2
X_3813_ _5976_/D _3814_/C VGND VGND VPWR VPWR _3925_/A sky130_fd_sc_hd__nand2_2
XTAP_TAPCELL_ROW_43_670 VGND VPWR sky130_fd_sc_hd__tapvpwrvgnd_1
X_4793_ _4793_/A _6315_/A VGND VGND VPWR VPWR _4983_/A sky130_fd_sc_hd__nand2_2
XTAP_TAPCELL_ROW_15_372 VGND VPWR sky130_fd_sc_hd__tapvpwrvgnd_1
X_6532_ _6532_/A VGND VGND VPWR VPWR _6532_/Y sky130_fd_sc_hd__inv_2
X_3744_ _3744_/A _3744_/B VGND VGND VPWR VPWR _4134_/B sky130_fd_sc_hd__xnor2_2
X_6463_ _6498_/B _6459_/X _6462_/X _6390_/B VGND VGND VPWR VPWR _6779_/B sky130_fd_sc_hd__a22oi_2
X_3675_ _3675_/A VGND VGND VPWR VPWR _3675_/Y sky130_fd_sc_hd__inv_2
Xoutput100 _6986_/D VGND VGND VPWR VPWR result[7] sky130_fd_sc_hd__clkbuf_2
X_5414_ _5414_/A _5414_/B _5414_/C VGND VGND VPWR VPWR _5414_/Y sky130_fd_sc_hd__nand3_2
XTAP_TAPCELL_ROW_76_1016 VGND VPWR sky130_fd_sc_hd__tapvpwrvgnd_1
X_6394_ _6182_/B _6187_/B _6395_/S VGND VGND VPWR VPWR _6394_/X sky130_fd_sc_hd__mux2_1
X_5345_ _5345_/A _5345_/B _5345_/C VGND VGND VPWR VPWR _5473_/A sky130_fd_sc_hd__and3_2
XFILLER_87_325 VGND VGND VPWR VPWR sky130_fd_sc_hd__fill_2
X_5276_ _4748_/B _5398_/C _5490_/D _5276_/B2 VGND VGND VPWR VPWR _5276_/Y sky130_fd_sc_hd__a22oi_2
X_4227_ _4228_/A _4228_/C _4228_/B VGND VGND VPWR VPWR _4227_/Y sky130_fd_sc_hd__a21oi_2
XFILLER_28_403 VGND VGND VPWR VPWR sky130_fd_sc_hd__fill_1
XFILLER_68_572 VGND VGND VPWR VPWR sky130_fd_sc_hd__fill_1
XFILLER_55_222 VGND VGND VPWR VPWR sky130_fd_sc_hd__fill_2
XFILLER_83_531 VGND VGND VPWR VPWR sky130_fd_sc_hd__decap_3
X_4158_ _4406_/B _4518_/B VGND VGND VPWR VPWR _4268_/A sky130_fd_sc_hd__nand2_2
XTAP_TAPCELL_ROW_87_1134 VGND VPWR sky130_fd_sc_hd__tapvpwrvgnd_1
XFILLER_95_391 VGND VGND VPWR VPWR sky130_fd_sc_hd__fill_1
XFILLER_15_108 VGND VGND VPWR VPWR sky130_fd_sc_hd__decap_3
XFILLER_28_469 VGND VGND VPWR VPWR sky130_fd_sc_hd__decap_3
XFILLER_43_417 VGND VGND VPWR VPWR sky130_fd_sc_hd__decap_3
XFILLER_83_564 VGND VGND VPWR VPWR sky130_fd_sc_hd__decap_3
X_4089_ _3990_/A _5992_/A _3542_/A _3540_/Y VGND VGND VPWR VPWR _4090_/B sky130_fd_sc_hd__o2bb2a_2
XFILLER_55_288 VGND VGND VPWR VPWR sky130_fd_sc_hd__decap_3
XFILLER_70_203 VGND VGND VPWR VPWR sky130_fd_sc_hd__decap_3
XFILLER_23_163 VGND VGND VPWR VPWR sky130_fd_sc_hd__decap_3
Xwire205 input7/X VGND VGND VPWR VPWR _3923_/B sky130_fd_sc_hd__clkbuf_4
XTAP_TAPCELL_ROW_98_1241 VGND VPWR sky130_fd_sc_hd__tapvpwrvgnd_1
XFILLER_2_3 VGND VGND VPWR VPWR sky130_fd_sc_hd__decap_3
XFILLER_3_557 VGND VGND VPWR VPWR sky130_fd_sc_hd__decap_3
XFILLER_59_550 VGND VGND VPWR VPWR sky130_fd_sc_hd__decap_3
XFILLER_66_509 VGND VGND VPWR VPWR sky130_fd_sc_hd__decap_3
XFILLER_19_403 VGND VGND VPWR VPWR sky130_fd_sc_hd__decap_3
XFILLER_59_561 VGND VGND VPWR VPWR sky130_fd_sc_hd__decap_3
Xfanout360 _6478_/S VGND VGND VPWR VPWR _6126_/B sky130_fd_sc_hd__clkbuf_2
Xfanout371 input43/X VGND VGND VPWR VPWR _6090_/A sky130_fd_sc_hd__clkdlybuf4s25_1
Xfanout393 _4264_/A VGND VGND VPWR VPWR _5395_/A sky130_fd_sc_hd__clkdlybuf4s25_1
XTAP_TAPCELL_ROW_49_729 VGND VPWR sky130_fd_sc_hd__tapvpwrvgnd_1
XFILLER_19_447 VGND VGND VPWR VPWR sky130_fd_sc_hd__fill_1
XFILLER_74_542 VGND VGND VPWR VPWR sky130_fd_sc_hd__decap_3
XFILLER_86_380 VGND VGND VPWR VPWR sky130_fd_sc_hd__decap_3
XFILLER_100_190 VGND VGND VPWR VPWR sky130_fd_sc_hd__decap_3
XFILLER_46_266 VGND VGND VPWR VPWR sky130_fd_sc_hd__decap_3
XFILLER_34_417 VGND VGND VPWR VPWR sky130_fd_sc_hd__decap_3
XFILLER_36_82 VGND VGND VPWR VPWR sky130_fd_sc_hd__fill_2
XFILLER_61_203 VGND VGND VPWR VPWR sky130_fd_sc_hd__decap_3
XFILLER_61_225 VGND VGND VPWR VPWR sky130_fd_sc_hd__decap_3
XFILLER_52_81 VGND VGND VPWR VPWR sky130_fd_sc_hd__decap_3
Xinput13 A[20] VGND VGND VPWR VPWR _6014_/B sky130_fd_sc_hd__clkbuf_2
XTAP_TAPCELL_ROW_40_640 VGND VPWR sky130_fd_sc_hd__tapvpwrvgnd_1
XTAP_TAPCELL_ROW_12_342 VGND VPWR sky130_fd_sc_hd__tapvpwrvgnd_1
Xinput46 B[21] VGND VGND VPWR VPWR _5981_/C sky130_fd_sc_hd__dlymetal6s2s_1
Xinput35 B[11] VGND VGND VPWR VPWR input35/X sky130_fd_sc_hd__dlymetal6s2s_1
Xinput24 A[30] VGND VGND VPWR VPWR _6068_/B sky130_fd_sc_hd__buf_1
XFILLER_10_391 VGND VGND VPWR VPWR sky130_fd_sc_hd__decap_3
XFILLER_6_351 VGND VGND VPWR VPWR sky130_fd_sc_hd__decap_3
Xinput68 opcode[3] VGND VGND VPWR VPWR _6332_/B sky130_fd_sc_hd__clkdlybuf4s25_1
Xinput57 B[31] VGND VGND VPWR VPWR _6350_/B sky130_fd_sc_hd__clkdlybuf4s25_1
XFILLER_6_384 VGND VGND VPWR VPWR sky130_fd_sc_hd__decap_3
XFILLER_35_3 VGND VGND VPWR VPWR sky130_fd_sc_hd__fill_1
X_5130_ _5127_/X _5130_/B VGND VGND VPWR VPWR _5197_/B sky130_fd_sc_hd__and2b_2
X_5061_ _5126_/C _5059_/A _5060_/Y _5044_/X VGND VGND VPWR VPWR _5061_/X sky130_fd_sc_hd__a211o_4
XFILLER_84_328 VGND VGND VPWR VPWR sky130_fd_sc_hd__decap_3
X_4012_ _6008_/B _6187_/A _4482_/B _6276_/A VGND VGND VPWR VPWR _4013_/B sky130_fd_sc_hd__a22oi_2
XFILLER_65_564 VGND VGND VPWR VPWR sky130_fd_sc_hd__decap_3
XFILLER_92_350 VGND VGND VPWR VPWR sky130_fd_sc_hd__decap_3
XFILLER_18_480 VGND VGND VPWR VPWR sky130_fd_sc_hd__decap_3
XFILLER_25_417 VGND VGND VPWR VPWR sky130_fd_sc_hd__decap_3
XFILLER_52_203 VGND VGND VPWR VPWR sky130_fd_sc_hd__decap_3
XFILLER_65_597 VGND VGND VPWR VPWR sky130_fd_sc_hd__fill_1
XFILLER_92_383 VGND VGND VPWR VPWR sky130_fd_sc_hd__decap_3
X_5963_ _5963_/A _5963_/B VGND VGND VPWR VPWR _5971_/A sky130_fd_sc_hd__xnor2_2
X_4914_ _4912_/X _4911_/Y _4854_/Y _4875_/X VGND VGND VPWR VPWR _4914_/Y sky130_fd_sc_hd__a211oi_4
XFILLER_33_461 VGND VGND VPWR VPWR sky130_fd_sc_hd__decap_3
XFILLER_80_589 VGND VGND VPWR VPWR sky130_fd_sc_hd__decap_3
X_5894_ _5888_/B _5888_/C _5888_/D _5888_/A VGND VGND VPWR VPWR _5894_/X sky130_fd_sc_hd__o22a_2
XFILLER_20_122 VGND VGND VPWR VPWR sky130_fd_sc_hd__decap_3
XFILLER_33_483 VGND VGND VPWR VPWR sky130_fd_sc_hd__decap_3
X_4845_ _4845_/A _4845_/B _4845_/C VGND VGND VPWR VPWR _4848_/B sky130_fd_sc_hd__or3_4
XTAP_TAPCELL_ROW_82_1075 VGND VPWR sky130_fd_sc_hd__tapvpwrvgnd_1
XFILLER_20_155 VGND VGND VPWR VPWR sky130_fd_sc_hd__decap_3
X_4776_ _4775_/B _4775_/C _4775_/A VGND VGND VPWR VPWR _4776_/Y sky130_fd_sc_hd__a21oi_2
X_6515_ _6515_/A _6515_/B VGND VGND VPWR VPWR _6516_/B sky130_fd_sc_hd__xnor2_2
X_3727_ _3730_/A VGND VGND VPWR VPWR _3887_/A sky130_fd_sc_hd__inv_2
X_6446_ _6446_/A _6447_/A VGND VGND VPWR VPWR _6446_/Y sky130_fd_sc_hd__nor2_2
X_3658_ _6019_/D _6014_/C _3678_/A _3656_/Y VGND VGND VPWR VPWR _3659_/B sky130_fd_sc_hd__o2bb2a_2
X_6377_ _6332_/A _6375_/A _6332_/C _6374_/X _6376_/X VGND VGND VPWR VPWR _6388_/B
+ sky130_fd_sc_hd__o311a_2
X_3589_ _3590_/B VGND VGND VPWR VPWR _3605_/A sky130_fd_sc_hd__inv_2
XFILLER_0_505 VGND VGND VPWR VPWR sky130_fd_sc_hd__decap_3
XFILLER_0_527 VGND VGND VPWR VPWR sky130_fd_sc_hd__decap_3
X_5328_ _5382_/B _5383_/A _5328_/C _5382_/D VGND VGND VPWR VPWR _5331_/A sky130_fd_sc_hd__and4_2
XTAP_TAPCELL_ROW_93_1193 VGND VPWR sky130_fd_sc_hd__tapvpwrvgnd_1
XFILLER_87_144 VGND VGND VPWR VPWR sky130_fd_sc_hd__decap_3
XFILLER_57_37 VGND VGND VPWR VPWR sky130_fd_sc_hd__fill_1
X_5259_ _5182_/Y _5262_/A _5262_/B _5263_/B VGND VGND VPWR VPWR _6839_/B sky130_fd_sc_hd__a31oi_2
XFILLER_68_380 VGND VGND VPWR VPWR sky130_fd_sc_hd__decap_3
XFILLER_28_233 VGND VGND VPWR VPWR sky130_fd_sc_hd__decap_3
XFILLER_90_309 VGND VGND VPWR VPWR sky130_fd_sc_hd__fill_2
XFILLER_16_417 VGND VGND VPWR VPWR sky130_fd_sc_hd__decap_3
XFILLER_16_439 VGND VGND VPWR VPWR sky130_fd_sc_hd__decap_3
XFILLER_43_203 VGND VGND VPWR VPWR sky130_fd_sc_hd__decap_3
XFILLER_71_523 VGND VGND VPWR VPWR sky130_fd_sc_hd__fill_2
XFILLER_73_25 VGND VGND VPWR VPWR sky130_fd_sc_hd__decap_3
XFILLER_43_258 VGND VGND VPWR VPWR sky130_fd_sc_hd__fill_2
XFILLER_71_556 VGND VGND VPWR VPWR sky130_fd_sc_hd__decap_3
XFILLER_73_69 VGND VGND VPWR VPWR sky130_fd_sc_hd__decap_3
XTAP_TAPCELL_ROW_54_787 VGND VPWR sky130_fd_sc_hd__tapvpwrvgnd_1
XTAP_TAPCELL_ROW_26_489 VGND VPWR sky130_fd_sc_hd__tapvpwrvgnd_1
XFILLER_24_494 VGND VGND VPWR VPWR sky130_fd_sc_hd__decap_3
XFILLER_11_133 VGND VGND VPWR VPWR sky130_fd_sc_hd__decap_3
XFILLER_3_332 VGND VGND VPWR VPWR sky130_fd_sc_hd__decap_3
XFILLER_66_306 VGND VGND VPWR VPWR sky130_fd_sc_hd__fill_2
XFILLER_47_520 VGND VGND VPWR VPWR sky130_fd_sc_hd__decap_3
XFILLER_59_391 VGND VGND VPWR VPWR sky130_fd_sc_hd__fill_1
XFILLER_66_339 VGND VGND VPWR VPWR sky130_fd_sc_hd__decap_3
Xfanout190 fanout194/A VGND VGND VPWR VPWR _6249_/B sky130_fd_sc_hd__clkdlybuf4s25_1
XFILLER_93_147 VGND VGND VPWR VPWR sky130_fd_sc_hd__decap_3
XFILLER_93_169 VGND VGND VPWR VPWR sky130_fd_sc_hd__decap_3
XFILLER_62_523 VGND VGND VPWR VPWR sky130_fd_sc_hd__decap_3
XFILLER_74_383 VGND VGND VPWR VPWR sky130_fd_sc_hd__decap_3
XFILLER_62_589 VGND VGND VPWR VPWR sky130_fd_sc_hd__decap_3
XFILLER_42_280 VGND VGND VPWR VPWR sky130_fd_sc_hd__decap_3
XFILLER_30_442 VGND VGND VPWR VPWR sky130_fd_sc_hd__decap_3
XFILLER_8_20 VGND VGND VPWR VPWR sky130_fd_sc_hd__decap_3
X_4630_ _4631_/A _4629_/Y _4630_/C _4646_/D VGND VGND VPWR VPWR _4922_/A sky130_fd_sc_hd__and4bb_2
X_6300_ _6212_/A _5582_/B _5542_/A VGND VGND VPWR VPWR _6300_/Y sky130_fd_sc_hd__o21ai_2
X_4561_ _5920_/B1 _4558_/B _4563_/B1 _4560_/Y VGND VGND VPWR VPWR _4561_/Y sky130_fd_sc_hd__o211ai_2
X_4492_ _4491_/A _4491_/B _4491_/C VGND VGND VPWR VPWR _4494_/B sky130_fd_sc_hd__a21oi_2
X_3512_ _4290_/A _6924_/S VGND VGND VPWR VPWR _3521_/A sky130_fd_sc_hd__nand2_2
XFILLER_6_192 VGND VGND VPWR VPWR sky130_fd_sc_hd__decap_3
X_6231_ _6381_/B _6231_/B _6231_/C VGND VGND VPWR VPWR _6566_/A sky130_fd_sc_hd__and3_2
X_6162_ _6088_/X _6795_/A _6796_/A VGND VGND VPWR VPWR _6807_/B sky130_fd_sc_hd__o21ai_2
XFILLER_69_122 VGND VGND VPWR VPWR sky130_fd_sc_hd__decap_3
Xload_slew530 _4010_/B VGND VGND VPWR VPWR _3960_/A sky130_fd_sc_hd__clkbuf_4
X_5113_ _5113_/A _5187_/A VGND VGND VPWR VPWR _5170_/A sky130_fd_sc_hd__xor2_2
Xload_slew552 _5765_/A VGND VGND VPWR VPWR _6228_/A sky130_fd_sc_hd__buf_4
X_6093_ _6093_/A _6093_/B VGND VGND VPWR VPWR _6095_/B sky130_fd_sc_hd__or2_2
XFILLER_69_199 VGND VGND VPWR VPWR sky130_fd_sc_hd__decap_3
Xload_slew585 _4630_/C VGND VGND VPWR VPWR _4593_/A sky130_fd_sc_hd__clkbuf_4
X_5044_ _5045_/A _5045_/B _5045_/C VGND VGND VPWR VPWR _5044_/X sky130_fd_sc_hd__and3_4
XFILLER_27_29 VGND VGND VPWR VPWR sky130_fd_sc_hd__decap_3
XFILLER_38_542 VGND VGND VPWR VPWR sky130_fd_sc_hd__decap_3
XFILLER_72_309 VGND VGND VPWR VPWR sky130_fd_sc_hd__decap_3
XFILLER_84_147 VGND VGND VPWR VPWR sky130_fd_sc_hd__decap_3
XFILLER_25_203 VGND VGND VPWR VPWR sky130_fd_sc_hd__decap_3
XFILLER_38_586 VGND VGND VPWR VPWR sky130_fd_sc_hd__fill_2
XFILLER_38_597 VGND VGND VPWR VPWR sky130_fd_sc_hd__fill_1
XFILLER_65_383 VGND VGND VPWR VPWR sky130_fd_sc_hd__decap_3
XTAP_TAPCELL_ROW_84_1104 VGND VPWR sky130_fd_sc_hd__tapvpwrvgnd_1
XFILLER_25_225 VGND VGND VPWR VPWR sky130_fd_sc_hd__decap_3
XFILLER_80_342 VGND VGND VPWR VPWR sky130_fd_sc_hd__decap_3
XFILLER_92_191 VGND VGND VPWR VPWR sky130_fd_sc_hd__decap_3
X_6995_ _6995_/A _6995_/B _6995_/C _6995_/D VGND VGND VPWR VPWR _6995_/Y sky130_fd_sc_hd__nor4_4
XFILLER_80_386 VGND VGND VPWR VPWR sky130_fd_sc_hd__fill_1
X_5946_ _6016_/D _6014_/C _3942_/X _3941_/X _3834_/D VGND VGND VPWR VPWR _5951_/A
+ sky130_fd_sc_hd__a32o_2
XFILLER_40_228 VGND VGND VPWR VPWR sky130_fd_sc_hd__decap_3
X_5877_ _5876_/B _5872_/X _5011_/Y _6839_/A _5264_/Y VGND VGND VPWR VPWR _5877_/X
+ sky130_fd_sc_hd__a2111o_2
XFILLER_33_291 VGND VGND VPWR VPWR sky130_fd_sc_hd__decap_3
X_4828_ _4828_/A _4828_/B _4828_/C VGND VGND VPWR VPWR _4830_/B sky130_fd_sc_hd__nand3_2
XTAP_TAPCELL_ROW_51_757 VGND VPWR sky130_fd_sc_hd__tapvpwrvgnd_1
XTAP_TAPCELL_ROW_23_459 VGND VPWR sky130_fd_sc_hd__tapvpwrvgnd_1
Xrebuffer713 _5126_/C VGND VGND VPWR VPWR _5145_/B1 sky130_fd_sc_hd__buf_2
Xrebuffer724 _4559_/X VGND VGND VPWR VPWR _4563_/B1 sky130_fd_sc_hd__buf_2
Xrebuffer702 _5872_/X VGND VGND VPWR VPWR _5876_/A sky130_fd_sc_hd__buf_6
Xrebuffer735 _5275_/B VGND VGND VPWR VPWR _5137_/A sky130_fd_sc_hd__buf_2
Xrebuffer746 _5053_/D VGND VGND VPWR VPWR _5138_/B2 sky130_fd_sc_hd__buf_2
Xrebuffer757 _4956_/X VGND VGND VPWR VPWR _4975_/C1 sky130_fd_sc_hd__buf_2
X_4759_ _4736_/B _4754_/C _4754_/B VGND VGND VPWR VPWR _4760_/C sky130_fd_sc_hd__a21o_2
XTAP_TAPCELL_ROW_95_1211 VGND VPWR sky130_fd_sc_hd__tapvpwrvgnd_1
X_6429_ _3663_/A _6244_/B _6435_/S VGND VGND VPWR VPWR _6429_/X sky130_fd_sc_hd__mux2_1
XFILLER_0_302 VGND VGND VPWR VPWR sky130_fd_sc_hd__decap_3
XFILLER_0_324 VGND VGND VPWR VPWR sky130_fd_sc_hd__decap_3
XFILLER_0_346 VGND VGND VPWR VPWR sky130_fd_sc_hd__decap_3
XFILLER_68_36 VGND VGND VPWR VPWR sky130_fd_sc_hd__decap_3
XFILLER_88_442 VGND VGND VPWR VPWR sky130_fd_sc_hd__decap_3
XFILLER_88_453 VGND VGND VPWR VPWR sky130_fd_sc_hd__decap_3
XFILLER_29_531 VGND VGND VPWR VPWR sky130_fd_sc_hd__decap_3
XTAP_TAPCELL_ROW_59_835 VGND VPWR sky130_fd_sc_hd__tapvpwrvgnd_1
XFILLER_29_564 VGND VGND VPWR VPWR sky130_fd_sc_hd__fill_1
XFILLER_75_158 VGND VGND VPWR VPWR sky130_fd_sc_hd__decap_3
XFILLER_75_169 VGND VGND VPWR VPWR sky130_fd_sc_hd__decap_3
XFILLER_84_35 VGND VGND VPWR VPWR sky130_fd_sc_hd__decap_3
XFILLER_17_40 VGND VGND VPWR VPWR sky130_fd_sc_hd__fill_2
XFILLER_56_383 VGND VGND VPWR VPWR sky130_fd_sc_hd__decap_3
XFILLER_44_545 VGND VGND VPWR VPWR sky130_fd_sc_hd__decap_3
XFILLER_71_320 VGND VGND VPWR VPWR sky130_fd_sc_hd__decap_3
XFILLER_83_180 VGND VGND VPWR VPWR sky130_fd_sc_hd__decap_3
XFILLER_71_375 VGND VGND VPWR VPWR sky130_fd_sc_hd__decap_3
XFILLER_24_280 VGND VGND VPWR VPWR sky130_fd_sc_hd__decap_3
XFILLER_12_442 VGND VGND VPWR VPWR sky130_fd_sc_hd__decap_3
XFILLER_12_475 VGND VGND VPWR VPWR sky130_fd_sc_hd__fill_1
XFILLER_12_486 VGND VGND VPWR VPWR sky130_fd_sc_hd__decap_3
XFILLER_8_424 VGND VGND VPWR VPWR sky130_fd_sc_hd__decap_3
XFILLER_8_446 VGND VGND VPWR VPWR sky130_fd_sc_hd__decap_3
XFILLER_3_184 VGND VGND VPWR VPWR sky130_fd_sc_hd__fill_2
XFILLER_79_420 VGND VGND VPWR VPWR sky130_fd_sc_hd__decap_3
XFILLER_39_306 VGND VGND VPWR VPWR sky130_fd_sc_hd__decap_3
XFILLER_79_464 VGND VGND VPWR VPWR sky130_fd_sc_hd__decap_3
XFILLER_58_91 VGND VGND VPWR VPWR sky130_fd_sc_hd__fill_1
XFILLER_66_136 VGND VGND VPWR VPWR sky130_fd_sc_hd__decap_3
XFILLER_79_497 VGND VGND VPWR VPWR sky130_fd_sc_hd__decap_3
XFILLER_94_445 VGND VGND VPWR VPWR sky130_fd_sc_hd__decap_3
XFILLER_54_309 VGND VGND VPWR VPWR sky130_fd_sc_hd__fill_2
XFILLER_66_147 VGND VGND VPWR VPWR sky130_fd_sc_hd__decap_3
XFILLER_47_383 VGND VGND VPWR VPWR sky130_fd_sc_hd__decap_3
XFILLER_35_534 VGND VGND VPWR VPWR sky130_fd_sc_hd__decap_3
XFILLER_62_342 VGND VGND VPWR VPWR sky130_fd_sc_hd__decap_3
XFILLER_74_180 VGND VGND VPWR VPWR sky130_fd_sc_hd__decap_3
XFILLER_35_578 VGND VGND VPWR VPWR sky130_fd_sc_hd__decap_3
XFILLER_62_375 VGND VGND VPWR VPWR sky130_fd_sc_hd__decap_3
X_6780_ _6095_/B _6809_/B _6797_/A2 _6095_/A VGND VGND VPWR VPWR _6780_/X sky130_fd_sc_hd__o2bb2a_2
X_5800_ _6123_/A _5791_/B _5791_/C VGND VGND VPWR VPWR _5801_/B sky130_fd_sc_hd__a21oi_2
X_3992_ _3992_/A _5994_/A VGND VGND VPWR VPWR _3992_/Y sky130_fd_sc_hd__nor2_2
XFILLER_22_217 VGND VGND VPWR VPWR sky130_fd_sc_hd__decap_3
XFILLER_62_397 VGND VGND VPWR VPWR sky130_fd_sc_hd__decap_3
X_5731_ _5732_/A _5732_/B _5732_/C VGND VGND VPWR VPWR _5733_/A sky130_fd_sc_hd__a21oi_2
XFILLER_15_291 VGND VGND VPWR VPWR sky130_fd_sc_hd__decap_3
X_5662_ _5779_/A _5778_/C VGND VGND VPWR VPWR _5664_/B sky130_fd_sc_hd__and2_2
XTAP_TAPCELL_ROW_20_429 VGND VPWR sky130_fd_sc_hd__tapvpwrvgnd_1
XFILLER_30_283 VGND VGND VPWR VPWR sky130_fd_sc_hd__fill_2
X_5593_ _5591_/A _5591_/C _5591_/B VGND VGND VPWR VPWR _5594_/C sky130_fd_sc_hd__a21oi_2
X_4613_ _4612_/A _4612_/B _4612_/C VGND VGND VPWR VPWR _4614_/B sky130_fd_sc_hd__a21o_2
Xmax_cap110 _5564_/Y VGND VGND VPWR VPWR _5571_/A1 sky130_fd_sc_hd__clkbuf_2
X_4544_ _4544_/A _4544_/B _4544_/C VGND VGND VPWR VPWR _4547_/A sky130_fd_sc_hd__or3_2
Xmax_cap132 _6367_/A VGND VGND VPWR VPWR _6390_/B sky130_fd_sc_hd__clkbuf_2
Xmax_cap121 _6898_/B VGND VGND VPWR VPWR _6930_/A sky130_fd_sc_hd__buf_2
XFILLER_89_206 VGND VGND VPWR VPWR sky130_fd_sc_hd__decap_3
XFILLER_89_228 VGND VGND VPWR VPWR sky130_fd_sc_hd__decap_3
X_6214_ _6215_/B _6214_/B VGND VGND VPWR VPWR _6214_/X sky130_fd_sc_hd__and2b_2
X_4475_ _4593_/A _4592_/A _4593_/C _4593_/D VGND VGND VPWR VPWR _4475_/X sky130_fd_sc_hd__and4_2
Xmax_cap187 input9/X VGND VGND VPWR VPWR fanout186/A sky130_fd_sc_hd__buf_2
X_6145_ _6145_/A _6145_/B VGND VGND VPWR VPWR _6672_/B sky130_fd_sc_hd__nor2_2
XTAP_TAPCELL_ROW_90_1163 VGND VPWR sky130_fd_sc_hd__tapvpwrvgnd_1
XFILLER_85_423 VGND VGND VPWR VPWR sky130_fd_sc_hd__decap_3
Xload_slew382 _3639_/B VGND VGND VPWR VPWR _4646_/D sky130_fd_sc_hd__buf_4
X_6076_ _6077_/A _6263_/B VGND VGND VPWR VPWR _6076_/Y sky130_fd_sc_hd__nor2_2
XFILLER_97_294 VGND VGND VPWR VPWR sky130_fd_sc_hd__decap_3
XFILLER_57_147 VGND VGND VPWR VPWR sky130_fd_sc_hd__decap_3
XFILLER_57_169 VGND VGND VPWR VPWR sky130_fd_sc_hd__decap_3
XFILLER_85_445 VGND VGND VPWR VPWR sky130_fd_sc_hd__decap_3
XFILLER_85_467 VGND VGND VPWR VPWR sky130_fd_sc_hd__decap_3
X_5027_ _5027_/A _5027_/B VGND VGND VPWR VPWR _5102_/B sky130_fd_sc_hd__xnor2_2
XTAP_TAPCELL_ROW_56_805 VGND VPWR sky130_fd_sc_hd__tapvpwrvgnd_1
XFILLER_26_512 VGND VGND VPWR VPWR sky130_fd_sc_hd__decap_3
XFILLER_38_350 VGND VGND VPWR VPWR sky130_fd_sc_hd__decap_3
XTAP_TAPCELL_ROW_28_507 VGND VPWR sky130_fd_sc_hd__tapvpwrvgnd_1
XFILLER_38_383 VGND VGND VPWR VPWR sky130_fd_sc_hd__decap_3
XFILLER_54_38 VGND VGND VPWR VPWR sky130_fd_sc_hd__decap_3
XFILLER_65_191 VGND VGND VPWR VPWR sky130_fd_sc_hd__decap_3
XFILLER_72_139 VGND VGND VPWR VPWR sky130_fd_sc_hd__fill_1
XFILLER_26_589 VGND VGND VPWR VPWR sky130_fd_sc_hd__fill_1
XFILLER_13_217 VGND VGND VPWR VPWR sky130_fd_sc_hd__decap_3
XFILLER_13_228 VGND VGND VPWR VPWR sky130_fd_sc_hd__fill_1
XFILLER_41_548 VGND VGND VPWR VPWR sky130_fd_sc_hd__decap_3
XFILLER_53_386 VGND VGND VPWR VPWR sky130_fd_sc_hd__decap_3
XFILLER_80_194 VGND VGND VPWR VPWR sky130_fd_sc_hd__fill_2
X_6978_ _6200_/A _6978_/A2 _6978_/B1 _6068_/B _6977_/Y VGND VGND VPWR VPWR _6978_/X
+ sky130_fd_sc_hd__o221a_2
XTAP_TAPCELL_ROW_64_893 VGND VPWR sky130_fd_sc_hd__tapvpwrvgnd_1
XTAP_TAPCELL_ROW_36_595 VGND VPWR sky130_fd_sc_hd__tapvpwrvgnd_1
XFILLER_41_559 VGND VGND VPWR VPWR sky130_fd_sc_hd__fill_1
X_5929_ _5934_/A _6921_/A _5934_/B VGND VGND VPWR VPWR _5930_/B sky130_fd_sc_hd__o21bai_2
XFILLER_5_438 VGND VGND VPWR VPWR sky130_fd_sc_hd__decap_3
XFILLER_79_68 VGND VGND VPWR VPWR sky130_fd_sc_hd__decap_3
XFILLER_48_103 VGND VGND VPWR VPWR sky130_fd_sc_hd__decap_3
XFILLER_76_412 VGND VGND VPWR VPWR sky130_fd_sc_hd__decap_3
XTAP_TAPCELL_ROW_8_298 VGND VPWR sky130_fd_sc_hd__tapvpwrvgnd_1
XFILLER_95_34 VGND VGND VPWR VPWR sky130_fd_sc_hd__decap_3
XFILLER_36_309 VGND VGND VPWR VPWR sky130_fd_sc_hd__fill_2
XFILLER_76_456 VGND VGND VPWR VPWR sky130_fd_sc_hd__fill_1
XFILLER_95_78 VGND VGND VPWR VPWR sky130_fd_sc_hd__decap_3
XFILLER_63_128 VGND VGND VPWR VPWR sky130_fd_sc_hd__decap_3
XFILLER_91_415 VGND VGND VPWR VPWR sky130_fd_sc_hd__decap_3
XFILLER_44_320 VGND VGND VPWR VPWR sky130_fd_sc_hd__decap_3
XFILLER_56_180 VGND VGND VPWR VPWR sky130_fd_sc_hd__decap_3
XFILLER_17_589 VGND VGND VPWR VPWR sky130_fd_sc_hd__fill_1
XFILLER_32_515 VGND VGND VPWR VPWR sky130_fd_sc_hd__fill_1
XFILLER_71_150 VGND VGND VPWR VPWR sky130_fd_sc_hd__decap_3
XFILLER_32_526 VGND VGND VPWR VPWR sky130_fd_sc_hd__decap_3
XFILLER_71_172 VGND VGND VPWR VPWR sky130_fd_sc_hd__decap_3
XFILLER_40_592 VGND VGND VPWR VPWR sky130_fd_sc_hd__fill_2
XFILLER_67_6 VGND VGND VPWR VPWR sky130_fd_sc_hd__decap_3
XFILLER_4_493 VGND VGND VPWR VPWR sky130_fd_sc_hd__decap_3
X_4260_ _4156_/A _4171_/Y _4272_/A _4170_/A VGND VGND VPWR VPWR _4260_/Y sky130_fd_sc_hd__o211ai_2
XFILLER_67_401 VGND VGND VPWR VPWR sky130_fd_sc_hd__decap_3
XFILLER_86_209 VGND VGND VPWR VPWR sky130_fd_sc_hd__decap_3
X_4191_ _4191_/A _4191_/B VGND VGND VPWR VPWR _4192_/C sky130_fd_sc_hd__xnor2_2
XFILLER_79_261 VGND VGND VPWR VPWR sky130_fd_sc_hd__decap_3
XFILLER_67_467 VGND VGND VPWR VPWR sky130_fd_sc_hd__decap_3
XFILLER_94_253 VGND VGND VPWR VPWR sky130_fd_sc_hd__decap_3
XFILLER_94_231 VGND VGND VPWR VPWR sky130_fd_sc_hd__fill_2
XFILLER_27_309 VGND VGND VPWR VPWR sky130_fd_sc_hd__decap_3
XFILLER_39_169 VGND VGND VPWR VPWR sky130_fd_sc_hd__decap_3
XFILLER_54_139 VGND VGND VPWR VPWR sky130_fd_sc_hd__fill_1
XFILLER_82_459 VGND VGND VPWR VPWR sky130_fd_sc_hd__decap_3
X_6901_ _6971_/B _6890_/Y _6900_/X _6888_/X VGND VGND VPWR VPWR _6993_/A sky130_fd_sc_hd__a211o_4
XFILLER_94_297 VGND VGND VPWR VPWR sky130_fd_sc_hd__decap_3
X_6832_ _6760_/X _6831_/X _6832_/S VGND VGND VPWR VPWR _6832_/X sky130_fd_sc_hd__mux2_1
XFILLER_50_312 VGND VGND VPWR VPWR sky130_fd_sc_hd__decap_3
XFILLER_62_183 VGND VGND VPWR VPWR sky130_fd_sc_hd__decap_3
X_6763_ _3655_/A _6781_/A2 _6810_/B1 _6758_/C _6762_/X VGND VGND VPWR VPWR _6763_/X
+ sky130_fd_sc_hd__o221a_2
X_3975_ _3975_/A _3975_/B VGND VGND VPWR VPWR _3982_/A sky130_fd_sc_hd__xor2_2
XFILLER_31_570 VGND VGND VPWR VPWR sky130_fd_sc_hd__decap_3
X_6694_ _6411_/X _6417_/B _6431_/X _6545_/B _5266_/D _3501_/Y VGND VGND VPWR VPWR
+ _6694_/X sky130_fd_sc_hd__mux4_2
X_5714_ _5714_/A _5714_/B VGND VGND VPWR VPWR _5717_/B sky130_fd_sc_hd__xnor2_2
XTAP_TAPCELL_ROW_33_565 VGND VPWR sky130_fd_sc_hd__tapvpwrvgnd_1
XFILLER_40_18 VGND VGND VPWR VPWR sky130_fd_sc_hd__fill_1
X_5645_ _5645_/A _5654_/A VGND VGND VPWR VPWR _5645_/Y sky130_fd_sc_hd__nand2_2
XFILLER_40_29 VGND VGND VPWR VPWR sky130_fd_sc_hd__fill_2
XTAP_TAPCELL_ROW_79_1047 VGND VPWR sky130_fd_sc_hd__tapvpwrvgnd_1
X_5576_ _5695_/A _5680_/A _5576_/C _5576_/D VGND VGND VPWR VPWR _5692_/A sky130_fd_sc_hd__and4_2
X_4527_ _4527_/A _4811_/A VGND VGND VPWR VPWR _4529_/B sky130_fd_sc_hd__nand2_2
X_4458_ _4458_/A _4458_/B VGND VGND VPWR VPWR _4460_/B sky130_fd_sc_hd__xnor2_2
XFILLER_49_38 VGND VGND VPWR VPWR sky130_fd_sc_hd__decap_3
XFILLER_77_209 VGND VGND VPWR VPWR sky130_fd_sc_hd__decap_3
XFILLER_100_520 VGND VGND VPWR VPWR sky130_fd_sc_hd__decap_3
XFILLER_58_412 VGND VGND VPWR VPWR sky130_fd_sc_hd__fill_2
XFILLER_58_434 VGND VGND VPWR VPWR sky130_fd_sc_hd__decap_3
X_6128_ _6381_/D _6127_/X _6124_/A VGND VGND VPWR VPWR _6129_/B sky130_fd_sc_hd__o21a_2
X_4389_ _6105_/A _6212_/B VGND VGND VPWR VPWR _4389_/Y sky130_fd_sc_hd__nand2_2
XFILLER_98_592 VGND VGND VPWR VPWR sky130_fd_sc_hd__decap_3
XFILLER_100_542 VGND VGND VPWR VPWR sky130_fd_sc_hd__decap_3
XFILLER_85_220 VGND VGND VPWR VPWR sky130_fd_sc_hd__decap_3
XFILLER_85_231 VGND VGND VPWR VPWR sky130_fd_sc_hd__decap_3
XTAP_TAPCELL_ROW_69_941 VGND VPWR sky130_fd_sc_hd__tapvpwrvgnd_1
XTAP_TAPCELL_ROW_5_268 VGND VPWR sky130_fd_sc_hd__tapvpwrvgnd_1
XFILLER_100_586 VGND VGND VPWR VPWR sky130_fd_sc_hd__fill_2
XFILLER_73_415 VGND VGND VPWR VPWR sky130_fd_sc_hd__decap_3
X_6059_ _6353_/C _6336_/A VGND VGND VPWR VPWR _6332_/C sky130_fd_sc_hd__nand2b_2
XFILLER_45_128 VGND VGND VPWR VPWR sky130_fd_sc_hd__decap_3
XFILLER_60_109 VGND VGND VPWR VPWR sky130_fd_sc_hd__decap_3
XFILLER_14_548 VGND VGND VPWR VPWR sky130_fd_sc_hd__decap_3
XFILLER_26_386 VGND VGND VPWR VPWR sky130_fd_sc_hd__decap_3
XFILLER_41_301 VGND VGND VPWR VPWR sky130_fd_sc_hd__decap_3
XFILLER_53_183 VGND VGND VPWR VPWR sky130_fd_sc_hd__decap_3
XFILLER_81_492 VGND VGND VPWR VPWR sky130_fd_sc_hd__fill_2
XFILLER_14_74 VGND VGND VPWR VPWR sky130_fd_sc_hd__decap_3
XFILLER_22_592 VGND VGND VPWR VPWR sky130_fd_sc_hd__decap_3
XFILLER_5_279 VGND VGND VPWR VPWR sky130_fd_sc_hd__fill_1
XFILLER_68_209 VGND VGND VPWR VPWR sky130_fd_sc_hd__decap_3
XFILLER_96_507 VGND VGND VPWR VPWR sky130_fd_sc_hd__fill_2
XFILLER_39_60 VGND VGND VPWR VPWR sky130_fd_sc_hd__decap_3
XFILLER_1_496 VGND VGND VPWR VPWR sky130_fd_sc_hd__decap_3
XFILLER_76_242 VGND VGND VPWR VPWR sky130_fd_sc_hd__decap_3
XFILLER_76_253 VGND VGND VPWR VPWR sky130_fd_sc_hd__decap_3
XFILLER_36_128 VGND VGND VPWR VPWR sky130_fd_sc_hd__fill_2
XFILLER_76_297 VGND VGND VPWR VPWR sky130_fd_sc_hd__decap_3
XFILLER_91_234 VGND VGND VPWR VPWR sky130_fd_sc_hd__decap_3
XFILLER_17_353 VGND VGND VPWR VPWR sky130_fd_sc_hd__decap_3
XFILLER_44_150 VGND VGND VPWR VPWR sky130_fd_sc_hd__decap_3
XFILLER_55_92 VGND VGND VPWR VPWR sky130_fd_sc_hd__decap_3
XFILLER_32_334 VGND VGND VPWR VPWR sky130_fd_sc_hd__decap_3
X_3760_ _3760_/A _3760_/B _3760_/C VGND VGND VPWR VPWR _4155_/A sky130_fd_sc_hd__nand3_2
XTAP_TAPCELL_ROW_30_535 VGND VPWR sky130_fd_sc_hd__tapvpwrvgnd_1
X_5430_ _5426_/Y _5428_/X _5355_/B _5355_/Y VGND VGND VPWR VPWR _5433_/B sky130_fd_sc_hd__o211ai_4
X_3691_ _3707_/A _3707_/B _3707_/C VGND VGND VPWR VPWR _3708_/A sky130_fd_sc_hd__o21ai_2
XFILLER_65_3 VGND VGND VPWR VPWR sky130_fd_sc_hd__decap_3
X_5361_ _5361_/A _5361_/B _5398_/C _5490_/D VGND VGND VPWR VPWR _5361_/X sky130_fd_sc_hd__and4_2
XFILLER_99_312 VGND VGND VPWR VPWR sky130_fd_sc_hd__decap_3
X_5292_ _5292_/A _5345_/A _5292_/C VGND VGND VPWR VPWR _5296_/A sky130_fd_sc_hd__or3_4
X_4312_ _4139_/X _4207_/Y _4224_/Y _4254_/Y VGND VGND VPWR VPWR _4313_/D sky130_fd_sc_hd__a211o_2
XFILLER_4_290 VGND VGND VPWR VPWR sky130_fd_sc_hd__decap_3
X_4243_ _4243_/A _4243_/B _4243_/C VGND VGND VPWR VPWR _4370_/A sky130_fd_sc_hd__nand3_2
XFILLER_99_389 VGND VGND VPWR VPWR sky130_fd_sc_hd__decap_3
XFILLER_67_231 VGND VGND VPWR VPWR sky130_fd_sc_hd__decap_3
X_4174_ _4192_/A VGND VGND VPWR VPWR _4174_/Y sky130_fd_sc_hd__inv_2
XTAP_TAPCELL_ROW_66_911 VGND VPWR sky130_fd_sc_hd__tapvpwrvgnd_1
XTAP_TAPCELL_ROW_38_613 VGND VPWR sky130_fd_sc_hd__tapvpwrvgnd_1
XTAP_TAPCELL_ROW_2_238 VGND VPWR sky130_fd_sc_hd__tapvpwrvgnd_1
XFILLER_55_426 VGND VGND VPWR VPWR sky130_fd_sc_hd__decap_3
XFILLER_82_223 VGND VGND VPWR VPWR sky130_fd_sc_hd__decap_3
XFILLER_95_595 VGND VGND VPWR VPWR sky130_fd_sc_hd__decap_3
XFILLER_70_418 VGND VGND VPWR VPWR sky130_fd_sc_hd__fill_2
XFILLER_82_256 VGND VGND VPWR VPWR sky130_fd_sc_hd__decap_3
XFILLER_82_278 VGND VGND VPWR VPWR sky130_fd_sc_hd__decap_3
XFILLER_35_172 VGND VGND VPWR VPWR sky130_fd_sc_hd__decap_3
XFILLER_63_470 VGND VGND VPWR VPWR sky130_fd_sc_hd__decap_3
XFILLER_23_334 VGND VGND VPWR VPWR sky130_fd_sc_hd__fill_2
X_6815_ _6744_/X _6814_/X _6939_/S VGND VGND VPWR VPWR _6815_/X sky130_fd_sc_hd__mux2_1
XFILLER_11_529 VGND VGND VPWR VPWR sky130_fd_sc_hd__decap_3
XFILLER_51_17 VGND VGND VPWR VPWR sky130_fd_sc_hd__decap_3
X_6746_ _6746_/A _6746_/B VGND VGND VPWR VPWR _6746_/X sky130_fd_sc_hd__or2_2
XFILLER_50_186 VGND VGND VPWR VPWR sky130_fd_sc_hd__decap_3
XFILLER_50_197 VGND VGND VPWR VPWR sky130_fd_sc_hd__decap_3
X_3958_ _3955_/X _3958_/B VGND VGND VPWR VPWR _4032_/B sky130_fd_sc_hd__and2b_2
X_6677_ _6638_/A _6676_/X _6675_/X VGND VGND VPWR VPWR _6677_/Y sky130_fd_sc_hd__a21oi_2
X_3889_ _3955_/A _3996_/B _6175_/A _6178_/A VGND VGND VPWR VPWR _3897_/A sky130_fd_sc_hd__and4_2
X_5628_ _5588_/A _5778_/C _5588_/C _5588_/D VGND VGND VPWR VPWR _5629_/C sky130_fd_sc_hd__a22o_2
X_5559_ _5513_/A _5508_/B _5473_/Y VGND VGND VPWR VPWR _5560_/C sky130_fd_sc_hd__o21ba_2
Xfanout520 _5306_/A VGND VGND VPWR VPWR _5312_/B2 sky130_fd_sc_hd__clkdlybuf4s25_1
Xfanout531 input29/X VGND VGND VPWR VPWR wire532/A sky130_fd_sc_hd__dlymetal6s2s_1
XFILLER_58_242 VGND VGND VPWR VPWR sky130_fd_sc_hd__decap_3
Xfanout553 _4634_/B VGND VGND VPWR VPWR _3550_/A sky130_fd_sc_hd__dlymetal6s2s_1
Xfanout564 _5477_/A VGND VGND VPWR VPWR _5779_/A sky130_fd_sc_hd__buf_4
Xfanout575 input25/X VGND VGND VPWR VPWR _6337_/A sky130_fd_sc_hd__clkdlybuf4s25_1
XFILLER_58_253 VGND VGND VPWR VPWR sky130_fd_sc_hd__decap_3
Xfanout586 _6004_/B VGND VGND VPWR VPWR _3993_/A1 sky130_fd_sc_hd__clkdlybuf4s25_1
XFILLER_46_448 VGND VGND VPWR VPWR sky130_fd_sc_hd__decap_3
XFILLER_58_286 VGND VGND VPWR VPWR sky130_fd_sc_hd__decap_3
XFILLER_73_212 VGND VGND VPWR VPWR sky130_fd_sc_hd__decap_3
XFILLER_86_595 VGND VGND VPWR VPWR sky130_fd_sc_hd__decap_3
XFILLER_33_109 VGND VGND VPWR VPWR sky130_fd_sc_hd__decap_3
XFILLER_61_418 VGND VGND VPWR VPWR sky130_fd_sc_hd__decap_3
XFILLER_73_256 VGND VGND VPWR VPWR sky130_fd_sc_hd__decap_3
XFILLER_92_13 VGND VGND VPWR VPWR sky130_fd_sc_hd__fill_1
XFILLER_14_312 VGND VGND VPWR VPWR sky130_fd_sc_hd__decap_3
XFILLER_14_334 VGND VGND VPWR VPWR sky130_fd_sc_hd__decap_3
XFILLER_41_120 VGND VGND VPWR VPWR sky130_fd_sc_hd__decap_3
XTAP_TAPCELL_ROW_72_969 VGND VPWR sky130_fd_sc_hd__tapvpwrvgnd_1
XFILLER_41_175 VGND VGND VPWR VPWR sky130_fd_sc_hd__fill_1
XFILLER_6_544 VGND VGND VPWR VPWR sky130_fd_sc_hd__decap_3
XFILLER_6_555 VGND VGND VPWR VPWR sky130_fd_sc_hd__fill_1
XFILLER_6_577 VGND VGND VPWR VPWR sky130_fd_sc_hd__fill_2
XFILLER_96_315 VGND VGND VPWR VPWR sky130_fd_sc_hd__decap_3
XFILLER_49_231 VGND VGND VPWR VPWR sky130_fd_sc_hd__decap_3
XFILLER_77_551 VGND VGND VPWR VPWR sky130_fd_sc_hd__fill_2
XFILLER_49_264 VGND VGND VPWR VPWR sky130_fd_sc_hd__decap_3
XFILLER_77_573 VGND VGND VPWR VPWR sky130_fd_sc_hd__decap_3
XFILLER_37_426 VGND VGND VPWR VPWR sky130_fd_sc_hd__fill_1
XFILLER_64_212 VGND VGND VPWR VPWR sky130_fd_sc_hd__decap_3
XFILLER_64_245 VGND VGND VPWR VPWR sky130_fd_sc_hd__decap_3
XFILLER_64_256 VGND VGND VPWR VPWR sky130_fd_sc_hd__decap_3
XFILLER_52_418 VGND VGND VPWR VPWR sky130_fd_sc_hd__fill_2
XFILLER_52_429 VGND VGND VPWR VPWR sky130_fd_sc_hd__decap_3
X_4930_ _4687_/C _5018_/B _4688_/A _4686_/Y VGND VGND VPWR VPWR _4931_/B sky130_fd_sc_hd__o2bb2a_2
XFILLER_17_183 VGND VGND VPWR VPWR sky130_fd_sc_hd__fill_2
XFILLER_32_131 VGND VGND VPWR VPWR sky130_fd_sc_hd__decap_3
X_4861_ _4859_/A _4859_/C _4859_/B VGND VGND VPWR VPWR _4861_/Y sky130_fd_sc_hd__a21oi_2
XFILLER_32_153 VGND VGND VPWR VPWR sky130_fd_sc_hd__fill_1
X_6600_ _6381_/A _6215_/Y _6234_/X _6932_/B _6599_/Y VGND VGND VPWR VPWR _6600_/Y
+ sky130_fd_sc_hd__a311oi_2
X_3812_ _3812_/A _6024_/A VGND VGND VPWR VPWR _3817_/A sky130_fd_sc_hd__nand2_2
XTAP_TAPCELL_ROW_43_671 VGND VPWR sky130_fd_sc_hd__tapvpwrvgnd_1
X_4792_ _5068_/A _4979_/A _4978_/C _4978_/D VGND VGND VPWR VPWR _4792_/X sky130_fd_sc_hd__and4_2
XTAP_TAPCELL_ROW_15_373 VGND VPWR sky130_fd_sc_hd__tapvpwrvgnd_1
XFILLER_20_359 VGND VGND VPWR VPWR sky130_fd_sc_hd__decap_3
X_6531_ _6897_/S _6657_/B VGND VGND VPWR VPWR _6532_/A sky130_fd_sc_hd__nor2_2
X_3743_ _3743_/A _3743_/B VGND VGND VPWR VPWR _4134_/A sky130_fd_sc_hd__xnor2_2
X_6462_ _6455_/X _6461_/X _6462_/S VGND VGND VPWR VPWR _6462_/X sky130_fd_sc_hd__mux2_1
X_3674_ _3674_/A _3674_/B _3674_/C VGND VGND VPWR VPWR _3675_/A sky130_fd_sc_hd__nor3_2
XFILLER_9_393 VGND VGND VPWR VPWR sky130_fd_sc_hd__fill_1
X_6393_ _6897_/S _6393_/B VGND VGND VPWR VPWR _6393_/Y sky130_fd_sc_hd__nor2_2
Xoutput101 _6987_/A VGND VGND VPWR VPWR result[8] sky130_fd_sc_hd__clkbuf_2
X_5413_ _5414_/A _5414_/B _5413_/C VGND VGND VPWR VPWR _5413_/X sky130_fd_sc_hd__and3_2
XTAP_TAPCELL_ROW_76_1017 VGND VPWR sky130_fd_sc_hd__tapvpwrvgnd_1
X_5344_ _5344_/A _5344_/B VGND VGND VPWR VPWR _5345_/C sky130_fd_sc_hd__xnor2_2
XFILLER_87_304 VGND VGND VPWR VPWR sky130_fd_sc_hd__decap_3
X_5275_ _5275_/A _5275_/B _5398_/C _5490_/D VGND VGND VPWR VPWR _5278_/A sky130_fd_sc_hd__and4_2
XFILLER_87_348 VGND VGND VPWR VPWR sky130_fd_sc_hd__decap_3
X_4226_ _4135_/A _4135_/B _4135_/C VGND VGND VPWR VPWR _4228_/C sky130_fd_sc_hd__o21ai_2
XFILLER_28_415 VGND VGND VPWR VPWR sky130_fd_sc_hd__decap_3
XFILLER_68_551 VGND VGND VPWR VPWR sky130_fd_sc_hd__fill_1
X_4157_ _4524_/A _4524_/B _4517_/C _4517_/D VGND VGND VPWR VPWR _4157_/X sky130_fd_sc_hd__and4_2
XFILLER_55_201 VGND VGND VPWR VPWR sky130_fd_sc_hd__decap_3
XTAP_TAPCELL_ROW_87_1135 VGND VPWR sky130_fd_sc_hd__tapvpwrvgnd_1
XFILLER_83_576 VGND VGND VPWR VPWR sky130_fd_sc_hd__fill_1
X_4088_ _4593_/B _4088_/B _4088_/C _6077_/A VGND VGND VPWR VPWR _4346_/A sky130_fd_sc_hd__and4_2
XFILLER_36_470 VGND VGND VPWR VPWR sky130_fd_sc_hd__decap_3
XFILLER_70_215 VGND VGND VPWR VPWR sky130_fd_sc_hd__decap_3
XFILLER_51_440 VGND VGND VPWR VPWR sky130_fd_sc_hd__fill_1
XFILLER_70_259 VGND VGND VPWR VPWR sky130_fd_sc_hd__decap_3
XFILLER_11_315 VGND VGND VPWR VPWR sky130_fd_sc_hd__decap_3
XFILLER_11_337 VGND VGND VPWR VPWR sky130_fd_sc_hd__decap_3
XFILLER_23_197 VGND VGND VPWR VPWR sky130_fd_sc_hd__decap_3
X_6729_ _6638_/A _6728_/X _6308_/X VGND VGND VPWR VPWR _6729_/Y sky130_fd_sc_hd__a21oi_2
XTAP_TAPCELL_ROW_98_1242 VGND VPWR sky130_fd_sc_hd__tapvpwrvgnd_1
XFILLER_11_42 VGND VGND VPWR VPWR sky130_fd_sc_hd__fill_2
XFILLER_78_315 VGND VGND VPWR VPWR sky130_fd_sc_hd__decap_3
XFILLER_87_35 VGND VGND VPWR VPWR sky130_fd_sc_hd__decap_3
XFILLER_93_318 VGND VGND VPWR VPWR sky130_fd_sc_hd__decap_3
Xfanout361 _6938_/S1 VGND VGND VPWR VPWR _6478_/S sky130_fd_sc_hd__clkbuf_4
Xfanout383 _5976_/C VGND VGND VPWR VPWR _6098_/A sky130_fd_sc_hd__clkdlybuf4s25_1
XFILLER_59_595 VGND VGND VPWR VPWR sky130_fd_sc_hd__decap_3
XFILLER_74_510 VGND VGND VPWR VPWR sky130_fd_sc_hd__fill_1
XFILLER_86_392 VGND VGND VPWR VPWR sky130_fd_sc_hd__decap_3
Xfanout394 _3608_/A VGND VGND VPWR VPWR _4659_/A sky130_fd_sc_hd__clkdlybuf4s25_1
XFILLER_46_234 VGND VGND VPWR VPWR sky130_fd_sc_hd__decap_3
XFILLER_74_565 VGND VGND VPWR VPWR sky130_fd_sc_hd__decap_3
XFILLER_27_470 VGND VGND VPWR VPWR sky130_fd_sc_hd__decap_3
XFILLER_36_50 VGND VGND VPWR VPWR sky130_fd_sc_hd__decap_3
XFILLER_61_215 VGND VGND VPWR VPWR sky130_fd_sc_hd__fill_1
XFILLER_36_94 VGND VGND VPWR VPWR sky130_fd_sc_hd__decap_3
XFILLER_61_237 VGND VGND VPWR VPWR sky130_fd_sc_hd__decap_3
XFILLER_61_259 VGND VGND VPWR VPWR sky130_fd_sc_hd__decap_3
XFILLER_14_197 VGND VGND VPWR VPWR sky130_fd_sc_hd__decap_3
XFILLER_52_71 VGND VGND VPWR VPWR sky130_fd_sc_hd__decap_3
XTAP_TAPCELL_ROW_40_641 VGND VPWR sky130_fd_sc_hd__tapvpwrvgnd_1
XTAP_TAPCELL_ROW_12_343 VGND VPWR sky130_fd_sc_hd__tapvpwrvgnd_1
Xinput14 A[21] VGND VGND VPWR VPWR _6016_/B sky130_fd_sc_hd__clkbuf_2
Xinput36 B[12] VGND VGND VPWR VPWR input36/X sky130_fd_sc_hd__buf_4
Xinput25 A[31] VGND VGND VPWR VPWR input25/X sky130_fd_sc_hd__clkdlybuf4s25_1
Xinput58 B[3] VGND VGND VPWR VPWR input58/X sky130_fd_sc_hd__clkbuf_2
Xinput47 B[22] VGND VGND VPWR VPWR input47/X sky130_fd_sc_hd__clkdlybuf4s25_1
XFILLER_6_363 VGND VGND VPWR VPWR sky130_fd_sc_hd__fill_1
XFILLER_69_337 VGND VGND VPWR VPWR sky130_fd_sc_hd__fill_2
X_5060_ _5045_/A _5045_/C _5045_/B VGND VGND VPWR VPWR _5060_/Y sky130_fd_sc_hd__a21oi_2
XFILLER_28_3 VGND VGND VPWR VPWR sky130_fd_sc_hd__decap_3
X_4011_ _6008_/B _6187_/A _4482_/B _6276_/A VGND VGND VPWR VPWR _4013_/A sky130_fd_sc_hd__and4_2
XFILLER_37_212 VGND VGND VPWR VPWR sky130_fd_sc_hd__decap_3
XFILLER_77_381 VGND VGND VPWR VPWR sky130_fd_sc_hd__decap_3
XFILLER_65_554 VGND VGND VPWR VPWR sky130_fd_sc_hd__decap_3
XFILLER_18_470 VGND VGND VPWR VPWR sky130_fd_sc_hd__decap_3
XFILLER_25_429 VGND VGND VPWR VPWR sky130_fd_sc_hd__decap_3
XFILLER_52_215 VGND VGND VPWR VPWR sky130_fd_sc_hd__decap_3
XFILLER_80_502 VGND VGND VPWR VPWR sky130_fd_sc_hd__decap_3
XFILLER_80_524 VGND VGND VPWR VPWR sky130_fd_sc_hd__decap_3
XFILLER_92_362 VGND VGND VPWR VPWR sky130_fd_sc_hd__fill_2
X_5962_ _5962_/A _5962_/B VGND VGND VPWR VPWR _5963_/B sky130_fd_sc_hd__xnor2_2
XFILLER_18_492 VGND VGND VPWR VPWR sky130_fd_sc_hd__decap_3
XFILLER_52_237 VGND VGND VPWR VPWR sky130_fd_sc_hd__decap_3
XFILLER_52_259 VGND VGND VPWR VPWR sky130_fd_sc_hd__fill_2
XFILLER_80_546 VGND VGND VPWR VPWR sky130_fd_sc_hd__decap_3
X_4913_ _4854_/Y _4875_/X _4911_/Y _4912_/X VGND VGND VPWR VPWR _4913_/X sky130_fd_sc_hd__o211a_2
XFILLER_33_440 VGND VGND VPWR VPWR sky130_fd_sc_hd__decap_3
X_5893_ _5892_/B _5892_/C _5882_/Y VGND VGND VPWR VPWR _5893_/Y sky130_fd_sc_hd__a21boi_2
XFILLER_33_495 VGND VGND VPWR VPWR sky130_fd_sc_hd__fill_1
X_4844_ _4844_/A _4844_/B VGND VGND VPWR VPWR _4845_/C sky130_fd_sc_hd__xnor2_2
XTAP_TAPCELL_ROW_82_1076 VGND VPWR sky130_fd_sc_hd__tapvpwrvgnd_1
XFILLER_20_134 VGND VGND VPWR VPWR sky130_fd_sc_hd__decap_3
X_4775_ _4775_/A _4775_/B _4775_/C VGND VGND VPWR VPWR _4775_/X sky130_fd_sc_hd__and3_2
X_6514_ _6514_/A _6514_/B VGND VGND VPWR VPWR _6515_/B sky130_fd_sc_hd__and2_2
X_3726_ _3710_/Y _3725_/X _3705_/Y _3706_/X VGND VGND VPWR VPWR _3730_/A sky130_fd_sc_hd__a211o_2
X_6445_ _6125_/Y _6717_/B _6891_/B1 _5799_/A VGND VGND VPWR VPWR _6445_/X sky130_fd_sc_hd__o22a_2
X_3657_ _3678_/A _3656_/Y _3657_/C _6014_/C VGND VGND VPWR VPWR _3678_/B sky130_fd_sc_hd__and4bb_2
X_6376_ _6353_/C input67/X _6332_/B _6375_/Y _6338_/A VGND VGND VPWR VPWR _6376_/X
+ sky130_fd_sc_hd__a2111o_2
X_3588_ _5983_/D _6024_/A _3588_/C _3588_/D VGND VGND VPWR VPWR _3590_/B sky130_fd_sc_hd__and4_2
X_5327_ _5327_/A _5327_/B _5327_/C VGND VGND VPWR VPWR _5334_/A sky130_fd_sc_hd__and3_2
XTAP_TAPCELL_ROW_93_1194 VGND VPWR sky130_fd_sc_hd__tapvpwrvgnd_1
XFILLER_0_539 VGND VGND VPWR VPWR sky130_fd_sc_hd__decap_3
XFILLER_87_156 VGND VGND VPWR VPWR sky130_fd_sc_hd__decap_3
X_5258_ _5180_/A _5184_/A _5258_/B1 _5101_/X VGND VGND VPWR VPWR _5263_/B sky130_fd_sc_hd__a211oi_2
XFILLER_87_189 VGND VGND VPWR VPWR sky130_fd_sc_hd__decap_3
X_5189_ _5321_/B _5188_/C _5290_/C _5300_/B VGND VGND VPWR VPWR _5190_/B sky130_fd_sc_hd__a22o_2
X_4209_ _4209_/A _4209_/B VGND VGND VPWR VPWR _4220_/A sky130_fd_sc_hd__xnor2_2
XFILLER_28_245 VGND VGND VPWR VPWR sky130_fd_sc_hd__fill_1
XFILLER_56_543 VGND VGND VPWR VPWR sky130_fd_sc_hd__decap_3
XFILLER_56_565 VGND VGND VPWR VPWR sky130_fd_sc_hd__decap_3
XFILLER_56_587 VGND VGND VPWR VPWR sky130_fd_sc_hd__fill_1
XFILLER_73_37 VGND VGND VPWR VPWR sky130_fd_sc_hd__fill_2
XFILLER_83_362 VGND VGND VPWR VPWR sky130_fd_sc_hd__decap_3
XFILLER_43_237 VGND VGND VPWR VPWR sky130_fd_sc_hd__decap_3
XFILLER_24_462 VGND VGND VPWR VPWR sky130_fd_sc_hd__decap_3
XTAP_TAPCELL_ROW_54_788 VGND VPWR sky130_fd_sc_hd__tapvpwrvgnd_1
XFILLER_51_281 VGND VGND VPWR VPWR sky130_fd_sc_hd__decap_3
XFILLER_11_145 VGND VGND VPWR VPWR sky130_fd_sc_hd__decap_3
XFILLER_7_105 VGND VGND VPWR VPWR sky130_fd_sc_hd__decap_3
XFILLER_22_41 VGND VGND VPWR VPWR sky130_fd_sc_hd__decap_3
XFILLER_22_63 VGND VGND VPWR VPWR sky130_fd_sc_hd__decap_3
XFILLER_7_149 VGND VGND VPWR VPWR sky130_fd_sc_hd__decap_3
XFILLER_78_101 VGND VGND VPWR VPWR sky130_fd_sc_hd__decap_3
XFILLER_78_134 VGND VGND VPWR VPWR sky130_fd_sc_hd__decap_3
XFILLER_66_318 VGND VGND VPWR VPWR sky130_fd_sc_hd__decap_3
XFILLER_78_156 VGND VGND VPWR VPWR sky130_fd_sc_hd__decap_3
XFILLER_19_223 VGND VGND VPWR VPWR sky130_fd_sc_hd__fill_1
XFILLER_59_370 VGND VGND VPWR VPWR sky130_fd_sc_hd__decap_3
Xfanout180 _3499_/Y VGND VGND VPWR VPWR _6764_/A sky130_fd_sc_hd__clkdlybuf4s25_1
XFILLER_93_159 VGND VGND VPWR VPWR sky130_fd_sc_hd__decap_3
XFILLER_19_278 VGND VGND VPWR VPWR sky130_fd_sc_hd__fill_2
XFILLER_19_289 VGND VGND VPWR VPWR sky130_fd_sc_hd__decap_3
XFILLER_34_215 VGND VGND VPWR VPWR sky130_fd_sc_hd__decap_3
XFILLER_47_576 VGND VGND VPWR VPWR sky130_fd_sc_hd__fill_2
XFILLER_47_93 VGND VGND VPWR VPWR sky130_fd_sc_hd__decap_3
XFILLER_62_502 VGND VGND VPWR VPWR sky130_fd_sc_hd__fill_2
XFILLER_62_546 VGND VGND VPWR VPWR sky130_fd_sc_hd__decap_3
XFILLER_34_259 VGND VGND VPWR VPWR sky130_fd_sc_hd__fill_1
XFILLER_30_421 VGND VGND VPWR VPWR sky130_fd_sc_hd__decap_3
XFILLER_63_81 VGND VGND VPWR VPWR sky130_fd_sc_hd__decap_3
XFILLER_30_454 VGND VGND VPWR VPWR sky130_fd_sc_hd__decap_3
XFILLER_8_32 VGND VGND VPWR VPWR sky130_fd_sc_hd__decap_3
X_4560_ _4441_/X _4453_/Y _4499_/X _4560_/C1 VGND VGND VPWR VPWR _4560_/Y sky130_fd_sc_hd__o211ai_2
X_4491_ _4491_/A _4491_/B _4491_/C VGND VGND VPWR VPWR _4491_/Y sky130_fd_sc_hd__nand3_2
X_3511_ _4551_/A _4432_/A _6929_/A _3869_/D VGND VGND VPWR VPWR _3511_/X sky130_fd_sc_hd__and4_2
X_6230_ _6381_/C _6227_/B _6227_/C _6229_/B _6218_/Y VGND VGND VPWR VPWR _6231_/C
+ sky130_fd_sc_hd__a311o_2
X_6161_ _6161_/A _6161_/B VGND VGND VPWR VPWR _6795_/A sky130_fd_sc_hd__or2_2
XFILLER_69_134 VGND VGND VPWR VPWR sky130_fd_sc_hd__decap_3
X_5112_ _5113_/A _5187_/A VGND VGND VPWR VPWR _5112_/Y sky130_fd_sc_hd__nor2_2
XFILLER_97_443 VGND VGND VPWR VPWR sky130_fd_sc_hd__decap_3
XFILLER_57_307 VGND VGND VPWR VPWR sky130_fd_sc_hd__decap_3
XFILLER_69_156 VGND VGND VPWR VPWR sky130_fd_sc_hd__decap_3
Xload_slew542 fanout541/X VGND VGND VPWR VPWR _4636_/C sky130_fd_sc_hd__clkbuf_4
X_6092_ _6095_/A VGND VGND VPWR VPWR _6161_/A sky130_fd_sc_hd__inv_2
XFILLER_38_510 VGND VGND VPWR VPWR sky130_fd_sc_hd__decap_3
XFILLER_69_178 VGND VGND VPWR VPWR sky130_fd_sc_hd__decap_3
XFILLER_84_137 VGND VGND VPWR VPWR sky130_fd_sc_hd__decap_3
Xload_slew597 _5277_/C VGND VGND VPWR VPWR _5054_/A sky130_fd_sc_hd__buf_4
X_5043_ _4970_/A _4970_/C _4970_/B VGND VGND VPWR VPWR _5045_/C sky130_fd_sc_hd__a21o_2
XFILLER_97_487 VGND VGND VPWR VPWR sky130_fd_sc_hd__decap_3
XFILLER_65_340 VGND VGND VPWR VPWR sky130_fd_sc_hd__decap_3
XFILLER_84_159 VGND VGND VPWR VPWR sky130_fd_sc_hd__decap_3
XFILLER_25_237 VGND VGND VPWR VPWR sky130_fd_sc_hd__fill_1
XFILLER_53_535 VGND VGND VPWR VPWR sky130_fd_sc_hd__decap_3
X_6994_ _6994_/A _6994_/B _6994_/C wire104/X VGND VGND VPWR VPWR _6995_/D sky130_fd_sc_hd__or4b_4
XFILLER_80_354 VGND VGND VPWR VPWR sky130_fd_sc_hd__decap_3
XFILLER_80_365 VGND VGND VPWR VPWR sky130_fd_sc_hd__decap_3
X_5945_ _6187_/B _5947_/A _3855_/A _3853_/A VGND VGND VPWR VPWR _5952_/A sky130_fd_sc_hd__a31o_2
XFILLER_33_281 VGND VGND VPWR VPWR sky130_fd_sc_hd__fill_2
XFILLER_80_398 VGND VGND VPWR VPWR sky130_fd_sc_hd__decap_3
X_5876_ _5876_/A _5876_/B VGND VGND VPWR VPWR _6806_/B sky130_fd_sc_hd__nand2_2
X_4827_ _4827_/A _4827_/B VGND VGND VPWR VPWR _4828_/C sky130_fd_sc_hd__xnor2_2
Xrebuffer714 _4643_/X VGND VGND VPWR VPWR _4851_/C1 sky130_fd_sc_hd__buf_2
Xrebuffer703 _5008_/B VGND VGND VPWR VPWR _5012_/B sky130_fd_sc_hd__buf_4
Xrebuffer725 _5941_/X VGND VGND VPWR VPWR _6058_/A2 sky130_fd_sc_hd__buf_2
Xrebuffer736 _5275_/B VGND VGND VPWR VPWR _4966_/A1 sky130_fd_sc_hd__buf_2
Xrebuffer747 _5053_/D VGND VGND VPWR VPWR _4958_/A sky130_fd_sc_hd__buf_2
Xrebuffer758 _5826_/X VGND VGND VPWR VPWR _5828_/B1 sky130_fd_sc_hd__buf_4
X_4758_ _4758_/A _4963_/A VGND VGND VPWR VPWR _4760_/B sky130_fd_sc_hd__nand2_2
XTAP_TAPCELL_ROW_95_1212 VGND VPWR sky130_fd_sc_hd__tapvpwrvgnd_1
X_4689_ _4689_/A _4689_/B VGND VGND VPWR VPWR _4924_/B sky130_fd_sc_hd__xnor2_2
X_3709_ _3724_/A _3724_/B _3724_/C VGND VGND VPWR VPWR _3709_/X sky130_fd_sc_hd__o21a_2
X_6428_ _6426_/X _6427_/Y _6434_/S VGND VGND VPWR VPWR _6428_/X sky130_fd_sc_hd__mux2_1
XFILLER_68_48 VGND VGND VPWR VPWR sky130_fd_sc_hd__fill_2
XFILLER_88_421 VGND VGND VPWR VPWR sky130_fd_sc_hd__decap_3
X_6359_ _6244_/B _6152_/A _6401_/S VGND VGND VPWR VPWR _6359_/X sky130_fd_sc_hd__mux2_1
XFILLER_88_465 VGND VGND VPWR VPWR sky130_fd_sc_hd__decap_3
XTAP_TAPCELL_ROW_59_836 VGND VPWR sky130_fd_sc_hd__tapvpwrvgnd_1
XFILLER_84_25 VGND VGND VPWR VPWR sky130_fd_sc_hd__decap_3
XFILLER_90_129 VGND VGND VPWR VPWR sky130_fd_sc_hd__fill_2
XFILLER_83_192 VGND VGND VPWR VPWR sky130_fd_sc_hd__decap_3
XFILLER_16_259 VGND VGND VPWR VPWR sky130_fd_sc_hd__fill_1
XFILLER_12_421 VGND VGND VPWR VPWR sky130_fd_sc_hd__decap_3
XFILLER_71_387 VGND VGND VPWR VPWR sky130_fd_sc_hd__decap_3
XFILLER_12_454 VGND VGND VPWR VPWR sky130_fd_sc_hd__decap_3
XFILLER_8_414 VGND VGND VPWR VPWR sky130_fd_sc_hd__decap_3
XFILLER_8_436 VGND VGND VPWR VPWR sky130_fd_sc_hd__fill_1
XPHY_EDGE_ROW_49_Left_150 VGND VGND VPWR VPWR sky130_fd_sc_hd__decap_3
XFILLER_12_498 VGND VGND VPWR VPWR sky130_fd_sc_hd__decap_3
XFILLER_8_458 VGND VGND VPWR VPWR sky130_fd_sc_hd__decap_3
XFILLER_79_432 VGND VGND VPWR VPWR sky130_fd_sc_hd__decap_3
XFILLER_79_476 VGND VGND VPWR VPWR sky130_fd_sc_hd__decap_3
XFILLER_94_402 VGND VGND VPWR VPWR sky130_fd_sc_hd__decap_3
XFILLER_39_318 VGND VGND VPWR VPWR sky130_fd_sc_hd__fill_2
XFILLER_66_104 VGND VGND VPWR VPWR sky130_fd_sc_hd__fill_1
XFILLER_94_424 VGND VGND VPWR VPWR sky130_fd_sc_hd__decap_3
XFILLER_12_6 VGND VGND VPWR VPWR sky130_fd_sc_hd__decap_3
XFILLER_66_159 VGND VGND VPWR VPWR sky130_fd_sc_hd__decap_3
XFILLER_94_457 VGND VGND VPWR VPWR sky130_fd_sc_hd__decap_3
XFILLER_35_502 VGND VGND VPWR VPWR sky130_fd_sc_hd__fill_2
XFILLER_47_351 VGND VGND VPWR VPWR sky130_fd_sc_hd__fill_1
XFILLER_35_546 VGND VGND VPWR VPWR sky130_fd_sc_hd__fill_1
XFILLER_62_321 VGND VGND VPWR VPWR sky130_fd_sc_hd__decap_3
XFILLER_74_192 VGND VGND VPWR VPWR sky130_fd_sc_hd__decap_3
X_3991_ _6073_/A _3991_/B VGND VGND VPWR VPWR _5994_/A sky130_fd_sc_hd__nand2_2
XFILLER_22_229 VGND VGND VPWR VPWR sky130_fd_sc_hd__decap_3
X_5730_ _5779_/A _5727_/B _5729_/B _5726_/X VGND VGND VPWR VPWR _5732_/C sky130_fd_sc_hd__a31o_2
XFILLER_30_240 VGND VGND VPWR VPWR sky130_fd_sc_hd__decap_3
X_5661_ _6123_/A _5695_/A _5695_/C _5725_/C VGND VGND VPWR VPWR _5664_/A sky130_fd_sc_hd__nand4_2
X_5592_ _5659_/A _5777_/B VGND VGND VPWR VPWR _5594_/B sky130_fd_sc_hd__nand2_2
X_4612_ _4612_/A _4612_/B _4612_/C VGND VGND VPWR VPWR _4612_/X sky130_fd_sc_hd__and3_2
X_4543_ _4544_/A _4544_/B _4544_/C VGND VGND VPWR VPWR _4549_/B sky130_fd_sc_hd__nor3_2
Xmax_cap111 _5888_/Y VGND VGND VPWR VPWR _5891_/C1 sky130_fd_sc_hd__clkbuf_2
XFILLER_89_218 VGND VGND VPWR VPWR sky130_fd_sc_hd__decap_3
X_6213_ _6213_/A _6213_/B VGND VGND VPWR VPWR _6383_/D sky130_fd_sc_hd__nor2_2
X_4474_ _4368_/A _4367_/C _4367_/B VGND VGND VPWR VPWR _4491_/B sky130_fd_sc_hd__a21o_2
XFILLER_85_402 VGND VGND VPWR VPWR sky130_fd_sc_hd__decap_3
X_6144_ _6144_/A _6144_/B VGND VGND VPWR VPWR _6145_/B sky130_fd_sc_hd__nor2_2
XTAP_TAPCELL_ROW_90_1164 VGND VPWR sky130_fd_sc_hd__tapvpwrvgnd_1
XFILLER_57_126 VGND VGND VPWR VPWR sky130_fd_sc_hd__decap_3
Xload_slew372 _6090_/A VGND VGND VPWR VPWR _5983_/A sky130_fd_sc_hd__buf_2
Xload_slew350 _4985_/B VGND VGND VPWR VPWR _4782_/B sky130_fd_sc_hd__buf_4
X_6075_ _6077_/A _6263_/B VGND VGND VPWR VPWR _6170_/A sky130_fd_sc_hd__nand2_2
XFILLER_57_159 VGND VGND VPWR VPWR sky130_fd_sc_hd__decap_3
X_5026_ _5027_/A _5027_/B VGND VGND VPWR VPWR _5084_/B sky130_fd_sc_hd__nor2_2
XTAP_TAPCELL_ROW_56_806 VGND VPWR sky130_fd_sc_hd__tapvpwrvgnd_1
XTAP_TAPCELL_ROW_28_508 VGND VPWR sky130_fd_sc_hd__tapvpwrvgnd_1
XFILLER_26_524 VGND VGND VPWR VPWR sky130_fd_sc_hd__fill_1
XFILLER_65_181 VGND VGND VPWR VPWR sky130_fd_sc_hd__decap_3
XFILLER_26_557 VGND VGND VPWR VPWR sky130_fd_sc_hd__decap_3
XFILLER_41_505 VGND VGND VPWR VPWR sky130_fd_sc_hd__decap_3
X_6977_ _6977_/A _6977_/B VGND VGND VPWR VPWR _6977_/Y sky130_fd_sc_hd__nand2_2
X_5928_ _5931_/A _5931_/B _5931_/C VGND VGND VPWR VPWR _6921_/A sky130_fd_sc_hd__a21oi_2
XTAP_TAPCELL_ROW_64_894 VGND VPWR sky130_fd_sc_hd__tapvpwrvgnd_1
XTAP_TAPCELL_ROW_36_596 VGND VPWR sky130_fd_sc_hd__tapvpwrvgnd_1
XFILLER_21_251 VGND VGND VPWR VPWR sky130_fd_sc_hd__decap_3
X_5859_ _5466_/B _5466_/Y _5848_/Y _5858_/X VGND VGND VPWR VPWR _5862_/A sky130_fd_sc_hd__a211o_4
XFILLER_21_284 VGND VGND VPWR VPWR sky130_fd_sc_hd__decap_3
XFILLER_0_111 VGND VGND VPWR VPWR sky130_fd_sc_hd__fill_1
XFILLER_0_144 VGND VGND VPWR VPWR sky130_fd_sc_hd__fill_1
XFILLER_88_251 VGND VGND VPWR VPWR sky130_fd_sc_hd__fill_1
XFILLER_0_166 VGND VGND VPWR VPWR sky130_fd_sc_hd__fill_2
XFILLER_48_115 VGND VGND VPWR VPWR sky130_fd_sc_hd__decap_3
XFILLER_88_273 VGND VGND VPWR VPWR sky130_fd_sc_hd__decap_3
XTAP_TAPCELL_ROW_8_299 VGND VPWR sky130_fd_sc_hd__tapvpwrvgnd_1
XFILLER_48_137 VGND VGND VPWR VPWR sky130_fd_sc_hd__decap_3
XFILLER_28_73 VGND VGND VPWR VPWR sky130_fd_sc_hd__decap_3
XFILLER_56_192 VGND VGND VPWR VPWR sky130_fd_sc_hd__decap_3
XFILLER_91_449 VGND VGND VPWR VPWR sky130_fd_sc_hd__decap_3
XFILLER_17_557 VGND VGND VPWR VPWR sky130_fd_sc_hd__decap_3
XFILLER_44_365 VGND VGND VPWR VPWR sky130_fd_sc_hd__decap_3
XFILLER_44_376 VGND VGND VPWR VPWR sky130_fd_sc_hd__decap_3
XFILLER_44_61 VGND VGND VPWR VPWR sky130_fd_sc_hd__decap_3
XFILLER_71_184 VGND VGND VPWR VPWR sky130_fd_sc_hd__decap_3
XFILLER_81_9 VGND VGND VPWR VPWR sky130_fd_sc_hd__fill_1
XFILLER_8_211 VGND VGND VPWR VPWR sky130_fd_sc_hd__decap_3
XFILLER_60_82 VGND VGND VPWR VPWR sky130_fd_sc_hd__fill_2
XFILLER_5_44 VGND VGND VPWR VPWR sky130_fd_sc_hd__fill_1
XFILLER_99_527 VGND VGND VPWR VPWR sky130_fd_sc_hd__decap_3
XFILLER_99_505 VGND VGND VPWR VPWR sky130_fd_sc_hd__decap_3
XFILLER_4_472 VGND VGND VPWR VPWR sky130_fd_sc_hd__decap_3
XFILLER_5_66 VGND VGND VPWR VPWR sky130_fd_sc_hd__decap_3
X_4190_ _4188_/X _4190_/B VGND VGND VPWR VPWR _4191_/B sky130_fd_sc_hd__and2b_2
XFILLER_79_273 VGND VGND VPWR VPWR sky130_fd_sc_hd__decap_3
XFILLER_10_3 VGND VGND VPWR VPWR sky130_fd_sc_hd__decap_3
XFILLER_39_126 VGND VGND VPWR VPWR sky130_fd_sc_hd__decap_3
XFILLER_67_446 VGND VGND VPWR VPWR sky130_fd_sc_hd__fill_2
XFILLER_67_479 VGND VGND VPWR VPWR sky130_fd_sc_hd__decap_3
XFILLER_94_265 VGND VGND VPWR VPWR sky130_fd_sc_hd__decap_3
XFILLER_35_332 VGND VGND VPWR VPWR sky130_fd_sc_hd__decap_3
XFILLER_85_90 VGND VGND VPWR VPWR sky130_fd_sc_hd__decap_3
X_6900_ _6273_/Y _6276_/X _6900_/A3 _6899_/X _6898_/X VGND VGND VPWR VPWR _6900_/X
+ sky130_fd_sc_hd__a41o_2
XFILLER_23_505 VGND VGND VPWR VPWR sky130_fd_sc_hd__decap_3
XFILLER_35_343 VGND VGND VPWR VPWR sky130_fd_sc_hd__decap_3
XFILLER_35_365 VGND VGND VPWR VPWR sky130_fd_sc_hd__fill_2
X_6831_ _6320_/Y _6322_/X _6831_/S VGND VGND VPWR VPWR _6831_/X sky130_fd_sc_hd__mux2_1
XFILLER_50_324 VGND VGND VPWR VPWR sky130_fd_sc_hd__decap_3
XFILLER_90_471 VGND VGND VPWR VPWR sky130_fd_sc_hd__decap_3
XFILLER_23_549 VGND VGND VPWR VPWR sky130_fd_sc_hd__decap_3
XFILLER_62_195 VGND VGND VPWR VPWR sky130_fd_sc_hd__fill_1
X_6762_ _6097_/Y _6717_/B _6797_/A2 _6208_/A VGND VGND VPWR VPWR _6762_/X sky130_fd_sc_hd__o22a_2
X_3974_ _3900_/A _5976_/A _3903_/B _3901_/X VGND VGND VPWR VPWR _3975_/B sky130_fd_sc_hd__a31o_2
XTAP_TAPCELL_ROW_61_853 VGND VPWR sky130_fd_sc_hd__tapvpwrvgnd_1
XFILLER_50_368 VGND VGND VPWR VPWR sky130_fd_sc_hd__decap_3
X_6693_ _6961_/A1 _6554_/B _6692_/X _6765_/B VGND VGND VPWR VPWR _6693_/Y sky130_fd_sc_hd__a22oi_2
X_5713_ _5739_/A _5713_/B _5713_/C _5750_/A VGND VGND VPWR VPWR _5740_/A sky130_fd_sc_hd__or4b_4
XTAP_TAPCELL_ROW_33_566 VGND VPWR sky130_fd_sc_hd__tapvpwrvgnd_1
XFILLER_31_593 VGND VGND VPWR VPWR sky130_fd_sc_hd__fill_1
X_5644_ _5645_/A _5644_/B VGND VGND VPWR VPWR _5654_/B sky130_fd_sc_hd__xor2_2
XTAP_TAPCELL_ROW_79_1048 VGND VPWR sky130_fd_sc_hd__tapvpwrvgnd_1
X_5575_ _5778_/B _5576_/D VGND VGND VPWR VPWR _5769_/A sky130_fd_sc_hd__nand2_2
X_4526_ _4526_/A _4526_/B _4527_/A _4526_/D VGND VGND VPWR VPWR _4811_/A sky130_fd_sc_hd__nand4_2
X_4457_ _4593_/B _4457_/B _4457_/C _4457_/D VGND VGND VPWR VPWR _4600_/A sky130_fd_sc_hd__and4_2
X_6127_ _6375_/A _6441_/A _5799_/A VGND VGND VPWR VPWR _6127_/X sky130_fd_sc_hd__o21a_2
X_4388_ _4662_/B _4608_/B VGND VGND VPWR VPWR _6378_/A sky130_fd_sc_hd__and2_2
XFILLER_85_243 VGND VGND VPWR VPWR sky130_fd_sc_hd__decap_3
Xload_slew191 _6249_/B VGND VGND VPWR VPWR _4793_/A sky130_fd_sc_hd__buf_2
XTAP_TAPCELL_ROW_69_942 VGND VPWR sky130_fd_sc_hd__tapvpwrvgnd_1
XTAP_TAPCELL_ROW_5_269 VGND VPWR sky130_fd_sc_hd__tapvpwrvgnd_1
XFILLER_65_38 VGND VGND VPWR VPWR sky130_fd_sc_hd__decap_3
X_6058_ _4322_/X _6058_/A2 _6057_/Y VGND VGND VPWR VPWR _6058_/Y sky130_fd_sc_hd__a21oi_4
XFILLER_73_449 VGND VGND VPWR VPWR sky130_fd_sc_hd__decap_3
XFILLER_85_287 VGND VGND VPWR VPWR sky130_fd_sc_hd__decap_3
X_5009_ _5007_/B _5008_/X _5913_/B _4920_/X VGND VGND VPWR VPWR _5009_/Y sky130_fd_sc_hd__a211oi_2
XFILLER_26_365 VGND VGND VPWR VPWR sky130_fd_sc_hd__decap_3
XFILLER_38_192 VGND VGND VPWR VPWR sky130_fd_sc_hd__decap_3
XFILLER_53_140 VGND VGND VPWR VPWR sky130_fd_sc_hd__decap_3
XFILLER_14_516 VGND VGND VPWR VPWR sky130_fd_sc_hd__decap_3
XFILLER_26_398 VGND VGND VPWR VPWR sky130_fd_sc_hd__decap_3
XFILLER_41_324 VGND VGND VPWR VPWR sky130_fd_sc_hd__decap_3
XFILLER_5_203 VGND VGND VPWR VPWR sky130_fd_sc_hd__decap_3
XFILLER_30_74 VGND VGND VPWR VPWR sky130_fd_sc_hd__decap_3
XFILLER_30_85 VGND VGND VPWR VPWR sky130_fd_sc_hd__decap_3
XFILLER_49_424 VGND VGND VPWR VPWR sky130_fd_sc_hd__fill_1
XFILLER_89_582 VGND VGND VPWR VPWR sky130_fd_sc_hd__fill_1
XFILLER_39_72 VGND VGND VPWR VPWR sky130_fd_sc_hd__decap_3
XFILLER_76_221 VGND VGND VPWR VPWR sky130_fd_sc_hd__decap_3
XFILLER_39_94 VGND VGND VPWR VPWR sky130_fd_sc_hd__decap_3
XFILLER_76_265 VGND VGND VPWR VPWR sky130_fd_sc_hd__decap_3
XFILLER_91_213 VGND VGND VPWR VPWR sky130_fd_sc_hd__decap_3
XFILLER_29_192 VGND VGND VPWR VPWR sky130_fd_sc_hd__decap_3
XFILLER_55_60 VGND VGND VPWR VPWR sky130_fd_sc_hd__decap_3
XFILLER_91_246 VGND VGND VPWR VPWR sky130_fd_sc_hd__decap_3
XFILLER_17_376 VGND VGND VPWR VPWR sky130_fd_sc_hd__fill_2
XFILLER_17_387 VGND VGND VPWR VPWR sky130_fd_sc_hd__decap_3
XFILLER_72_471 VGND VGND VPWR VPWR sky130_fd_sc_hd__decap_3
XFILLER_72_482 VGND VGND VPWR VPWR sky130_fd_sc_hd__decap_3
XFILLER_32_368 VGND VGND VPWR VPWR sky130_fd_sc_hd__decap_3
XTAP_TAPCELL_ROW_30_536 VGND VPWR sky130_fd_sc_hd__tapvpwrvgnd_1
XFILLER_9_531 VGND VGND VPWR VPWR sky130_fd_sc_hd__decap_3
X_3690_ _3690_/A _3690_/B VGND VGND VPWR VPWR _3707_/C sky130_fd_sc_hd__xnor2_2
XFILLER_9_564 VGND VGND VPWR VPWR sky130_fd_sc_hd__decap_3
XFILLER_58_3 VGND VGND VPWR VPWR sky130_fd_sc_hd__decap_3
X_5360_ _5360_/A _5360_/B VGND VGND VPWR VPWR _5373_/A sky130_fd_sc_hd__xnor2_2
X_5291_ _5341_/A _5304_/B _5191_/C VGND VGND VPWR VPWR _5292_/C sky130_fd_sc_hd__a21oi_2
X_4311_ _4257_/X _4258_/Y _4309_/A _4309_/Y VGND VGND VPWR VPWR _4313_/C sky130_fd_sc_hd__o211ai_2
XFILLER_99_324 VGND VGND VPWR VPWR sky130_fd_sc_hd__fill_2
XFILLER_87_508 VGND VGND VPWR VPWR sky130_fd_sc_hd__decap_3
XFILLER_87_519 VGND VGND VPWR VPWR sky130_fd_sc_hd__decap_3
X_4242_ _4237_/A _4237_/C _4237_/B VGND VGND VPWR VPWR _4243_/C sky130_fd_sc_hd__a21o_4
XFILLER_99_346 VGND VGND VPWR VPWR sky130_fd_sc_hd__decap_3
X_4173_ _4156_/Y _4172_/X _3762_/Y _4144_/X VGND VGND VPWR VPWR _4192_/A sky130_fd_sc_hd__a211o_2
XFILLER_67_254 VGND VGND VPWR VPWR sky130_fd_sc_hd__fill_1
XTAP_TAPCELL_ROW_66_912 VGND VPWR sky130_fd_sc_hd__tapvpwrvgnd_1
XFILLER_55_449 VGND VGND VPWR VPWR sky130_fd_sc_hd__decap_3
XFILLER_82_235 VGND VGND VPWR VPWR sky130_fd_sc_hd__fill_2
XTAP_TAPCELL_ROW_38_614 VGND VPWR sky130_fd_sc_hd__tapvpwrvgnd_1
XTAP_TAPCELL_ROW_2_239 VGND VPWR sky130_fd_sc_hd__tapvpwrvgnd_1
XFILLER_23_302 VGND VGND VPWR VPWR sky130_fd_sc_hd__decap_3
XFILLER_35_162 VGND VGND VPWR VPWR sky130_fd_sc_hd__decap_3
XFILLER_23_346 VGND VGND VPWR VPWR sky130_fd_sc_hd__decap_3
XFILLER_50_121 VGND VGND VPWR VPWR sky130_fd_sc_hd__fill_1
X_6814_ _3941_/A _6089_/B _6093_/B _3655_/A _6402_/S _6876_/S1 VGND VGND VPWR VPWR
+ _6814_/X sky130_fd_sc_hd__mux4_2
XFILLER_11_508 VGND VGND VPWR VPWR sky130_fd_sc_hd__decap_3
X_6745_ _6673_/X _6744_/X _6939_/S VGND VGND VPWR VPWR _6746_/B sky130_fd_sc_hd__mux2_1
X_3957_ _3996_/B _4003_/C _6175_/A _3955_/A VGND VGND VPWR VPWR _3958_/B sky130_fd_sc_hd__a22o_2
X_6676_ _6360_/X _6403_/X _6406_/X _6396_/X wire299/X _5585_/B VGND VGND VPWR VPWR
+ _6676_/X sky130_fd_sc_hd__mux4_2
X_3888_ _3888_/A _3888_/B VGND VGND VPWR VPWR _4060_/A sky130_fd_sc_hd__xor2_2
X_5627_ _5626_/B _5626_/C _5626_/A VGND VGND VPWR VPWR _5629_/B sky130_fd_sc_hd__a21bo_2
X_5558_ _5558_/A _5562_/A _5558_/C VGND VGND VPWR VPWR _5606_/A sky130_fd_sc_hd__or3_4
X_4509_ _4509_/A _4509_/B _4509_/C VGND VGND VPWR VPWR _4612_/A sky130_fd_sc_hd__or3_2
XFILLER_78_519 VGND VGND VPWR VPWR sky130_fd_sc_hd__decap_3
X_5489_ _5489_/A _5489_/B VGND VGND VPWR VPWR _5501_/B sky130_fd_sc_hd__nor2_2
Xfanout510 _5502_/A VGND VGND VPWR VPWR _4965_/A sky130_fd_sc_hd__buf_6
XFILLER_58_221 VGND VGND VPWR VPWR sky130_fd_sc_hd__decap_3
Xfanout543 input28/X VGND VGND VPWR VPWR _6008_/B sky130_fd_sc_hd__buf_6
Xfanout565 _5477_/A VGND VGND VPWR VPWR _6219_/A sky130_fd_sc_hd__clkdlybuf4s25_1
XFILLER_100_351 VGND VGND VPWR VPWR sky130_fd_sc_hd__decap_3
XFILLER_46_416 VGND VGND VPWR VPWR sky130_fd_sc_hd__decap_3
XFILLER_58_265 VGND VGND VPWR VPWR sky130_fd_sc_hd__decap_3
XFILLER_86_552 VGND VGND VPWR VPWR sky130_fd_sc_hd__decap_3
Xfanout598 _6673_/A2 VGND VGND VPWR VPWR _5526_/A sky130_fd_sc_hd__clkdlybuf4s25_1
XFILLER_73_268 VGND VGND VPWR VPWR sky130_fd_sc_hd__decap_3
XFILLER_92_36 VGND VGND VPWR VPWR sky130_fd_sc_hd__fill_1
XFILLER_14_324 VGND VGND VPWR VPWR sky130_fd_sc_hd__fill_1
XFILLER_14_346 VGND VGND VPWR VPWR sky130_fd_sc_hd__fill_2
XFILLER_25_63 VGND VGND VPWR VPWR sky130_fd_sc_hd__fill_1
XFILLER_41_110 VGND VGND VPWR VPWR sky130_fd_sc_hd__fill_2
XFILLER_81_290 VGND VGND VPWR VPWR sky130_fd_sc_hd__decap_3
XFILLER_14_368 VGND VGND VPWR VPWR sky130_fd_sc_hd__decap_3
XFILLER_6_501 VGND VGND VPWR VPWR sky130_fd_sc_hd__decap_3
XFILLER_41_73 VGND VGND VPWR VPWR sky130_fd_sc_hd__decap_3
XFILLER_6_589 VGND VGND VPWR VPWR sky130_fd_sc_hd__decap_3
XFILLER_44_9 VGND VGND VPWR VPWR sky130_fd_sc_hd__fill_1
XFILLER_1_272 VGND VGND VPWR VPWR sky130_fd_sc_hd__decap_3
XFILLER_2_23 VGND VGND VPWR VPWR sky130_fd_sc_hd__decap_3
XFILLER_49_243 VGND VGND VPWR VPWR sky130_fd_sc_hd__decap_3
XFILLER_37_449 VGND VGND VPWR VPWR sky130_fd_sc_hd__fill_1
XFILLER_49_276 VGND VGND VPWR VPWR sky130_fd_sc_hd__decap_3
XFILLER_49_287 VGND VGND VPWR VPWR sky130_fd_sc_hd__decap_3
XFILLER_64_224 VGND VGND VPWR VPWR sky130_fd_sc_hd__decap_3
XFILLER_64_268 VGND VGND VPWR VPWR sky130_fd_sc_hd__decap_3
XFILLER_17_162 VGND VGND VPWR VPWR sky130_fd_sc_hd__decap_3
XFILLER_60_430 VGND VGND VPWR VPWR sky130_fd_sc_hd__decap_3
X_4860_ _4860_/A VGND VGND VPWR VPWR _4860_/Y sky130_fd_sc_hd__inv_2
XFILLER_60_463 VGND VGND VPWR VPWR sky130_fd_sc_hd__fill_1
XFILLER_82_91 VGND VGND VPWR VPWR sky130_fd_sc_hd__decap_3
X_3811_ _3804_/A _3803_/B _3803_/A VGND VGND VPWR VPWR _3819_/A sky130_fd_sc_hd__o21ba_2
X_6530_ _6625_/B _6867_/A VGND VGND VPWR VPWR _6657_/B sky130_fd_sc_hd__or2_2
X_4791_ _4791_/A _4791_/B VGND VGND VPWR VPWR _4803_/A sky130_fd_sc_hd__xnor2_2
XTAP_TAPCELL_ROW_43_672 VGND VPWR sky130_fd_sc_hd__tapvpwrvgnd_1
XTAP_TAPCELL_ROW_15_374 VGND VPWR sky130_fd_sc_hd__tapvpwrvgnd_1
X_3742_ _3742_/A _4146_/A VGND VGND VPWR VPWR _3744_/B sky130_fd_sc_hd__nand2_2
X_6461_ _6589_/B _6876_/S1 _6337_/A _6458_/X VGND VGND VPWR VPWR _6461_/X sky130_fd_sc_hd__a31o_2
X_3673_ _3724_/B _3673_/B VGND VGND VPWR VPWR _3674_/C sky130_fd_sc_hd__or2_2
X_6392_ _6392_/A _6638_/A VGND VGND VPWR VPWR _6392_/Y sky130_fd_sc_hd__nand2_2
X_5412_ _5412_/A _5412_/B VGND VGND VPWR VPWR _5413_/C sky130_fd_sc_hd__xnor2_2
XTAP_TAPCELL_ROW_76_1018 VGND VPWR sky130_fd_sc_hd__tapvpwrvgnd_1
Xoutput102 _6987_/B VGND VGND VPWR VPWR result[9] sky130_fd_sc_hd__clkbuf_2
X_5343_ _5341_/X _5343_/B VGND VGND VPWR VPWR _5344_/B sky130_fd_sc_hd__and2b_2
XFILLER_87_316 VGND VGND VPWR VPWR sky130_fd_sc_hd__decap_3
X_5274_ _5274_/A _5274_/B VGND VGND VPWR VPWR _5287_/A sky130_fd_sc_hd__xnor2_2
X_4225_ _4225_/A _4225_/B _4348_/A VGND VGND VPWR VPWR _4253_/A sky130_fd_sc_hd__or3_2
X_4156_ _4156_/A VGND VGND VPWR VPWR _4156_/Y sky130_fd_sc_hd__inv_2
XFILLER_28_427 VGND VGND VPWR VPWR sky130_fd_sc_hd__fill_1
XFILLER_83_522 VGND VGND VPWR VPWR sky130_fd_sc_hd__decap_3
XFILLER_95_393 VGND VGND VPWR VPWR sky130_fd_sc_hd__decap_3
XFILLER_43_408 VGND VGND VPWR VPWR sky130_fd_sc_hd__decap_3
XFILLER_55_257 VGND VGND VPWR VPWR sky130_fd_sc_hd__decap_3
XFILLER_83_555 VGND VGND VPWR VPWR sky130_fd_sc_hd__decap_3
X_4087_ _4457_/B _6077_/A VGND VGND VPWR VPWR _4465_/A sky130_fd_sc_hd__nand2_2
XFILLER_55_279 VGND VGND VPWR VPWR sky130_fd_sc_hd__fill_1
XFILLER_70_227 VGND VGND VPWR VPWR sky130_fd_sc_hd__decap_3
XFILLER_62_17 VGND VGND VPWR VPWR sky130_fd_sc_hd__decap_3
XFILLER_63_290 VGND VGND VPWR VPWR sky130_fd_sc_hd__decap_3
XFILLER_70_249 VGND VGND VPWR VPWR sky130_fd_sc_hd__decap_3
X_4989_ _4989_/A _4989_/B _4990_/B VGND VGND VPWR VPWR _4989_/X sky130_fd_sc_hd__and3_2
X_6728_ _6488_/X _6493_/B _6500_/X _6489_/X _6314_/B _6832_/S VGND VGND VPWR VPWR
+ _6728_/X sky130_fd_sc_hd__mux4_2
XPHY_EDGE_ROW_12_Left_113 VGND VGND VPWR VPWR sky130_fd_sc_hd__decap_3
X_6659_ _6961_/A1 _6505_/X _6658_/X _6765_/B VGND VGND VPWR VPWR _6929_/B sky130_fd_sc_hd__a22o_2
XTAP_TAPCELL_ROW_98_1243 VGND VPWR sky130_fd_sc_hd__tapvpwrvgnd_1
XFILLER_78_305 VGND VGND VPWR VPWR sky130_fd_sc_hd__decap_3
XFILLER_78_327 VGND VGND VPWR VPWR sky130_fd_sc_hd__decap_3
XFILLER_87_47 VGND VGND VPWR VPWR sky130_fd_sc_hd__decap_3
XFILLER_78_349 VGND VGND VPWR VPWR sky130_fd_sc_hd__decap_3
XFILLER_93_308 VGND VGND VPWR VPWR sky130_fd_sc_hd__decap_3
Xfanout351 _6499_/S VGND VGND VPWR VPWR _4568_/B sky130_fd_sc_hd__clkdlybuf4s25_1
Xfanout373 _4646_/C VGND VGND VPWR VPWR _4593_/D sky130_fd_sc_hd__dlymetal6s2s_1
XPHY_EDGE_ROW_21_Left_122 VGND VGND VPWR VPWR sky130_fd_sc_hd__decap_3
XFILLER_19_438 VGND VGND VPWR VPWR sky130_fd_sc_hd__decap_3
XFILLER_46_224 VGND VGND VPWR VPWR sky130_fd_sc_hd__fill_1
XFILLER_74_533 VGND VGND VPWR VPWR sky130_fd_sc_hd__decap_3
XFILLER_86_360 VGND VGND VPWR VPWR sky130_fd_sc_hd__decap_3
XFILLER_86_371 VGND VGND VPWR VPWR sky130_fd_sc_hd__decap_3
Xfanout395 input4/X VGND VGND VPWR VPWR _3608_/A sky130_fd_sc_hd__buf_6
XFILLER_19_449 VGND VGND VPWR VPWR sky130_fd_sc_hd__decap_3
XFILLER_34_408 VGND VGND VPWR VPWR sky130_fd_sc_hd__decap_3
XFILLER_36_73 VGND VGND VPWR VPWR sky130_fd_sc_hd__decap_3
XFILLER_14_121 VGND VGND VPWR VPWR sky130_fd_sc_hd__decap_3
XFILLER_27_493 VGND VGND VPWR VPWR sky130_fd_sc_hd__fill_1
XPHY_EDGE_ROW_30_Left_131 VGND VGND VPWR VPWR sky130_fd_sc_hd__decap_3
XFILLER_52_94 VGND VGND VPWR VPWR sky130_fd_sc_hd__decap_3
XTAP_TAPCELL_ROW_40_642 VGND VPWR sky130_fd_sc_hd__tapvpwrvgnd_1
XTAP_TAPCELL_ROW_12_344 VGND VPWR sky130_fd_sc_hd__tapvpwrvgnd_1
Xinput15 A[22] VGND VGND VPWR VPWR input15/X sky130_fd_sc_hd__clkbuf_2
Xinput37 B[13] VGND VGND VPWR VPWR input37/X sky130_fd_sc_hd__clkbuf_2
Xinput26 A[3] VGND VGND VPWR VPWR wire573/A sky130_fd_sc_hd__clkbuf_4
Xinput59 B[4] VGND VGND VPWR VPWR input59/X sky130_fd_sc_hd__clkbuf_2
Xinput48 B[23] VGND VGND VPWR VPWR input48/X sky130_fd_sc_hd__clkdlybuf4s25_1
XFILLER_69_305 VGND VGND VPWR VPWR sky130_fd_sc_hd__decap_3
XFILLER_2_592 VGND VGND VPWR VPWR sky130_fd_sc_hd__decap_3
X_4010_ _6187_/A _4010_/B VGND VGND VPWR VPWR _5996_/A sky130_fd_sc_hd__nand2_2
XFILLER_65_500 VGND VGND VPWR VPWR sky130_fd_sc_hd__decap_3
XTAP_TAPCELL_ROW_48_720 VGND VPWR sky130_fd_sc_hd__tapvpwrvgnd_1
XFILLER_92_341 VGND VGND VPWR VPWR sky130_fd_sc_hd__decap_3
XFILLER_65_588 VGND VGND VPWR VPWR sky130_fd_sc_hd__decap_3
XFILLER_92_374 VGND VGND VPWR VPWR sky130_fd_sc_hd__decap_3
X_5961_ _5959_/X _5961_/B VGND VGND VPWR VPWR _5962_/B sky130_fd_sc_hd__nand2b_2
XFILLER_52_227 VGND VGND VPWR VPWR sky130_fd_sc_hd__fill_1
XFILLER_80_536 VGND VGND VPWR VPWR sky130_fd_sc_hd__decap_3
X_4912_ _4911_/A _4911_/B _4911_/C _4911_/D VGND VGND VPWR VPWR _4912_/X sky130_fd_sc_hd__a22o_2
XFILLER_33_452 VGND VGND VPWR VPWR sky130_fd_sc_hd__decap_3
X_5892_ _5882_/Y _5892_/B _5892_/C VGND VGND VPWR VPWR _5892_/X sky130_fd_sc_hd__and3b_2
X_4843_ _4841_/A _4841_/B _4841_/C VGND VGND VPWR VPWR _4845_/B sky130_fd_sc_hd__a21oi_2
XTAP_TAPCELL_ROW_82_1077 VGND VPWR sky130_fd_sc_hd__tapvpwrvgnd_1
X_4774_ _4773_/B _4773_/C _4773_/A VGND VGND VPWR VPWR _4775_/C sky130_fd_sc_hd__a21o_2
XFILLER_20_179 VGND VGND VPWR VPWR sky130_fd_sc_hd__decap_3
X_6513_ _6514_/B _6923_/A _6484_/Y _6512_/X VGND VGND VPWR VPWR _6985_/C sky130_fd_sc_hd__a31o_2
X_3725_ _3723_/A _3747_/A _3724_/Y _3709_/X VGND VGND VPWR VPWR _3725_/X sky130_fd_sc_hd__a211o_2
X_6444_ _6375_/A _6441_/A _6443_/Y VGND VGND VPWR VPWR _6444_/X sky130_fd_sc_hd__o21a_2
X_3656_ _6024_/B _3941_/B _3834_/D _6019_/B VGND VGND VPWR VPWR _3656_/Y sky130_fd_sc_hd__a22oi_2
X_6375_ _6375_/A _6375_/B VGND VGND VPWR VPWR _6375_/Y sky130_fd_sc_hd__nand2_2
X_3587_ _3585_/A _3814_/C _3814_/D _5983_/B VGND VGND VPWR VPWR _3588_/D sky130_fd_sc_hd__a22o_2
XFILLER_0_518 VGND VGND VPWR VPWR sky130_fd_sc_hd__decap_3
XFILLER_87_102 VGND VGND VPWR VPWR sky130_fd_sc_hd__decap_3
X_5326_ _5308_/A _5308_/C _5308_/B VGND VGND VPWR VPWR _5327_/C sky130_fd_sc_hd__o21ai_2
XFILLER_87_124 VGND VGND VPWR VPWR sky130_fd_sc_hd__fill_2
X_5257_ _5257_/A _5257_/B VGND VGND VPWR VPWR _5262_/B sky130_fd_sc_hd__or2_2
XTAP_TAPCELL_ROW_93_1195 VGND VPWR sky130_fd_sc_hd__tapvpwrvgnd_1
X_4208_ _4109_/A _4109_/B _4109_/C VGND VGND VPWR VPWR _4225_/B sky130_fd_sc_hd__a21oi_2
XFILLER_56_511 VGND VGND VPWR VPWR sky130_fd_sc_hd__decap_3
X_5188_ _5300_/B _5321_/B _5188_/C _5290_/C VGND VGND VPWR VPWR _5188_/X sky130_fd_sc_hd__and4_2
X_4139_ _4139_/A _4139_/B _4139_/C _4139_/D VGND VGND VPWR VPWR _4139_/X sky130_fd_sc_hd__or4_4
XFILLER_16_408 VGND VGND VPWR VPWR sky130_fd_sc_hd__decap_3
XFILLER_71_514 VGND VGND VPWR VPWR sky130_fd_sc_hd__decap_3
XFILLER_73_16 VGND VGND VPWR VPWR sky130_fd_sc_hd__decap_3
XFILLER_83_374 VGND VGND VPWR VPWR sky130_fd_sc_hd__decap_3
XFILLER_83_385 VGND VGND VPWR VPWR sky130_fd_sc_hd__decap_3
XFILLER_71_547 VGND VGND VPWR VPWR sky130_fd_sc_hd__decap_3
XTAP_TAPCELL_ROW_54_789 VGND VPWR sky130_fd_sc_hd__tapvpwrvgnd_1
XFILLER_11_113 VGND VGND VPWR VPWR sky130_fd_sc_hd__fill_2
XFILLER_24_485 VGND VGND VPWR VPWR sky130_fd_sc_hd__decap_3
XFILLER_51_293 VGND VGND VPWR VPWR sky130_fd_sc_hd__decap_3
XFILLER_22_75 VGND VGND VPWR VPWR sky130_fd_sc_hd__fill_1
XFILLER_98_68 VGND VGND VPWR VPWR sky130_fd_sc_hd__fill_2
XFILLER_3_378 VGND VGND VPWR VPWR sky130_fd_sc_hd__fill_1
XFILLER_47_511 VGND VGND VPWR VPWR sky130_fd_sc_hd__decap_3
XFILLER_59_382 VGND VGND VPWR VPWR sky130_fd_sc_hd__decap_3
XFILLER_93_105 VGND VGND VPWR VPWR sky130_fd_sc_hd__decap_3
Xfanout170 _3501_/Y VGND VGND VPWR VPWR _6976_/S sky130_fd_sc_hd__clkdlybuf4s25_1
Xfanout181 wire183/A VGND VGND VPWR VPWR _5162_/A sky130_fd_sc_hd__clkdlybuf4s25_1
Xfanout192 fanout194/A VGND VGND VPWR VPWR _6100_/B sky130_fd_sc_hd__clkdlybuf4s25_1
XFILLER_74_352 VGND VGND VPWR VPWR sky130_fd_sc_hd__decap_3
XFILLER_74_374 VGND VGND VPWR VPWR sky130_fd_sc_hd__decap_3
XFILLER_62_558 VGND VGND VPWR VPWR sky130_fd_sc_hd__decap_3
XFILLER_15_441 VGND VGND VPWR VPWR sky130_fd_sc_hd__fill_2
XFILLER_63_60 VGND VGND VPWR VPWR sky130_fd_sc_hd__decap_3
XFILLER_30_433 VGND VGND VPWR VPWR sky130_fd_sc_hd__decap_3
XTAP_TAPCELL_ROW_25_480 VGND VPWR sky130_fd_sc_hd__tapvpwrvgnd_1
XFILLER_30_499 VGND VGND VPWR VPWR sky130_fd_sc_hd__decap_3
X_3510_ _3510_/A _3510_/B VGND VGND VPWR VPWR _3517_/A sky130_fd_sc_hd__xnor2_2
Xwire571 wire571/A VGND VGND VPWR VPWR _3991_/B sky130_fd_sc_hd__buf_4
X_4490_ _4491_/A _4491_/B _4491_/C VGND VGND VPWR VPWR _4494_/A sky130_fd_sc_hd__and3_2
X_6160_ _6208_/A _6758_/A _6758_/B _6097_/Y _6209_/A VGND VGND VPWR VPWR _6161_/B
+ sky130_fd_sc_hd__a311oi_2
XFILLER_69_113 VGND VGND VPWR VPWR sky130_fd_sc_hd__decap_3
Xload_slew521 _5312_/B2 VGND VGND VPWR VPWR _5046_/B sky130_fd_sc_hd__buf_6
X_5111_ _5186_/A _5186_/B VGND VGND VPWR VPWR _5187_/A sky130_fd_sc_hd__or2_2
Xload_slew554 _3550_/A VGND VGND VPWR VPWR _4476_/A sky130_fd_sc_hd__buf_6
X_6091_ _6093_/A _6093_/B VGND VGND VPWR VPWR _6095_/A sky130_fd_sc_hd__nand2_2
XFILLER_97_466 VGND VGND VPWR VPWR sky130_fd_sc_hd__fill_2
Xload_slew587 _3993_/A1 VGND VGND VPWR VPWR _3990_/A sky130_fd_sc_hd__clkbuf_4
X_5042_ _5040_/B _5104_/B _5038_/X VGND VGND VPWR VPWR _5045_/B sky130_fd_sc_hd__a21o_2
XFILLER_38_533 VGND VGND VPWR VPWR sky130_fd_sc_hd__decap_3
XFILLER_65_330 VGND VGND VPWR VPWR sky130_fd_sc_hd__decap_3
XFILLER_38_577 VGND VGND VPWR VPWR sky130_fd_sc_hd__decap_3
XFILLER_53_503 VGND VGND VPWR VPWR sky130_fd_sc_hd__fill_1
XFILLER_53_514 VGND VGND VPWR VPWR sky130_fd_sc_hd__decap_3
XFILLER_65_352 VGND VGND VPWR VPWR sky130_fd_sc_hd__decap_3
XFILLER_65_396 VGND VGND VPWR VPWR sky130_fd_sc_hd__decap_3
XFILLER_80_333 VGND VGND VPWR VPWR sky130_fd_sc_hd__decap_3
X_6993_ _6993_/A _6993_/B VGND VGND VPWR VPWR _6995_/C sky130_fd_sc_hd__or2_2
XFILLER_80_377 VGND VGND VPWR VPWR sky130_fd_sc_hd__decap_3
X_5944_ _4081_/A _4081_/B _4082_/X VGND VGND VPWR VPWR _6055_/A sky130_fd_sc_hd__a21oi_2
XFILLER_21_422 VGND VGND VPWR VPWR sky130_fd_sc_hd__fill_2
X_5875_ _5856_/X _6775_/B _5874_/X _5843_/B VGND VGND VPWR VPWR _5876_/B sky130_fd_sc_hd__o22a_2
X_4826_ _4826_/A _4989_/B _4827_/B VGND VGND VPWR VPWR _4826_/X sky130_fd_sc_hd__and3_2
XTAP_TAPCELL_ROW_51_748 VGND VPWR sky130_fd_sc_hd__tapvpwrvgnd_1
Xrebuffer715 _4643_/X VGND VGND VPWR VPWR _4680_/A1 sky130_fd_sc_hd__buf_2
Xrebuffer704 _5936_/X VGND VGND VPWR VPWR _6951_/B sky130_fd_sc_hd__buf_6
Xrebuffer726 _5848_/A VGND VGND VPWR VPWR _5851_/B1 sky130_fd_sc_hd__buf_2
Xrebuffer737 _5275_/B VGND VGND VPWR VPWR _5267_/A1 sky130_fd_sc_hd__buf_2
Xrebuffer748 _5840_/A VGND VGND VPWR VPWR _5844_/A1 sky130_fd_sc_hd__buf_2
X_4757_ _5151_/B _4757_/B _4758_/A _4757_/D VGND VGND VPWR VPWR _4963_/A sky130_fd_sc_hd__nand4_2
XFILLER_4_109 VGND VGND VPWR VPWR sky130_fd_sc_hd__fill_2
Xrebuffer759 _5311_/B VGND VGND VPWR VPWR _5209_/A sky130_fd_sc_hd__buf_2
X_4688_ _4688_/A _4931_/A VGND VGND VPWR VPWR _4924_/A sky130_fd_sc_hd__nor2_2
X_3708_ _3708_/A _3708_/B VGND VGND VPWR VPWR _3724_/C sky130_fd_sc_hd__and2_2
XTAP_TAPCELL_ROW_95_1213 VGND VPWR sky130_fd_sc_hd__tapvpwrvgnd_1
X_6427_ _6212_/A _5582_/B _5412_/B VGND VGND VPWR VPWR _6427_/Y sky130_fd_sc_hd__o21ai_2
X_3639_ _3639_/A _3639_/B VGND VGND VPWR VPWR _4102_/A sky130_fd_sc_hd__nand2_2
X_6358_ _3489_/Y _6358_/A2 _5375_/A VGND VGND VPWR VPWR _6358_/Y sky130_fd_sc_hd__o21ai_2
XFILLER_0_315 VGND VGND VPWR VPWR sky130_fd_sc_hd__decap_3
XFILLER_0_337 VGND VGND VPWR VPWR sky130_fd_sc_hd__decap_3
XFILLER_88_433 VGND VGND VPWR VPWR sky130_fd_sc_hd__decap_3
X_5309_ _5308_/A _5327_/A VGND VGND VPWR VPWR _5317_/A sky130_fd_sc_hd__nand2b_2
XFILLER_88_477 VGND VGND VPWR VPWR sky130_fd_sc_hd__decap_3
X_6289_ _6336_/A _6332_/A _6332_/B _6353_/C VGND VGND VPWR VPWR _6932_/B sky130_fd_sc_hd__or4b_2
XFILLER_29_522 VGND VGND VPWR VPWR sky130_fd_sc_hd__decap_3
XFILLER_75_105 VGND VGND VPWR VPWR sky130_fd_sc_hd__fill_2
XTAP_TAPCELL_ROW_59_837 VGND VPWR sky130_fd_sc_hd__tapvpwrvgnd_1
XFILLER_75_138 VGND VGND VPWR VPWR sky130_fd_sc_hd__decap_3
XFILLER_17_31 VGND VGND VPWR VPWR sky130_fd_sc_hd__decap_3
XFILLER_44_503 VGND VGND VPWR VPWR sky130_fd_sc_hd__decap_3
XFILLER_56_363 VGND VGND VPWR VPWR sky130_fd_sc_hd__fill_1
XFILLER_56_374 VGND VGND VPWR VPWR sky130_fd_sc_hd__decap_3
XFILLER_84_48 VGND VGND VPWR VPWR sky130_fd_sc_hd__fill_2
XFILLER_90_108 VGND VGND VPWR VPWR sky130_fd_sc_hd__decap_3
XFILLER_16_216 VGND VGND VPWR VPWR sky130_fd_sc_hd__fill_1
XFILLER_44_525 VGND VGND VPWR VPWR sky130_fd_sc_hd__decap_3
XFILLER_44_536 VGND VGND VPWR VPWR sky130_fd_sc_hd__decap_3
XFILLER_71_311 VGND VGND VPWR VPWR sky130_fd_sc_hd__decap_3
XFILLER_17_75 VGND VGND VPWR VPWR sky130_fd_sc_hd__decap_3
XFILLER_71_366 VGND VGND VPWR VPWR sky130_fd_sc_hd__decap_3
XFILLER_12_433 VGND VGND VPWR VPWR sky130_fd_sc_hd__decap_3
XFILLER_12_466 VGND VGND VPWR VPWR sky130_fd_sc_hd__decap_3
XFILLER_12_477 VGND VGND VPWR VPWR sky130_fd_sc_hd__decap_3
XTAP_TAPCELL_ROW_22_450 VGND VPWR sky130_fd_sc_hd__tapvpwrvgnd_1
XFILLER_79_411 VGND VGND VPWR VPWR sky130_fd_sc_hd__decap_3
XFILLER_79_444 VGND VGND VPWR VPWR sky130_fd_sc_hd__decap_3
XFILLER_79_455 VGND VGND VPWR VPWR sky130_fd_sc_hd__decap_3
XFILLER_58_60 VGND VGND VPWR VPWR sky130_fd_sc_hd__decap_3
XFILLER_58_82 VGND VGND VPWR VPWR sky130_fd_sc_hd__fill_2
XFILLER_66_127 VGND VGND VPWR VPWR sky130_fd_sc_hd__decap_3
XFILLER_79_488 VGND VGND VPWR VPWR sky130_fd_sc_hd__decap_3
XFILLER_94_436 VGND VGND VPWR VPWR sky130_fd_sc_hd__decap_3
XFILLER_94_414 VGND VGND VPWR VPWR sky130_fd_sc_hd__decap_3
XFILLER_94_469 VGND VGND VPWR VPWR sky130_fd_sc_hd__decap_3
XFILLER_35_514 VGND VGND VPWR VPWR sky130_fd_sc_hd__decap_3
XFILLER_47_374 VGND VGND VPWR VPWR sky130_fd_sc_hd__decap_3
XFILLER_81_108 VGND VGND VPWR VPWR sky130_fd_sc_hd__decap_3
XFILLER_81_119 VGND VGND VPWR VPWR sky130_fd_sc_hd__decap_3
XFILLER_47_396 VGND VGND VPWR VPWR sky130_fd_sc_hd__decap_3
XFILLER_62_333 VGND VGND VPWR VPWR sky130_fd_sc_hd__decap_3
XFILLER_74_171 VGND VGND VPWR VPWR sky130_fd_sc_hd__decap_3
XFILLER_35_558 VGND VGND VPWR VPWR sky130_fd_sc_hd__fill_2
XFILLER_35_569 VGND VGND VPWR VPWR sky130_fd_sc_hd__decap_3
X_3990_ _3990_/A _6175_/A VGND VGND VPWR VPWR _3992_/A sky130_fd_sc_hd__nand2_2
XFILLER_50_539 VGND VGND VPWR VPWR sky130_fd_sc_hd__fill_1
XFILLER_62_388 VGND VGND VPWR VPWR sky130_fd_sc_hd__decap_3
X_5660_ _5632_/A _5632_/C _5632_/B VGND VGND VPWR VPWR _5672_/B sky130_fd_sc_hd__o21ai_2
X_4611_ _4610_/B _4610_/C _4610_/A VGND VGND VPWR VPWR _4612_/C sky130_fd_sc_hd__o21bai_2
XFILLER_30_274 VGND VGND VPWR VPWR sky130_fd_sc_hd__decap_3
X_5591_ _5591_/A _5591_/B _5591_/C VGND VGND VPWR VPWR _5594_/A sky130_fd_sc_hd__and3_2
X_4542_ _6085_/B _4539_/B _4541_/B _4538_/X VGND VGND VPWR VPWR _4544_/C sky130_fd_sc_hd__a31oi_2
Xmax_cap123 _6767_/Y VGND VGND VPWR VPWR _6944_/B1 sky130_fd_sc_hd__buf_2
Xmax_cap112 _5831_/Y VGND VGND VPWR VPWR _5839_/C1 sky130_fd_sc_hd__buf_1
X_4473_ _4473_/A _4473_/B _4473_/C VGND VGND VPWR VPWR _4473_/Y sky130_fd_sc_hd__nand3_2
Xmax_cap156 _6288_/Y VGND VGND VPWR VPWR _7000_/B2 sky130_fd_sc_hd__buf_1
Xmax_cap145 _6550_/B VGND VGND VPWR VPWR _6977_/B sky130_fd_sc_hd__clkbuf_2
X_6212_ _6212_/A _6212_/B VGND VGND VPWR VPWR _6212_/X sky130_fd_sc_hd__and2_2
Xload_slew340 _4457_/D VGND VGND VPWR VPWR _4097_/B sky130_fd_sc_hd__buf_2
X_6143_ _6378_/B _6155_/B VGND VGND VPWR VPWR _6672_/A sky130_fd_sc_hd__nor2_2
XTAP_TAPCELL_ROW_90_1165 VGND VPWR sky130_fd_sc_hd__tapvpwrvgnd_1
XFILLER_97_252 VGND VGND VPWR VPWR sky130_fd_sc_hd__decap_3
XFILLER_57_105 VGND VGND VPWR VPWR sky130_fd_sc_hd__decap_3
XFILLER_85_414 VGND VGND VPWR VPWR sky130_fd_sc_hd__decap_3
Xload_slew362 _6478_/S VGND VGND VPWR VPWR _5777_/B sky130_fd_sc_hd__clkbuf_2
X_6074_ _6074_/A _6940_/A VGND VGND VPWR VPWR _6348_/C sky130_fd_sc_hd__nand2_2
XFILLER_57_138 VGND VGND VPWR VPWR sky130_fd_sc_hd__decap_3
XFILLER_85_458 VGND VGND VPWR VPWR sky130_fd_sc_hd__decap_3
Xload_slew384 _6098_/A VGND VGND VPWR VPWR _3976_/B sky130_fd_sc_hd__buf_4
X_5025_ _5022_/A _5022_/B _5108_/A VGND VGND VPWR VPWR _5027_/B sky130_fd_sc_hd__o21ba_4
XTAP_TAPCELL_ROW_56_807 VGND VPWR sky130_fd_sc_hd__tapvpwrvgnd_1
XTAP_TAPCELL_ROW_28_509 VGND VPWR sky130_fd_sc_hd__tapvpwrvgnd_1
XFILLER_54_29 VGND VGND VPWR VPWR sky130_fd_sc_hd__decap_3
XFILLER_26_569 VGND VGND VPWR VPWR sky130_fd_sc_hd__decap_3
XFILLER_80_141 VGND VGND VPWR VPWR sky130_fd_sc_hd__fill_2
X_6976_ _6909_/X _6975_/X _6976_/S VGND VGND VPWR VPWR _6976_/X sky130_fd_sc_hd__mux2_1
XFILLER_53_377 VGND VGND VPWR VPWR sky130_fd_sc_hd__decap_3
X_5927_ _5927_/A _5927_/B VGND VGND VPWR VPWR _5931_/C sky130_fd_sc_hd__nand2_2
XTAP_TAPCELL_ROW_64_884 VGND VPWR sky130_fd_sc_hd__tapvpwrvgnd_1
XTAP_TAPCELL_ROW_36_597 VGND VPWR sky130_fd_sc_hd__tapvpwrvgnd_1
X_5858_ _5848_/A _5848_/C _5848_/B VGND VGND VPWR VPWR _5858_/X sky130_fd_sc_hd__o21a_2
X_5789_ _5777_/A _6123_/B _5799_/A VGND VGND VPWR VPWR _5790_/B sky130_fd_sc_hd__a21boi_2
X_4809_ _4659_/A _4659_/B _4664_/B _4662_/X VGND VGND VPWR VPWR _4811_/B sky130_fd_sc_hd__a31o_2
XPHY_EDGE_ROW_17_Right_17 VGND VGND VPWR VPWR sky130_fd_sc_hd__decap_3
XFILLER_5_418 VGND VGND VPWR VPWR sky130_fd_sc_hd__fill_2
XFILLER_0_123 VGND VGND VPWR VPWR sky130_fd_sc_hd__fill_1
XFILLER_88_230 VGND VGND VPWR VPWR sky130_fd_sc_hd__decap_3
XPHY_EDGE_ROW_26_Right_26 VGND VGND VPWR VPWR sky130_fd_sc_hd__decap_3
XFILLER_28_41 VGND VGND VPWR VPWR sky130_fd_sc_hd__decap_3
XFILLER_76_447 VGND VGND VPWR VPWR sky130_fd_sc_hd__decap_3
XFILLER_88_296 VGND VGND VPWR VPWR sky130_fd_sc_hd__decap_3
XFILLER_17_503 VGND VGND VPWR VPWR sky130_fd_sc_hd__fill_1
XFILLER_28_63 VGND VGND VPWR VPWR sky130_fd_sc_hd__decap_3
XFILLER_91_406 VGND VGND VPWR VPWR sky130_fd_sc_hd__decap_3
XFILLER_17_514 VGND VGND VPWR VPWR sky130_fd_sc_hd__decap_3
XFILLER_28_85 VGND VGND VPWR VPWR sky130_fd_sc_hd__decap_3
XFILLER_29_396 VGND VGND VPWR VPWR sky130_fd_sc_hd__decap_3
XFILLER_44_300 VGND VGND VPWR VPWR sky130_fd_sc_hd__decap_3
XFILLER_56_171 VGND VGND VPWR VPWR sky130_fd_sc_hd__decap_3
XFILLER_84_480 VGND VGND VPWR VPWR sky130_fd_sc_hd__fill_1
XFILLER_91_439 VGND VGND VPWR VPWR sky130_fd_sc_hd__decap_3
XFILLER_17_569 VGND VGND VPWR VPWR sky130_fd_sc_hd__decap_3
XFILLER_71_163 VGND VGND VPWR VPWR sky130_fd_sc_hd__decap_3
XFILLER_25_591 VGND VGND VPWR VPWR sky130_fd_sc_hd__decap_3
XFILLER_44_73 VGND VGND VPWR VPWR sky130_fd_sc_hd__decap_3
XPHY_EDGE_ROW_4_Left_105 VGND VGND VPWR VPWR sky130_fd_sc_hd__decap_3
XPHY_EDGE_ROW_35_Right_35 VGND VGND VPWR VPWR sky130_fd_sc_hd__decap_3
XFILLER_40_583 VGND VGND VPWR VPWR sky130_fd_sc_hd__decap_3
XFILLER_74_9 VGND VGND VPWR VPWR sky130_fd_sc_hd__fill_1
XFILLER_8_245 VGND VGND VPWR VPWR sky130_fd_sc_hd__decap_3
XFILLER_8_278 VGND VGND VPWR VPWR sky130_fd_sc_hd__decap_3
XFILLER_99_539 VGND VGND VPWR VPWR sky130_fd_sc_hd__fill_1
XFILLER_69_70 VGND VGND VPWR VPWR sky130_fd_sc_hd__fill_1
XFILLER_69_81 VGND VGND VPWR VPWR sky130_fd_sc_hd__fill_2
XPHY_EDGE_ROW_44_Right_44 VGND VGND VPWR VPWR sky130_fd_sc_hd__decap_3
XFILLER_94_222 VGND VGND VPWR VPWR sky130_fd_sc_hd__decap_3
XFILLER_82_417 VGND VGND VPWR VPWR sky130_fd_sc_hd__decap_3
XFILLER_47_160 VGND VGND VPWR VPWR sky130_fd_sc_hd__decap_3
XFILLER_75_491 VGND VGND VPWR VPWR sky130_fd_sc_hd__decap_3
XFILLER_94_288 VGND VGND VPWR VPWR sky130_fd_sc_hd__decap_3
X_6830_ _6830_/A _6830_/B VGND VGND VPWR VPWR _6830_/Y sky130_fd_sc_hd__nand2_2
XFILLER_23_517 VGND VGND VPWR VPWR sky130_fd_sc_hd__decap_3
XFILLER_50_303 VGND VGND VPWR VPWR sky130_fd_sc_hd__decap_3
XFILLER_62_174 VGND VGND VPWR VPWR sky130_fd_sc_hd__decap_3
XFILLER_90_483 VGND VGND VPWR VPWR sky130_fd_sc_hd__fill_1
X_6761_ _6691_/X _6760_/X _6761_/S VGND VGND VPWR VPWR _6761_/X sky130_fd_sc_hd__mux2_1
XFILLER_50_336 VGND VGND VPWR VPWR sky130_fd_sc_hd__decap_3
X_5712_ _5680_/A _6110_/B _5680_/C _5680_/D VGND VGND VPWR VPWR _5713_/C sky130_fd_sc_hd__a22oi_2
X_3973_ _3973_/A _3973_/B VGND VGND VPWR VPWR _3975_/A sky130_fd_sc_hd__xnor2_2
XTAP_TAPCELL_ROW_61_854 VGND VPWR sky130_fd_sc_hd__tapvpwrvgnd_1
XPHY_EDGE_ROW_53_Right_53 VGND VGND VPWR VPWR sky130_fd_sc_hd__decap_3
XFILLER_31_561 VGND VGND VPWR VPWR sky130_fd_sc_hd__decap_3
X_6692_ _6621_/X _6691_/X _6761_/S VGND VGND VPWR VPWR _6692_/X sky130_fd_sc_hd__mux2_1
XTAP_TAPCELL_ROW_33_567 VGND VPWR sky130_fd_sc_hd__tapvpwrvgnd_1
X_5643_ _5645_/A _5644_/B VGND VGND VPWR VPWR _5643_/Y sky130_fd_sc_hd__nand2_2
X_5574_ _5574_/A _5574_/B VGND VGND VPWR VPWR _5603_/A sky130_fd_sc_hd__xnor2_2
XTAP_TAPCELL_ROW_79_1049 VGND VPWR sky130_fd_sc_hd__tapvpwrvgnd_1
X_4525_ _4524_/A _4767_/C _4767_/D _4525_/B2 VGND VGND VPWR VPWR _4526_/D sky130_fd_sc_hd__a22o_2
X_4456_ _4457_/B _6266_/A VGND VGND VPWR VPWR _4683_/A sky130_fd_sc_hd__nand2_2
XPHY_EDGE_ROW_68_Left_169 VGND VGND VPWR VPWR sky130_fd_sc_hd__decap_3
XPHY_EDGE_ROW_62_Right_62 VGND VGND VPWR VPWR sky130_fd_sc_hd__decap_3
X_4387_ _4505_/B _4387_/B _4387_/C _4387_/D VGND VGND VPWR VPWR _4392_/A sky130_fd_sc_hd__nand4_2
XFILLER_100_511 VGND VGND VPWR VPWR sky130_fd_sc_hd__decap_3
X_6126_ _6126_/A _6126_/B VGND VGND VPWR VPWR _6126_/Y sky130_fd_sc_hd__xnor2_2
XFILLER_98_583 VGND VGND VPWR VPWR sky130_fd_sc_hd__decap_3
XFILLER_100_533 VGND VGND VPWR VPWR sky130_fd_sc_hd__decap_3
XFILLER_58_458 VGND VGND VPWR VPWR sky130_fd_sc_hd__decap_3
XTAP_TAPCELL_ROW_69_943 VGND VPWR sky130_fd_sc_hd__tapvpwrvgnd_1
XFILLER_100_566 VGND VGND VPWR VPWR sky130_fd_sc_hd__decap_3
XFILLER_73_406 VGND VGND VPWR VPWR sky130_fd_sc_hd__decap_3
XFILLER_85_255 VGND VGND VPWR VPWR sky130_fd_sc_hd__fill_2
X_6057_ _6057_/A _6057_/B VGND VGND VPWR VPWR _6057_/Y sky130_fd_sc_hd__xnor2_2
XFILLER_45_119 VGND VGND VPWR VPWR sky130_fd_sc_hd__decap_3
XFILLER_66_480 VGND VGND VPWR VPWR sky130_fd_sc_hd__decap_3
XFILLER_85_299 VGND VGND VPWR VPWR sky130_fd_sc_hd__decap_3
X_5008_ _5012_/A _5008_/B VGND VGND VPWR VPWR _5008_/X sky130_fd_sc_hd__or2_4
XPHY_EDGE_ROW_77_Left_178 VGND VGND VPWR VPWR sky130_fd_sc_hd__decap_3
XFILLER_14_539 VGND VGND VPWR VPWR sky130_fd_sc_hd__decap_3
XFILLER_26_377 VGND VGND VPWR VPWR sky130_fd_sc_hd__decap_3
XFILLER_53_152 VGND VGND VPWR VPWR sky130_fd_sc_hd__decap_3
XPHY_EDGE_ROW_71_Right_71 VGND VGND VPWR VPWR sky130_fd_sc_hd__decap_3
XFILLER_41_347 VGND VGND VPWR VPWR sky130_fd_sc_hd__decap_3
XFILLER_81_38 VGND VGND VPWR VPWR sky130_fd_sc_hd__decap_3
X_6959_ _6893_/X _6958_/X _6976_/S VGND VGND VPWR VPWR _6960_/B sky130_fd_sc_hd__mux2_1
XFILLER_14_43 VGND VGND VPWR VPWR sky130_fd_sc_hd__decap_3
XFILLER_22_561 VGND VGND VPWR VPWR sky130_fd_sc_hd__decap_3
XFILLER_14_65 VGND VGND VPWR VPWR sky130_fd_sc_hd__decap_3
XFILLER_14_98 VGND VGND VPWR VPWR sky130_fd_sc_hd__decap_3
XFILLER_30_53 VGND VGND VPWR VPWR sky130_fd_sc_hd__decap_3
XPHY_EDGE_ROW_86_Left_187 VGND VGND VPWR VPWR sky130_fd_sc_hd__decap_3
XPHY_EDGE_ROW_80_Right_80 VGND VGND VPWR VPWR sky130_fd_sc_hd__decap_3
XFILLER_30_97 VGND VGND VPWR VPWR sky130_fd_sc_hd__decap_3
XFILLER_39_51 VGND VGND VPWR VPWR sky130_fd_sc_hd__decap_3
XFILLER_49_447 VGND VGND VPWR VPWR sky130_fd_sc_hd__fill_1
XFILLER_76_233 VGND VGND VPWR VPWR sky130_fd_sc_hd__decap_3
XFILLER_89_594 VGND VGND VPWR VPWR sky130_fd_sc_hd__decap_3
XFILLER_29_160 VGND VGND VPWR VPWR sky130_fd_sc_hd__decap_3
XFILLER_36_119 VGND VGND VPWR VPWR sky130_fd_sc_hd__fill_1
XFILLER_91_225 VGND VGND VPWR VPWR sky130_fd_sc_hd__decap_3
XPHY_EDGE_ROW_95_Left_196 VGND VGND VPWR VPWR sky130_fd_sc_hd__decap_3
XFILLER_17_344 VGND VGND VPWR VPWR sky130_fd_sc_hd__decap_3
XFILLER_44_141 VGND VGND VPWR VPWR sky130_fd_sc_hd__decap_3
XFILLER_55_72 VGND VGND VPWR VPWR sky130_fd_sc_hd__fill_2
XFILLER_57_491 VGND VGND VPWR VPWR sky130_fd_sc_hd__decap_3
XFILLER_17_366 VGND VGND VPWR VPWR sky130_fd_sc_hd__fill_2
XFILLER_44_174 VGND VGND VPWR VPWR sky130_fd_sc_hd__decap_3
XFILLER_55_83 VGND VGND VPWR VPWR sky130_fd_sc_hd__decap_3
XFILLER_17_399 VGND VGND VPWR VPWR sky130_fd_sc_hd__decap_3
XFILLER_72_494 VGND VGND VPWR VPWR sky130_fd_sc_hd__decap_3
XFILLER_13_550 VGND VGND VPWR VPWR sky130_fd_sc_hd__decap_3
XFILLER_13_561 VGND VGND VPWR VPWR sky130_fd_sc_hd__fill_1
XFILLER_71_60 VGND VGND VPWR VPWR sky130_fd_sc_hd__fill_2
XTAP_TAPCELL_ROW_30_537 VGND VPWR sky130_fd_sc_hd__tapvpwrvgnd_1
X_5290_ _5300_/B _5321_/B _5290_/C _5304_/B VGND VGND VPWR VPWR _5345_/A sky130_fd_sc_hd__nand4_2
X_4310_ _4309_/A _4309_/Y _4257_/X _4258_/Y VGND VGND VPWR VPWR _4313_/B sky130_fd_sc_hd__a211o_2
XFILLER_99_303 VGND VGND VPWR VPWR sky130_fd_sc_hd__decap_3
XFILLER_4_281 VGND VGND VPWR VPWR sky130_fd_sc_hd__decap_3
X_4241_ _4241_/A _4360_/A VGND VGND VPWR VPWR _4243_/B sky130_fd_sc_hd__nand2_2
XFILLER_99_358 VGND VGND VPWR VPWR sky130_fd_sc_hd__fill_1
X_4172_ _4170_/A _4272_/A _4171_/Y _4156_/A VGND VGND VPWR VPWR _4172_/X sky130_fd_sc_hd__a211o_2
XTAP_TAPCELL_ROW_66_913 VGND VPWR sky130_fd_sc_hd__tapvpwrvgnd_1
XFILLER_95_575 VGND VGND VPWR VPWR sky130_fd_sc_hd__decap_3
XFILLER_27_119 VGND VGND VPWR VPWR sky130_fd_sc_hd__fill_1
XFILLER_67_299 VGND VGND VPWR VPWR sky130_fd_sc_hd__decap_3
XFILLER_82_214 VGND VGND VPWR VPWR sky130_fd_sc_hd__decap_3
XTAP_TAPCELL_ROW_38_615 VGND VPWR sky130_fd_sc_hd__tapvpwrvgnd_1
XFILLER_23_314 VGND VGND VPWR VPWR sky130_fd_sc_hd__decap_3
XFILLER_35_141 VGND VGND VPWR VPWR sky130_fd_sc_hd__fill_2
XFILLER_63_461 VGND VGND VPWR VPWR sky130_fd_sc_hd__decap_3
XFILLER_50_100 VGND VGND VPWR VPWR sky130_fd_sc_hd__decap_3
X_6813_ _6830_/A _6813_/B VGND VGND VPWR VPWR _6813_/Y sky130_fd_sc_hd__nand2_2
XTAP_TAPCELL_ROW_74_990 VGND VPWR sky130_fd_sc_hd__tapvpwrvgnd_1
XFILLER_50_155 VGND VGND VPWR VPWR sky130_fd_sc_hd__fill_2
X_6744_ _3628_/C _6152_/A _6244_/B _3663_/A _6744_/S0 _6876_/S1 VGND VGND VPWR VPWR
+ _6744_/X sky130_fd_sc_hd__mux4_2
X_3956_ _3990_/A _6178_/A VGND VGND VPWR VPWR _4032_/A sky130_fd_sc_hd__nand2_2
XFILLER_50_177 VGND VGND VPWR VPWR sky130_fd_sc_hd__decap_3
X_6675_ _6961_/A1 _6528_/B _6674_/X _6960_/A VGND VGND VPWR VPWR _6675_/X sky130_fd_sc_hd__a22o_2
XFILLER_31_391 VGND VGND VPWR VPWR sky130_fd_sc_hd__fill_1
X_5626_ _5626_/A _5626_/B _5626_/C VGND VGND VPWR VPWR _5667_/A sky130_fd_sc_hd__nand3_2
X_3887_ _3887_/A _3887_/B VGND VGND VPWR VPWR _3888_/B sky130_fd_sc_hd__nor2_2
X_5557_ _5557_/A _5557_/B _5557_/C VGND VGND VPWR VPWR _5558_/C sky130_fd_sc_hd__and3_2
X_5488_ _5407_/A _5407_/C _5407_/B VGND VGND VPWR VPWR _5489_/B sky130_fd_sc_hd__a21oi_2
X_4508_ _4509_/A _4509_/B _4509_/C VGND VGND VPWR VPWR _4508_/Y sky130_fd_sc_hd__nor3_2
X_4439_ _4254_/A _4329_/X _4378_/A _4439_/C1 VGND VGND VPWR VPWR _4440_/B sky130_fd_sc_hd__a211oi_2
Xfanout500 input30/X VGND VGND VPWR VPWR _4748_/A sky130_fd_sc_hd__buf_6
Xfanout522 input29/X VGND VGND VPWR VPWR _5306_/A sky130_fd_sc_hd__buf_8
Xfanout533 _5329_/A VGND VGND VPWR VPWR _5311_/A sky130_fd_sc_hd__buf_6
XFILLER_58_200 VGND VGND VPWR VPWR sky130_fd_sc_hd__decap_3
XFILLER_58_233 VGND VGND VPWR VPWR sky130_fd_sc_hd__decap_3
Xfanout555 _6002_/A1 VGND VGND VPWR VPWR _4634_/B sky130_fd_sc_hd__buf_4
Xfanout566 _6552_/A2 VGND VGND VPWR VPWR _5477_/A sky130_fd_sc_hd__buf_4
XFILLER_100_330 VGND VGND VPWR VPWR sky130_fd_sc_hd__fill_1
XFILLER_86_564 VGND VGND VPWR VPWR sky130_fd_sc_hd__decap_3
Xfanout577 _5382_/A VGND VGND VPWR VPWR _5341_/A sky130_fd_sc_hd__buf_6
Xfanout588 wire590/A VGND VGND VPWR VPWR _6004_/B sky130_fd_sc_hd__clkdlybuf4s25_1
X_6109_ _6109_/A _6109_/B VGND VGND VPWR VPWR _6213_/B sky130_fd_sc_hd__nor2_2
XFILLER_100_363 VGND VGND VPWR VPWR sky130_fd_sc_hd__fill_1
XFILLER_100_396 VGND VGND VPWR VPWR sky130_fd_sc_hd__decap_3
XFILLER_58_277 VGND VGND VPWR VPWR sky130_fd_sc_hd__decap_3
XFILLER_73_203 VGND VGND VPWR VPWR sky130_fd_sc_hd__decap_3
XFILLER_73_225 VGND VGND VPWR VPWR sky130_fd_sc_hd__decap_3
XFILLER_73_247 VGND VGND VPWR VPWR sky130_fd_sc_hd__decap_3
XFILLER_14_303 VGND VGND VPWR VPWR sky130_fd_sc_hd__decap_3
XFILLER_54_472 VGND VGND VPWR VPWR sky130_fd_sc_hd__decap_3
XFILLER_25_97 VGND VGND VPWR VPWR sky130_fd_sc_hd__decap_3
XFILLER_41_188 VGND VGND VPWR VPWR sky130_fd_sc_hd__decap_3
XFILLER_22_391 VGND VGND VPWR VPWR sky130_fd_sc_hd__decap_3
XFILLER_6_524 VGND VGND VPWR VPWR sky130_fd_sc_hd__decap_3
XFILLER_10_597 VGND VGND VPWR VPWR sky130_fd_sc_hd__fill_1
XFILLER_6_568 VGND VGND VPWR VPWR sky130_fd_sc_hd__decap_3
XFILLER_1_240 VGND VGND VPWR VPWR sky130_fd_sc_hd__decap_3
XFILLER_96_306 VGND VGND VPWR VPWR sky130_fd_sc_hd__fill_2
XFILLER_49_222 VGND VGND VPWR VPWR sky130_fd_sc_hd__fill_2
XFILLER_49_255 VGND VGND VPWR VPWR sky130_fd_sc_hd__decap_3
XFILLER_77_564 VGND VGND VPWR VPWR sky130_fd_sc_hd__decap_3
XFILLER_49_299 VGND VGND VPWR VPWR sky130_fd_sc_hd__decap_3
XFILLER_64_203 VGND VGND VPWR VPWR sky130_fd_sc_hd__decap_3
XFILLER_77_597 VGND VGND VPWR VPWR sky130_fd_sc_hd__fill_1
XFILLER_64_236 VGND VGND VPWR VPWR sky130_fd_sc_hd__decap_3
XFILLER_66_82 VGND VGND VPWR VPWR sky130_fd_sc_hd__fill_2
XFILLER_92_556 VGND VGND VPWR VPWR sky130_fd_sc_hd__decap_3
XFILLER_17_152 VGND VGND VPWR VPWR sky130_fd_sc_hd__decap_3
XFILLER_45_461 VGND VGND VPWR VPWR sky130_fd_sc_hd__decap_3
XFILLER_52_409 VGND VGND VPWR VPWR sky130_fd_sc_hd__decap_3
XFILLER_92_589 VGND VGND VPWR VPWR sky130_fd_sc_hd__decap_3
XFILLER_72_291 VGND VGND VPWR VPWR sky130_fd_sc_hd__decap_3
XFILLER_20_306 VGND VGND VPWR VPWR sky130_fd_sc_hd__fill_2
XFILLER_32_144 VGND VGND VPWR VPWR sky130_fd_sc_hd__decap_3
XFILLER_82_70 VGND VGND VPWR VPWR sky130_fd_sc_hd__decap_3
X_4790_ _4790_/A _4790_/B VGND VGND VPWR VPWR _4791_/B sky130_fd_sc_hd__xnor2_2
X_3810_ _3808_/A _3808_/B _4051_/A VGND VGND VPWR VPWR _3845_/A sky130_fd_sc_hd__o21bai_2
XTAP_TAPCELL_ROW_71_960 VGND VPWR sky130_fd_sc_hd__tapvpwrvgnd_1
XFILLER_32_177 VGND VGND VPWR VPWR sky130_fd_sc_hd__decap_3
X_3741_ _4524_/A _4264_/B _3742_/A _3741_/D VGND VGND VPWR VPWR _4146_/A sky130_fd_sc_hd__nand4_2
XTAP_TAPCELL_ROW_43_673 VGND VPWR sky130_fd_sc_hd__tapvpwrvgnd_1
XTAP_TAPCELL_ROW_15_375 VGND VPWR sky130_fd_sc_hd__tapvpwrvgnd_1
XFILLER_9_340 VGND VGND VPWR VPWR sky130_fd_sc_hd__decap_3
XFILLER_70_3 VGND VGND VPWR VPWR sky130_fd_sc_hd__fill_1
X_6460_ _6545_/A _6731_/A VGND VGND VPWR VPWR _6680_/A sky130_fd_sc_hd__nand2_2
X_3672_ _3672_/A _3672_/B VGND VGND VPWR VPWR _3673_/B sky130_fd_sc_hd__nor2_2
XFILLER_9_362 VGND VGND VPWR VPWR sky130_fd_sc_hd__decap_3
X_6391_ _6498_/A _6498_/B VGND VGND VPWR VPWR _6391_/Y sky130_fd_sc_hd__nand2_2
X_5411_ _5412_/B _5412_/A VGND VGND VPWR VPWR _5411_/Y sky130_fd_sc_hd__nand2b_2
XTAP_TAPCELL_ROW_76_1019 VGND VPWR sky130_fd_sc_hd__tapvpwrvgnd_1
Xoutput103 _6995_/Y VGND VGND VPWR VPWR zero sky130_fd_sc_hd__buf_6
X_5342_ _5341_/A _5341_/C _5341_/D _5341_/B VGND VGND VPWR VPWR _5343_/B sky130_fd_sc_hd__a22o_2
XFILLER_99_111 VGND VGND VPWR VPWR sky130_fd_sc_hd__fill_1
XFILLER_99_100 VGND VGND VPWR VPWR sky130_fd_sc_hd__decap_3
X_5273_ _5374_/A _5284_/B _5273_/C VGND VGND VPWR VPWR _5455_/B sky130_fd_sc_hd__and3_2
XFILLER_99_166 VGND VGND VPWR VPWR sky130_fd_sc_hd__fill_2
XFILLER_68_520 VGND VGND VPWR VPWR sky130_fd_sc_hd__decap_3
XFILLER_68_531 VGND VGND VPWR VPWR sky130_fd_sc_hd__fill_1
X_4224_ _4225_/A _4225_/B _4348_/A VGND VGND VPWR VPWR _4224_/Y sky130_fd_sc_hd__nor3_2
XFILLER_68_542 VGND VGND VPWR VPWR sky130_fd_sc_hd__decap_3
X_4155_ _4155_/A _4155_/B _4155_/C VGND VGND VPWR VPWR _4156_/A sky130_fd_sc_hd__and3_2
XFILLER_55_225 VGND VGND VPWR VPWR sky130_fd_sc_hd__decap_3
XFILLER_68_597 VGND VGND VPWR VPWR sky130_fd_sc_hd__fill_1
XTAP_TAPCELL_ROW_87_1126 VGND VPWR sky130_fd_sc_hd__tapvpwrvgnd_1
XFILLER_95_361 VGND VGND VPWR VPWR sky130_fd_sc_hd__decap_3
XFILLER_83_567 VGND VGND VPWR VPWR sky130_fd_sc_hd__decap_3
X_4086_ _4070_/A _4070_/C _4070_/B VGND VGND VPWR VPWR _4111_/B sky130_fd_sc_hd__a21o_2
XFILLER_70_206 VGND VGND VPWR VPWR sky130_fd_sc_hd__decap_3
XFILLER_23_166 VGND VGND VPWR VPWR sky130_fd_sc_hd__fill_2
XFILLER_23_188 VGND VGND VPWR VPWR sky130_fd_sc_hd__decap_3
X_4988_ _4988_/A _4988_/B VGND VGND VPWR VPWR _4990_/B sky130_fd_sc_hd__xor2_2
X_6727_ _6727_/A _6727_/B VGND VGND VPWR VPWR _6727_/Y sky130_fd_sc_hd__xnor2_2
X_3939_ _3938_/A _3938_/B _3938_/C VGND VGND VPWR VPWR _3940_/B sky130_fd_sc_hd__o21a_2
X_6658_ _6301_/X _6306_/X _6924_/S VGND VGND VPWR VPWR _6658_/X sky130_fd_sc_hd__mux2_1
XTAP_TAPCELL_ROW_98_1244 VGND VPWR sky130_fd_sc_hd__tapvpwrvgnd_1
XFILLER_11_22 VGND VGND VPWR VPWR sky130_fd_sc_hd__fill_1
X_5609_ _5562_/B _5562_/C _5562_/A VGND VGND VPWR VPWR _5609_/X sky130_fd_sc_hd__a21o_2
XFILLER_3_527 VGND VGND VPWR VPWR sky130_fd_sc_hd__decap_3
X_6589_ _6589_/A _6589_/B _6589_/C VGND VGND VPWR VPWR _6862_/B sky130_fd_sc_hd__or3_2
XFILLER_11_99 VGND VGND VPWR VPWR sky130_fd_sc_hd__decap_3
XFILLER_2_6 VGND VGND VPWR VPWR sky130_fd_sc_hd__fill_2
Xfanout330 input47/X VGND VGND VPWR VPWR _6079_/A sky130_fd_sc_hd__dlymetal6s2s_1
Xfanout341 _3552_/B VGND VGND VPWR VPWR _3574_/A2 sky130_fd_sc_hd__clkdlybuf4s25_1
XFILLER_59_553 VGND VGND VPWR VPWR sky130_fd_sc_hd__decap_3
XFILLER_59_564 VGND VGND VPWR VPWR sky130_fd_sc_hd__decap_3
Xfanout352 _6499_/S VGND VGND VPWR VPWR _6893_/S sky130_fd_sc_hd__clkdlybuf4s25_1
Xfanout363 _6456_/S VGND VGND VPWR VPWR _6453_/S sky130_fd_sc_hd__clkdlybuf4s25_1
Xfanout374 input42/X VGND VGND VPWR VPWR _3638_/D sky130_fd_sc_hd__clkbuf_2
XFILLER_59_575 VGND VGND VPWR VPWR sky130_fd_sc_hd__decap_3
XFILLER_86_383 VGND VGND VPWR VPWR sky130_fd_sc_hd__decap_3
XFILLER_100_193 VGND VGND VPWR VPWR sky130_fd_sc_hd__decap_3
XFILLER_74_545 VGND VGND VPWR VPWR sky130_fd_sc_hd__fill_1
XFILLER_27_461 VGND VGND VPWR VPWR sky130_fd_sc_hd__decap_3
XFILLER_36_41 VGND VGND VPWR VPWR sky130_fd_sc_hd__decap_3
XFILLER_46_269 VGND VGND VPWR VPWR sky130_fd_sc_hd__decap_3
XFILLER_61_206 VGND VGND VPWR VPWR sky130_fd_sc_hd__fill_1
XFILLER_74_589 VGND VGND VPWR VPWR sky130_fd_sc_hd__decap_3
XFILLER_36_85 VGND VGND VPWR VPWR sky130_fd_sc_hd__decap_3
XFILLER_61_228 VGND VGND VPWR VPWR sky130_fd_sc_hd__decap_3
XFILLER_42_475 VGND VGND VPWR VPWR sky130_fd_sc_hd__fill_1
XTAP_TAPCELL_ROW_40_632 VGND VPWR sky130_fd_sc_hd__tapvpwrvgnd_1
XTAP_TAPCELL_ROW_12_345 VGND VPWR sky130_fd_sc_hd__tapvpwrvgnd_1
Xinput16 A[23] VGND VGND VPWR VPWR input16/X sky130_fd_sc_hd__clkdlybuf4s25_1
Xinput27 A[4] VGND VGND VPWR VPWR input27/X sky130_fd_sc_hd__clkbuf_2
XFILLER_10_394 VGND VGND VPWR VPWR sky130_fd_sc_hd__decap_3
Xinput49 B[24] VGND VGND VPWR VPWR _4088_/C sky130_fd_sc_hd__clkdlybuf4s25_1
Xinput38 B[14] VGND VGND VPWR VPWR input38/X sky130_fd_sc_hd__clkdlybuf4s25_1
XFILLER_6_354 VGND VGND VPWR VPWR sky130_fd_sc_hd__decap_3
XFILLER_6_387 VGND VGND VPWR VPWR sky130_fd_sc_hd__decap_3
XFILLER_84_309 VGND VGND VPWR VPWR sky130_fd_sc_hd__decap_3
XFILLER_65_512 VGND VGND VPWR VPWR sky130_fd_sc_hd__decap_3
XFILLER_37_225 VGND VGND VPWR VPWR sky130_fd_sc_hd__decap_3
XTAP_TAPCELL_ROW_48_721 VGND VPWR sky130_fd_sc_hd__tapvpwrvgnd_1
XFILLER_18_450 VGND VGND VPWR VPWR sky130_fd_sc_hd__decap_3
XFILLER_52_206 VGND VGND VPWR VPWR sky130_fd_sc_hd__fill_1
XFILLER_65_567 VGND VGND VPWR VPWR sky130_fd_sc_hd__decap_3
XFILLER_92_353 VGND VGND VPWR VPWR sky130_fd_sc_hd__decap_3
X_5960_ _5959_/A _5959_/B _5959_/C _5959_/D VGND VGND VPWR VPWR _5961_/B sky130_fd_sc_hd__a22o_2
XFILLER_18_483 VGND VGND VPWR VPWR sky130_fd_sc_hd__decap_3
XFILLER_92_386 VGND VGND VPWR VPWR sky130_fd_sc_hd__decap_3
X_5891_ _4558_/X _5883_/Y _5888_/B _5891_/C1 VGND VGND VPWR VPWR _5892_/C sky130_fd_sc_hd__a211o_2
X_4911_ _4911_/A _4911_/B _4911_/C _4911_/D VGND VGND VPWR VPWR _4911_/Y sky130_fd_sc_hd__nand4_2
XFILLER_33_486 VGND VGND VPWR VPWR sky130_fd_sc_hd__decap_3
X_4842_ _4845_/A VGND VGND VPWR VPWR _4842_/Y sky130_fd_sc_hd__inv_2
XTAP_TAPCELL_ROW_82_1078 VGND VPWR sky130_fd_sc_hd__tapvpwrvgnd_1
XFILLER_20_125 VGND VGND VPWR VPWR sky130_fd_sc_hd__decap_3
XFILLER_60_294 VGND VGND VPWR VPWR sky130_fd_sc_hd__decap_3
X_4773_ _4773_/A _4773_/B _4773_/C VGND VGND VPWR VPWR _4775_/B sky130_fd_sc_hd__nand3_2
XFILLER_20_158 VGND VGND VPWR VPWR sky130_fd_sc_hd__fill_2
X_6512_ _6512_/A _6512_/B _6512_/C VGND VGND VPWR VPWR _6512_/X sky130_fd_sc_hd__or3_2
X_3724_ _3724_/A _3724_/B _3724_/C VGND VGND VPWR VPWR _3724_/Y sky130_fd_sc_hd__nor3_2
X_6443_ _6375_/A _6441_/A _6778_/B1 VGND VGND VPWR VPWR _6443_/Y sky130_fd_sc_hd__a21oi_2
X_3655_ _3655_/A _6019_/B _3941_/B _3834_/D VGND VGND VPWR VPWR _3678_/A sky130_fd_sc_hd__and4_2
XFILLER_9_181 VGND VGND VPWR VPWR sky130_fd_sc_hd__fill_2
X_6374_ _6331_/B _6375_/B _6605_/A2 _6373_/A VGND VGND VPWR VPWR _6374_/X sky130_fd_sc_hd__o2bb2a_2
X_3586_ _3590_/A VGND VGND VPWR VPWR _3588_/C sky130_fd_sc_hd__inv_2
XFILLER_0_508 VGND VGND VPWR VPWR sky130_fd_sc_hd__decap_3
X_5325_ _5382_/A _5322_/B _5324_/B _5321_/X VGND VGND VPWR VPWR _5327_/B sky130_fd_sc_hd__a31o_2
X_5256_ _5077_/Y _5079_/Y _5257_/A _5255_/X VGND VGND VPWR VPWR _5257_/B sky130_fd_sc_hd__a211oi_2
XTAP_TAPCELL_ROW_93_1196 VGND VPWR sky130_fd_sc_hd__tapvpwrvgnd_1
XFILLER_87_147 VGND VGND VPWR VPWR sky130_fd_sc_hd__decap_3
XFILLER_87_169 VGND VGND VPWR VPWR sky130_fd_sc_hd__fill_2
X_4207_ _4139_/B _4139_/C _4139_/D _4139_/A VGND VGND VPWR VPWR _4207_/Y sky130_fd_sc_hd__o22ai_2
XFILLER_68_383 VGND VGND VPWR VPWR sky130_fd_sc_hd__decap_3
X_5187_ _5187_/A _5187_/B VGND VGND VPWR VPWR _5248_/C sky130_fd_sc_hd__and2_2
XFILLER_28_236 VGND VGND VPWR VPWR sky130_fd_sc_hd__decap_3
XFILLER_83_331 VGND VGND VPWR VPWR sky130_fd_sc_hd__fill_2
X_4138_ _4111_/A _4111_/B _4225_/A VGND VGND VPWR VPWR _4139_/D sky130_fd_sc_hd__a21oi_2
XFILLER_43_206 VGND VGND VPWR VPWR sky130_fd_sc_hd__decap_3
XFILLER_56_589 VGND VGND VPWR VPWR sky130_fd_sc_hd__decap_3
XFILLER_73_28 VGND VGND VPWR VPWR sky130_fd_sc_hd__decap_3
X_4069_ _3584_/A _3584_/B _3584_/C VGND VGND VPWR VPWR _4070_/C sky130_fd_sc_hd__a21o_2
XFILLER_71_559 VGND VGND VPWR VPWR sky130_fd_sc_hd__fill_1
XTAP_TAPCELL_ROW_54_779 VGND VPWR sky130_fd_sc_hd__tapvpwrvgnd_1
XFILLER_24_497 VGND VGND VPWR VPWR sky130_fd_sc_hd__decap_3
XFILLER_51_250 VGND VGND VPWR VPWR sky130_fd_sc_hd__fill_1
XFILLER_11_136 VGND VGND VPWR VPWR sky130_fd_sc_hd__decap_3
XFILLER_3_335 VGND VGND VPWR VPWR sky130_fd_sc_hd__fill_1
XFILLER_0_3 VGND VGND VPWR VPWR sky130_fd_sc_hd__decap_3
XFILLER_66_309 VGND VGND VPWR VPWR sky130_fd_sc_hd__decap_3
XFILLER_47_501 VGND VGND VPWR VPWR sky130_fd_sc_hd__decap_3
XFILLER_47_523 VGND VGND VPWR VPWR sky130_fd_sc_hd__fill_1
Xfanout160 fanout160/A VGND VGND VPWR VPWR wire161/A sky130_fd_sc_hd__clkdlybuf4s25_1
Xfanout171 _6939_/S VGND VGND VPWR VPWR _6569_/A sky130_fd_sc_hd__dlymetal6s4s_1
Xfanout182 fanout186/A VGND VGND VPWR VPWR wire183/A sky130_fd_sc_hd__clkdlybuf4s25_1
XFILLER_86_180 VGND VGND VPWR VPWR sky130_fd_sc_hd__decap_3
XFILLER_47_84 VGND VGND VPWR VPWR sky130_fd_sc_hd__decap_3
XFILLER_62_526 VGND VGND VPWR VPWR sky130_fd_sc_hd__decap_3
XFILLER_42_261 VGND VGND VPWR VPWR sky130_fd_sc_hd__decap_3
XFILLER_30_445 VGND VGND VPWR VPWR sky130_fd_sc_hd__decap_3
XFILLER_42_283 VGND VGND VPWR VPWR sky130_fd_sc_hd__decap_3
XFILLER_70_592 VGND VGND VPWR VPWR sky130_fd_sc_hd__decap_3
XFILLER_8_23 VGND VGND VPWR VPWR sky130_fd_sc_hd__decap_3
XTAP_TAPCELL_ROW_25_481 VGND VPWR sky130_fd_sc_hd__tapvpwrvgnd_1
XFILLER_8_56 VGND VGND VPWR VPWR sky130_fd_sc_hd__fill_1
XFILLER_6_195 VGND VGND VPWR VPWR sky130_fd_sc_hd__fill_1
XFILLER_69_125 VGND VGND VPWR VPWR sky130_fd_sc_hd__decap_3
Xload_slew511 _4965_/A VGND VGND VPWR VPWR _5268_/C sky130_fd_sc_hd__buf_4
X_6090_ _6090_/A _6254_/B VGND VGND VPWR VPWR _6796_/A sky130_fd_sc_hd__or2_2
X_5110_ _5166_/A _5110_/B VGND VGND VPWR VPWR _5186_/B sky130_fd_sc_hd__nand2_2
XFILLER_97_412 VGND VGND VPWR VPWR sky130_fd_sc_hd__decap_3
Xload_slew544 _6008_/B VGND VGND VPWR VPWR _3544_/A sky130_fd_sc_hd__buf_4
X_5041_ _6138_/A _5041_/B VGND VGND VPWR VPWR _5104_/B sky130_fd_sc_hd__xnor2_2
XFILLER_69_169 VGND VGND VPWR VPWR sky130_fd_sc_hd__decap_3
XFILLER_84_128 VGND VGND VPWR VPWR sky130_fd_sc_hd__decap_3
Xload_slew599 _5526_/A VGND VGND VPWR VPWR _6238_/B sky130_fd_sc_hd__clkbuf_4
XFILLER_38_545 VGND VGND VPWR VPWR sky130_fd_sc_hd__decap_3
XFILLER_92_150 VGND VGND VPWR VPWR sky130_fd_sc_hd__decap_3
XFILLER_25_228 VGND VGND VPWR VPWR sky130_fd_sc_hd__decap_3
XFILLER_65_386 VGND VGND VPWR VPWR sky130_fd_sc_hd__decap_3
XFILLER_80_312 VGND VGND VPWR VPWR sky130_fd_sc_hd__decap_3
XFILLER_92_161 VGND VGND VPWR VPWR sky130_fd_sc_hd__fill_1
XFILLER_92_194 VGND VGND VPWR VPWR sky130_fd_sc_hd__fill_2
X_6992_ _6992_/A _6992_/B _6992_/C _6992_/D VGND VGND VPWR VPWR _6992_/Y sky130_fd_sc_hd__nor4_4
XFILLER_18_291 VGND VGND VPWR VPWR sky130_fd_sc_hd__fill_1
XFILLER_80_345 VGND VGND VPWR VPWR sky130_fd_sc_hd__decap_3
X_5943_ _3867_/A _6319_/S _3882_/B _3881_/A VGND VGND VPWR VPWR _6056_/A sky130_fd_sc_hd__a31o_2
XFILLER_33_272 VGND VGND VPWR VPWR sky130_fd_sc_hd__decap_3
XFILLER_61_570 VGND VGND VPWR VPWR sky130_fd_sc_hd__fill_1
X_5874_ _5856_/A _5874_/B VGND VGND VPWR VPWR _5874_/X sky130_fd_sc_hd__and2b_2
XFILLER_21_434 VGND VGND VPWR VPWR sky130_fd_sc_hd__decap_3
XFILLER_33_294 VGND VGND VPWR VPWR sky130_fd_sc_hd__decap_3
X_4825_ _4825_/A _4825_/B VGND VGND VPWR VPWR _4827_/B sky130_fd_sc_hd__xor2_2
XTAP_TAPCELL_ROW_51_749 VGND VPWR sky130_fd_sc_hd__tapvpwrvgnd_1
Xrebuffer705 fanout300/X VGND VGND VPWR VPWR _6789_/A1 sky130_fd_sc_hd__buf_2
Xrebuffer716 _5571_/A1 VGND VGND VPWR VPWR _5566_/B1 sky130_fd_sc_hd__buf_2
Xrebuffer727 _5850_/X VGND VGND VPWR VPWR _5854_/B1 sky130_fd_sc_hd__buf_2
Xrebuffer738 _4181_/B VGND VGND VPWR VPWR _6265_/B sky130_fd_sc_hd__buf_2
Xrebuffer749 _4755_/C VGND VGND VPWR VPWR _4734_/A2 sky130_fd_sc_hd__buf_2
X_4756_ _5054_/A _4755_/C _4755_/D _4965_/A VGND VGND VPWR VPWR _4757_/D sky130_fd_sc_hd__a22o_2
X_4687_ _4688_/A _4686_/Y _4687_/C _5018_/B VGND VGND VPWR VPWR _4931_/A sky130_fd_sc_hd__and4bb_2
X_3707_ _3707_/A _3707_/B _3707_/C VGND VGND VPWR VPWR _3708_/B sky130_fd_sc_hd__or3_2
XTAP_TAPCELL_ROW_95_1214 VGND VPWR sky130_fd_sc_hd__tapvpwrvgnd_1
X_6426_ _6236_/B _6238_/B _6435_/S VGND VGND VPWR VPWR _6426_/X sky130_fd_sc_hd__mux2_1
X_3638_ _4617_/A _4483_/A _4628_/C _3638_/D VGND VGND VPWR VPWR _3638_/X sky130_fd_sc_hd__and4_2
X_6357_ _6621_/A1 _6236_/B _6238_/B _6105_/A _6439_/B _6126_/B VGND VGND VPWR VPWR
+ _6357_/X sky130_fd_sc_hd__mux4_2
X_3569_ _3960_/A _4097_/B _3553_/A _3552_/D VGND VGND VPWR VPWR _3575_/B sky130_fd_sc_hd__a22o_2
XFILLER_0_305 VGND VGND VPWR VPWR sky130_fd_sc_hd__decap_3
XFILLER_0_327 VGND VGND VPWR VPWR sky130_fd_sc_hd__decap_3
XFILLER_68_39 VGND VGND VPWR VPWR sky130_fd_sc_hd__decap_3
XFILLER_88_412 VGND VGND VPWR VPWR sky130_fd_sc_hd__decap_3
X_5308_ _5308_/A _5308_/B _5308_/C VGND VGND VPWR VPWR _5327_/A sky130_fd_sc_hd__or3_4
XFILLER_0_349 VGND VGND VPWR VPWR sky130_fd_sc_hd__fill_1
XFILLER_88_445 VGND VGND VPWR VPWR sky130_fd_sc_hd__decap_3
XFILLER_88_456 VGND VGND VPWR VPWR sky130_fd_sc_hd__decap_3
X_6288_ _6336_/A _6332_/A _6332_/B _6353_/C VGND VGND VPWR VPWR _6288_/Y sky130_fd_sc_hd__nor4b_2
XFILLER_48_309 VGND VGND VPWR VPWR sky130_fd_sc_hd__decap_3
X_5239_ _5321_/B _4925_/D _5018_/B _5300_/B VGND VGND VPWR VPWR _5240_/C sky130_fd_sc_hd__a22o_2
XTAP_TAPCELL_ROW_59_838 VGND VPWR sky130_fd_sc_hd__tapvpwrvgnd_1
XFILLER_29_534 VGND VGND VPWR VPWR sky130_fd_sc_hd__decap_3
XFILLER_29_578 VGND VGND VPWR VPWR sky130_fd_sc_hd__decap_3
XFILLER_44_548 VGND VGND VPWR VPWR sky130_fd_sc_hd__fill_1
XFILLER_56_386 VGND VGND VPWR VPWR sky130_fd_sc_hd__decap_3
XFILLER_71_323 VGND VGND VPWR VPWR sky130_fd_sc_hd__decap_3
XFILLER_83_161 VGND VGND VPWR VPWR sky130_fd_sc_hd__decap_3
XFILLER_83_172 VGND VGND VPWR VPWR sky130_fd_sc_hd__fill_1
XFILLER_83_183 VGND VGND VPWR VPWR sky130_fd_sc_hd__decap_3
XFILLER_71_378 VGND VGND VPWR VPWR sky130_fd_sc_hd__decap_3
XFILLER_12_445 VGND VGND VPWR VPWR sky130_fd_sc_hd__decap_3
XFILLER_24_283 VGND VGND VPWR VPWR sky130_fd_sc_hd__decap_3
XFILLER_8_427 VGND VGND VPWR VPWR sky130_fd_sc_hd__fill_1
XTAP_TAPCELL_ROW_22_451 VGND VPWR sky130_fd_sc_hd__tapvpwrvgnd_1
XFILLER_12_489 VGND VGND VPWR VPWR sky130_fd_sc_hd__decap_3
XFILLER_8_449 VGND VGND VPWR VPWR sky130_fd_sc_hd__decap_3
XFILLER_3_110 VGND VGND VPWR VPWR sky130_fd_sc_hd__fill_2
XFILLER_79_423 VGND VGND VPWR VPWR sky130_fd_sc_hd__decap_3
XFILLER_79_467 VGND VGND VPWR VPWR sky130_fd_sc_hd__decap_3
XFILLER_39_309 VGND VGND VPWR VPWR sky130_fd_sc_hd__decap_3
XFILLER_58_72 VGND VGND VPWR VPWR sky130_fd_sc_hd__decap_3
XFILLER_59_191 VGND VGND VPWR VPWR sky130_fd_sc_hd__decap_3
XFILLER_66_139 VGND VGND VPWR VPWR sky130_fd_sc_hd__fill_1
XFILLER_94_448 VGND VGND VPWR VPWR sky130_fd_sc_hd__decap_3
XFILLER_74_150 VGND VGND VPWR VPWR sky130_fd_sc_hd__decap_3
XFILLER_35_537 VGND VGND VPWR VPWR sky130_fd_sc_hd__decap_3
XFILLER_47_386 VGND VGND VPWR VPWR sky130_fd_sc_hd__decap_3
XFILLER_62_312 VGND VGND VPWR VPWR sky130_fd_sc_hd__decap_3
XFILLER_74_183 VGND VGND VPWR VPWR sky130_fd_sc_hd__decap_3
XFILLER_62_345 VGND VGND VPWR VPWR sky130_fd_sc_hd__fill_1
XFILLER_74_93 VGND VGND VPWR VPWR sky130_fd_sc_hd__decap_3
XFILLER_15_261 VGND VGND VPWR VPWR sky130_fd_sc_hd__decap_3
XFILLER_62_378 VGND VGND VPWR VPWR sky130_fd_sc_hd__fill_1
XFILLER_15_294 VGND VGND VPWR VPWR sky130_fd_sc_hd__decap_3
XFILLER_30_253 VGND VGND VPWR VPWR sky130_fd_sc_hd__decap_3
X_4610_ _4610_/A _4610_/B _4610_/C VGND VGND VPWR VPWR _4672_/A sky130_fd_sc_hd__or3_2
X_5590_ _5630_/A _6123_/B _5533_/A _5532_/D VGND VGND VPWR VPWR _5591_/C sky130_fd_sc_hd__a22o_2
X_4541_ _4538_/X _4541_/B VGND VGND VPWR VPWR _4569_/B sky130_fd_sc_hd__and2b_2
Xwire391 _6100_/A VGND VGND VPWR VPWR _3814_/C sky130_fd_sc_hd__clkbuf_4
Xmax_cap113 _4834_/Y VGND VGND VPWR VPWR _5001_/A1 sky130_fd_sc_hd__clkbuf_2
X_4472_ _4473_/A _4473_/B _4473_/C VGND VGND VPWR VPWR _4472_/X sky130_fd_sc_hd__and3_2
XFILLER_89_209 VGND VGND VPWR VPWR sky130_fd_sc_hd__decap_3
X_6211_ _6211_/A _6211_/B VGND VGND VPWR VPWR _6247_/A sky130_fd_sc_hd__nand2_2
X_6142_ _6635_/A _6213_/B _6140_/C _6141_/A _4389_/Y VGND VGND VPWR VPWR _6155_/B
+ sky130_fd_sc_hd__o311a_2
XTAP_TAPCELL_ROW_90_1166 VGND VPWR sky130_fd_sc_hd__tapvpwrvgnd_1
XFILLER_85_426 VGND VGND VPWR VPWR sky130_fd_sc_hd__decap_3
X_6073_ _6073_/A _6205_/A VGND VGND VPWR VPWR _6940_/A sky130_fd_sc_hd__or2_2
Xload_slew396 _3608_/A VGND VGND VPWR VPWR _4264_/A sky130_fd_sc_hd__buf_4
X_5024_ _5107_/A _5107_/B VGND VGND VPWR VPWR _5108_/A sky130_fd_sc_hd__and2_2
XFILLER_97_297 VGND VGND VPWR VPWR sky130_fd_sc_hd__decap_3
XFILLER_38_353 VGND VGND VPWR VPWR sky130_fd_sc_hd__decap_3
XTAP_TAPCELL_ROW_56_808 VGND VPWR sky130_fd_sc_hd__tapvpwrvgnd_1
XFILLER_26_515 VGND VGND VPWR VPWR sky130_fd_sc_hd__decap_3
XFILLER_38_386 VGND VGND VPWR VPWR sky130_fd_sc_hd__decap_3
XFILLER_65_161 VGND VGND VPWR VPWR sky130_fd_sc_hd__decap_3
XFILLER_65_172 VGND VGND VPWR VPWR sky130_fd_sc_hd__decap_3
XFILLER_93_470 VGND VGND VPWR VPWR sky130_fd_sc_hd__decap_3
XFILLER_53_334 VGND VGND VPWR VPWR sky130_fd_sc_hd__fill_2
XFILLER_65_194 VGND VGND VPWR VPWR sky130_fd_sc_hd__decap_3
XFILLER_80_131 VGND VGND VPWR VPWR sky130_fd_sc_hd__decap_3
X_6975_ _3867_/A _3868_/A _3872_/A _6175_/B _3867_/B _6456_/S VGND VGND VPWR VPWR
+ _6975_/X sky130_fd_sc_hd__mux4_2
XFILLER_53_389 VGND VGND VPWR VPWR sky130_fd_sc_hd__decap_3
X_5926_ _5921_/Y _5922_/X _4430_/X _5926_/C1 VGND VGND VPWR VPWR _5927_/B sky130_fd_sc_hd__a211o_2
XTAP_TAPCELL_ROW_64_885 VGND VPWR sky130_fd_sc_hd__tapvpwrvgnd_1
XFILLER_21_220 VGND VGND VPWR VPWR sky130_fd_sc_hd__decap_3
XFILLER_80_197 VGND VGND VPWR VPWR sky130_fd_sc_hd__decap_3
XTAP_TAPCELL_ROW_36_598 VGND VPWR sky130_fd_sc_hd__tapvpwrvgnd_1
XFILLER_21_231 VGND VGND VPWR VPWR sky130_fd_sc_hd__decap_3
X_5857_ _5850_/X _5851_/Y _5233_/Y _5235_/Y VGND VGND VPWR VPWR _5857_/X sky130_fd_sc_hd__o211a_4
XFILLER_21_297 VGND VGND VPWR VPWR sky130_fd_sc_hd__decap_3
X_5788_ _5788_/A _5788_/B VGND VGND VPWR VPWR _6515_/A sky130_fd_sc_hd__or2_2
X_4808_ _4808_/A _4808_/B VGND VGND VPWR VPWR _4813_/A sky130_fd_sc_hd__nand2_2
X_4739_ _5151_/B _4755_/C _4755_/D _4767_/A VGND VGND VPWR VPWR _4740_/D sky130_fd_sc_hd__a22o_2
X_6409_ _3655_/A _6093_/B _6435_/S VGND VGND VPWR VPWR _6409_/X sky130_fd_sc_hd__mux2_1
XFILLER_0_102 VGND VGND VPWR VPWR sky130_fd_sc_hd__decap_3
XFILLER_0_113 VGND VGND VPWR VPWR sky130_fd_sc_hd__fill_1
XFILLER_0_157 VGND VGND VPWR VPWR sky130_fd_sc_hd__decap_3
XFILLER_48_106 VGND VGND VPWR VPWR sky130_fd_sc_hd__decap_3
XFILLER_76_415 VGND VGND VPWR VPWR sky130_fd_sc_hd__decap_3
XFILLER_88_253 VGND VGND VPWR VPWR sky130_fd_sc_hd__decap_3
XFILLER_88_264 VGND VGND VPWR VPWR sky130_fd_sc_hd__decap_3
XFILLER_95_37 VGND VGND VPWR VPWR sky130_fd_sc_hd__fill_2
XFILLER_29_320 VGND VGND VPWR VPWR sky130_fd_sc_hd__fill_1
XFILLER_91_418 VGND VGND VPWR VPWR sky130_fd_sc_hd__fill_2
XFILLER_44_323 VGND VGND VPWR VPWR sky130_fd_sc_hd__fill_2
XFILLER_56_150 VGND VGND VPWR VPWR sky130_fd_sc_hd__decap_3
XFILLER_56_183 VGND VGND VPWR VPWR sky130_fd_sc_hd__decap_3
XFILLER_84_492 VGND VGND VPWR VPWR sky130_fd_sc_hd__decap_3
XFILLER_44_334 VGND VGND VPWR VPWR sky130_fd_sc_hd__decap_3
XFILLER_71_142 VGND VGND VPWR VPWR sky130_fd_sc_hd__fill_2
XFILLER_32_529 VGND VGND VPWR VPWR sky130_fd_sc_hd__decap_3
XFILLER_71_153 VGND VGND VPWR VPWR sky130_fd_sc_hd__fill_2
XFILLER_71_175 VGND VGND VPWR VPWR sky130_fd_sc_hd__decap_3
XFILLER_12_220 VGND VGND VPWR VPWR sky130_fd_sc_hd__fill_2
XFILLER_12_253 VGND VGND VPWR VPWR sky130_fd_sc_hd__decap_3
XFILLER_100_91 VGND VGND VPWR VPWR sky130_fd_sc_hd__decap_3
XFILLER_12_297 VGND VGND VPWR VPWR sky130_fd_sc_hd__decap_3
XFILLER_40_573 VGND VGND VPWR VPWR sky130_fd_sc_hd__fill_2
XFILLER_60_40 VGND VGND VPWR VPWR sky130_fd_sc_hd__decap_3
XFILLER_67_9 VGND VGND VPWR VPWR sky130_fd_sc_hd__decap_3
XFILLER_5_24 VGND VGND VPWR VPWR sky130_fd_sc_hd__decap_3
XFILLER_4_485 VGND VGND VPWR VPWR sky130_fd_sc_hd__fill_1
XFILLER_4_496 VGND VGND VPWR VPWR sky130_fd_sc_hd__fill_1
XFILLER_79_264 VGND VGND VPWR VPWR sky130_fd_sc_hd__decap_3
XFILLER_67_426 VGND VGND VPWR VPWR sky130_fd_sc_hd__fill_1
XFILLER_67_459 VGND VGND VPWR VPWR sky130_fd_sc_hd__fill_1
XTAP_TAPCELL_ROW_7_290 VGND VPWR sky130_fd_sc_hd__tapvpwrvgnd_1
XFILLER_94_256 VGND VGND VPWR VPWR sky130_fd_sc_hd__decap_3
XFILLER_47_172 VGND VGND VPWR VPWR sky130_fd_sc_hd__decap_3
XFILLER_85_81 VGND VGND VPWR VPWR sky130_fd_sc_hd__decap_3
XFILLER_35_356 VGND VGND VPWR VPWR sky130_fd_sc_hd__decap_3
XFILLER_62_120 VGND VGND VPWR VPWR sky130_fd_sc_hd__decap_3
XFILLER_50_315 VGND VGND VPWR VPWR sky130_fd_sc_hd__decap_3
XFILLER_90_462 VGND VGND VPWR VPWR sky130_fd_sc_hd__decap_3
X_6760_ _6297_/Y _6323_/X _6760_/S VGND VGND VPWR VPWR _6760_/X sky130_fd_sc_hd__mux2_1
XFILLER_16_592 VGND VGND VPWR VPWR sky130_fd_sc_hd__decap_3
XFILLER_62_186 VGND VGND VPWR VPWR sky130_fd_sc_hd__decap_3
XFILLER_62_197 VGND VGND VPWR VPWR sky130_fd_sc_hd__decap_3
X_5711_ _5711_/A _5711_/B VGND VGND VPWR VPWR _5750_/A sky130_fd_sc_hd__xnor2_2
X_3972_ _3972_/A _5976_/A VGND VGND VPWR VPWR _3973_/B sky130_fd_sc_hd__nand2_2
X_6691_ _6298_/X _6300_/Y _6831_/S VGND VGND VPWR VPWR _6691_/X sky130_fd_sc_hd__mux2_1
XTAP_TAPCELL_ROW_61_855 VGND VPWR sky130_fd_sc_hd__tapvpwrvgnd_1
XTAP_TAPCELL_ROW_33_568 VGND VPWR sky130_fd_sc_hd__tapvpwrvgnd_1
XFILLER_31_573 VGND VGND VPWR VPWR sky130_fd_sc_hd__decap_3
X_5642_ _5655_/A _5655_/B VGND VGND VPWR VPWR _5644_/B sky130_fd_sc_hd__nor2_2
X_5573_ _5618_/A VGND VGND VPWR VPWR _5604_/A sky130_fd_sc_hd__inv_2
X_4524_ _4524_/A _4524_/B _4767_/C _4767_/D VGND VGND VPWR VPWR _4527_/A sky130_fd_sc_hd__nand4_2
X_4455_ _4455_/A _4455_/B VGND VGND VPWR VPWR _4464_/A sky130_fd_sc_hd__xnor2_2
X_4386_ _4386_/A _4386_/B VGND VGND VPWR VPWR _4394_/A sky130_fd_sc_hd__nand2_2
XFILLER_98_551 VGND VGND VPWR VPWR sky130_fd_sc_hd__decap_3
XFILLER_100_501 VGND VGND VPWR VPWR sky130_fd_sc_hd__decap_3
X_6125_ _6126_/A _6125_/B VGND VGND VPWR VPWR _6125_/Y sky130_fd_sc_hd__nor2_2
XFILLER_100_523 VGND VGND VPWR VPWR sky130_fd_sc_hd__decap_3
XFILLER_85_223 VGND VGND VPWR VPWR sky130_fd_sc_hd__fill_1
XFILLER_85_234 VGND VGND VPWR VPWR sky130_fd_sc_hd__decap_3
XTAP_TAPCELL_ROW_69_944 VGND VPWR sky130_fd_sc_hd__tapvpwrvgnd_1
XFILLER_98_595 VGND VGND VPWR VPWR sky130_fd_sc_hd__decap_3
Xload_slew193 _6100_/B VGND VGND VPWR VPWR _3628_/C sky130_fd_sc_hd__clkbuf_4
X_6056_ _6056_/A _6056_/B VGND VGND VPWR VPWR _6057_/B sky130_fd_sc_hd__xnor2_2
XFILLER_100_589 VGND VGND VPWR VPWR sky130_fd_sc_hd__decap_3
XFILLER_26_312 VGND VGND VPWR VPWR sky130_fd_sc_hd__decap_3
XFILLER_66_470 VGND VGND VPWR VPWR sky130_fd_sc_hd__decap_3
XFILLER_73_418 VGND VGND VPWR VPWR sky130_fd_sc_hd__decap_3
X_5007_ _5007_/A _5007_/B VGND VGND VPWR VPWR _5008_/B sky130_fd_sc_hd__nand2_2
XFILLER_53_131 VGND VGND VPWR VPWR sky130_fd_sc_hd__decap_3
XFILLER_26_389 VGND VGND VPWR VPWR sky130_fd_sc_hd__decap_3
XFILLER_41_304 VGND VGND VPWR VPWR sky130_fd_sc_hd__decap_3
XFILLER_53_186 VGND VGND VPWR VPWR sky130_fd_sc_hd__decap_3
X_6958_ _3868_/A _3872_/A input20/X _4290_/A _6958_/S0 _6893_/S VGND VGND VPWR VPWR
+ _6958_/X sky130_fd_sc_hd__mux4_2
XFILLER_22_540 VGND VGND VPWR VPWR sky130_fd_sc_hd__decap_3
X_6889_ _6871_/A _6190_/C _6192_/A VGND VGND VPWR VPWR _6902_/B sky130_fd_sc_hd__o21ai_2
X_5909_ _5907_/A _5908_/Y _5931_/B _5902_/X VGND VGND VPWR VPWR _5916_/A sky130_fd_sc_hd__o211a_2
XFILLER_14_77 VGND VGND VPWR VPWR sky130_fd_sc_hd__decap_3
XFILLER_22_595 VGND VGND VPWR VPWR sky130_fd_sc_hd__decap_3
XFILLER_30_32 VGND VGND VPWR VPWR sky130_fd_sc_hd__fill_1
XFILLER_5_238 VGND VGND VPWR VPWR sky130_fd_sc_hd__decap_3
XFILLER_100_3 VGND VGND VPWR VPWR sky130_fd_sc_hd__fill_2
XFILLER_1_499 VGND VGND VPWR VPWR sky130_fd_sc_hd__decap_3
XFILLER_39_63 VGND VGND VPWR VPWR sky130_fd_sc_hd__decap_3
XFILLER_76_245 VGND VGND VPWR VPWR sky130_fd_sc_hd__decap_3
XFILLER_76_256 VGND VGND VPWR VPWR sky130_fd_sc_hd__decap_3
XTAP_TAPCELL_ROW_4_260 VGND VPWR sky130_fd_sc_hd__tapvpwrvgnd_1
XFILLER_64_429 VGND VGND VPWR VPWR sky130_fd_sc_hd__decap_3
XFILLER_72_440 VGND VGND VPWR VPWR sky130_fd_sc_hd__decap_3
XFILLER_91_237 VGND VGND VPWR VPWR sky130_fd_sc_hd__decap_3
XFILLER_17_356 VGND VGND VPWR VPWR sky130_fd_sc_hd__fill_2
XFILLER_44_153 VGND VGND VPWR VPWR sky130_fd_sc_hd__fill_2
XFILLER_55_95 VGND VGND VPWR VPWR sky130_fd_sc_hd__decap_3
XFILLER_32_337 VGND VGND VPWR VPWR sky130_fd_sc_hd__fill_2
XFILLER_40_381 VGND VGND VPWR VPWR sky130_fd_sc_hd__fill_2
XTAP_TAPCELL_ROW_30_527 VGND VPWR sky130_fd_sc_hd__tapvpwrvgnd_1
XFILLER_9_511 VGND VGND VPWR VPWR sky130_fd_sc_hd__decap_3
XFILLER_71_94 VGND VGND VPWR VPWR sky130_fd_sc_hd__decap_3
XFILLER_4_260 VGND VGND VPWR VPWR sky130_fd_sc_hd__decap_3
XFILLER_99_315 VGND VGND VPWR VPWR sky130_fd_sc_hd__decap_3
XFILLER_4_293 VGND VGND VPWR VPWR sky130_fd_sc_hd__fill_1
X_4240_ _4505_/B _4362_/B _4241_/A _4240_/D VGND VGND VPWR VPWR _4360_/A sky130_fd_sc_hd__nand4_2
XFILLER_99_337 VGND VGND VPWR VPWR sky130_fd_sc_hd__fill_1
X_4171_ _4155_/A _4155_/C _4155_/B VGND VGND VPWR VPWR _4171_/Y sky130_fd_sc_hd__a21oi_2
XFILLER_67_234 VGND VGND VPWR VPWR sky130_fd_sc_hd__decap_3
XFILLER_55_429 VGND VGND VPWR VPWR sky130_fd_sc_hd__decap_3
XFILLER_82_226 VGND VGND VPWR VPWR sky130_fd_sc_hd__decap_3
XTAP_TAPCELL_ROW_66_914 VGND VPWR sky130_fd_sc_hd__tapvpwrvgnd_1
XTAP_TAPCELL_ROW_38_616 VGND VPWR sky130_fd_sc_hd__tapvpwrvgnd_1
XFILLER_63_440 VGND VGND VPWR VPWR sky130_fd_sc_hd__fill_1
XFILLER_82_259 VGND VGND VPWR VPWR sky130_fd_sc_hd__decap_3
XFILLER_63_473 VGND VGND VPWR VPWR sky130_fd_sc_hd__decap_3
X_6812_ _6965_/A _6812_/B _6812_/C VGND VGND VPWR VPWR _6812_/X sky130_fd_sc_hd__and3_2
XFILLER_23_337 VGND VGND VPWR VPWR sky130_fd_sc_hd__decap_3
XFILLER_35_175 VGND VGND VPWR VPWR sky130_fd_sc_hd__decap_3
XFILLER_50_112 VGND VGND VPWR VPWR sky130_fd_sc_hd__fill_1
XFILLER_90_281 VGND VGND VPWR VPWR sky130_fd_sc_hd__decap_3
XTAP_TAPCELL_ROW_74_991 VGND VPWR sky130_fd_sc_hd__tapvpwrvgnd_1
X_6743_ _6960_/A _6372_/A _6294_/Y VGND VGND VPWR VPWR _6743_/X sky130_fd_sc_hd__a21o_2
X_3955_ _3955_/A _3996_/B _4003_/C _6175_/A VGND VGND VPWR VPWR _3955_/X sky130_fd_sc_hd__and4_2
XFILLER_50_189 VGND VGND VPWR VPWR sky130_fd_sc_hd__fill_1
X_6674_ _6606_/X _6673_/X _6783_/S VGND VGND VPWR VPWR _6674_/X sky130_fd_sc_hd__mux2_1
X_5625_ _6123_/A _5695_/C _5725_/C _5779_/A VGND VGND VPWR VPWR _5626_/C sky130_fd_sc_hd__a22o_2
X_3886_ _3886_/A _3886_/B VGND VGND VPWR VPWR _3888_/A sky130_fd_sc_hd__xnor2_2
X_5556_ _5557_/B _5557_/C _5557_/A VGND VGND VPWR VPWR _5562_/A sky130_fd_sc_hd__a21oi_2
XFILLER_2_208 VGND VGND VPWR VPWR sky130_fd_sc_hd__fill_2
X_5487_ _5502_/A _5487_/B VGND VGND VPWR VPWR _5503_/B sky130_fd_sc_hd__nand2_2
X_4507_ _4607_/B _6019_/A _6019_/C _4608_/A VGND VGND VPWR VPWR _4509_/C sky130_fd_sc_hd__a22oi_2
X_4438_ _4382_/A _4383_/X _4436_/A _4436_/Y VGND VGND VPWR VPWR _4441_/B sky130_fd_sc_hd__o211ai_2
Xfanout501 _6621_/A2 VGND VGND VPWR VPWR _6214_/B sky130_fd_sc_hd__dlymetal6s2s_1
Xfanout512 wire514/A VGND VGND VPWR VPWR _5502_/A sky130_fd_sc_hd__buf_4
Xfanout523 _6621_/A3 VGND VGND VPWR VPWR _5707_/A sky130_fd_sc_hd__dlymetal6s2s_1
XFILLER_58_212 VGND VGND VPWR VPWR sky130_fd_sc_hd__decap_3
Xfanout534 _4694_/A VGND VGND VPWR VPWR _5329_/A sky130_fd_sc_hd__buf_6
Xfanout556 _6002_/A1 VGND VGND VPWR VPWR wire557/A sky130_fd_sc_hd__clkdlybuf4s25_1
X_4369_ _4370_/A _4370_/B _4370_/C VGND VGND VPWR VPWR _4373_/B sky130_fd_sc_hd__and3_2
XFILLER_58_245 VGND VGND VPWR VPWR sky130_fd_sc_hd__decap_3
XFILLER_58_256 VGND VGND VPWR VPWR sky130_fd_sc_hd__decap_3
Xfanout567 wire573/A VGND VGND VPWR VPWR _6552_/A2 sky130_fd_sc_hd__buf_4
Xfanout578 _4685_/A VGND VGND VPWR VPWR _5382_/A sky130_fd_sc_hd__buf_6
X_6108_ _6108_/A _6108_/B VGND VGND VPWR VPWR _6635_/A sky130_fd_sc_hd__or2_2
XFILLER_58_289 VGND VGND VPWR VPWR sky130_fd_sc_hd__fill_2
XFILLER_73_215 VGND VGND VPWR VPWR sky130_fd_sc_hd__decap_3
X_6039_ _6039_/A _6039_/B VGND VGND VPWR VPWR _6047_/A sky130_fd_sc_hd__nor2_2
XFILLER_73_259 VGND VGND VPWR VPWR sky130_fd_sc_hd__decap_3
XTAP_TAPCELL_ROW_1_230 VGND VPWR sky130_fd_sc_hd__tapvpwrvgnd_1
XFILLER_54_451 VGND VGND VPWR VPWR sky130_fd_sc_hd__decap_3
XFILLER_14_315 VGND VGND VPWR VPWR sky130_fd_sc_hd__decap_3
XFILLER_14_337 VGND VGND VPWR VPWR sky130_fd_sc_hd__fill_1
XFILLER_25_54 VGND VGND VPWR VPWR sky130_fd_sc_hd__fill_2
XFILLER_26_197 VGND VGND VPWR VPWR sky130_fd_sc_hd__decap_3
XFILLER_41_123 VGND VGND VPWR VPWR sky130_fd_sc_hd__decap_3
XFILLER_81_281 VGND VGND VPWR VPWR sky130_fd_sc_hd__decap_3
XFILLER_41_167 VGND VGND VPWR VPWR sky130_fd_sc_hd__fill_1
XFILLER_96_318 VGND VGND VPWR VPWR sky130_fd_sc_hd__decap_3
XFILLER_1_263 VGND VGND VPWR VPWR sky130_fd_sc_hd__decap_3
XFILLER_1_296 VGND VGND VPWR VPWR sky130_fd_sc_hd__decap_3
XFILLER_2_58 VGND VGND VPWR VPWR sky130_fd_sc_hd__fill_2
XFILLER_49_234 VGND VGND VPWR VPWR sky130_fd_sc_hd__decap_3
XFILLER_49_267 VGND VGND VPWR VPWR sky130_fd_sc_hd__decap_3
XFILLER_64_215 VGND VGND VPWR VPWR sky130_fd_sc_hd__decap_3
XFILLER_77_576 VGND VGND VPWR VPWR sky130_fd_sc_hd__fill_2
XFILLER_64_248 VGND VGND VPWR VPWR sky130_fd_sc_hd__decap_3
XFILLER_64_259 VGND VGND VPWR VPWR sky130_fd_sc_hd__decap_3
XFILLER_92_546 VGND VGND VPWR VPWR sky130_fd_sc_hd__decap_3
XFILLER_60_421 VGND VGND VPWR VPWR sky130_fd_sc_hd__decap_3
XFILLER_32_134 VGND VGND VPWR VPWR sky130_fd_sc_hd__decap_3
XFILLER_60_454 VGND VGND VPWR VPWR sky130_fd_sc_hd__decap_3
XFILLER_82_82 VGND VGND VPWR VPWR sky130_fd_sc_hd__fill_2
XTAP_TAPCELL_ROW_71_961 VGND VPWR sky130_fd_sc_hd__tapvpwrvgnd_1
X_3740_ _4659_/A _4387_/C _4387_/D _4518_/A VGND VGND VPWR VPWR _3741_/D sky130_fd_sc_hd__a22o_2
XTAP_TAPCELL_ROW_15_376 VGND VPWR sky130_fd_sc_hd__tapvpwrvgnd_1
X_3671_ _3672_/A _3672_/B VGND VGND VPWR VPWR _3724_/B sky130_fd_sc_hd__and2_2
XFILLER_63_3 VGND VGND VPWR VPWR sky130_fd_sc_hd__decap_3
X_6390_ _6498_/A _6390_/B VGND VGND VPWR VPWR _6730_/B sky130_fd_sc_hd__nand2_2
X_5410_ _5410_/A _5410_/B VGND VGND VPWR VPWR _5412_/A sky130_fd_sc_hd__xnor2_2
X_5341_ _5341_/A _5341_/B _5341_/C _5341_/D VGND VGND VPWR VPWR _5341_/X sky130_fd_sc_hd__and4_2
XFILLER_5_591 VGND VGND VPWR VPWR sky130_fd_sc_hd__decap_3
XFILLER_87_307 VGND VGND VPWR VPWR sky130_fd_sc_hd__decap_3
X_5272_ _5272_/A _5272_/B VGND VGND VPWR VPWR _5273_/C sky130_fd_sc_hd__xnor2_2
XFILLER_99_178 VGND VGND VPWR VPWR sky130_fd_sc_hd__decap_3
X_4223_ _4228_/B _4223_/B _4223_/C VGND VGND VPWR VPWR _4348_/A sky130_fd_sc_hd__or3_2
X_4154_ _3760_/A _3760_/C _3760_/B VGND VGND VPWR VPWR _4155_/C sky130_fd_sc_hd__a21o_2
XFILLER_28_418 VGND VGND VPWR VPWR sky130_fd_sc_hd__fill_2
XFILLER_55_204 VGND VGND VPWR VPWR sky130_fd_sc_hd__decap_3
XFILLER_83_513 VGND VGND VPWR VPWR sky130_fd_sc_hd__decap_3
X_4085_ _4075_/A _4075_/B _4075_/C VGND VGND VPWR VPWR _4085_/Y sky130_fd_sc_hd__a21oi_2
XFILLER_95_373 VGND VGND VPWR VPWR sky130_fd_sc_hd__decap_3
XTAP_TAPCELL_ROW_87_1127 VGND VPWR sky130_fd_sc_hd__tapvpwrvgnd_1
XFILLER_70_218 VGND VGND VPWR VPWR sky130_fd_sc_hd__decap_3
XFILLER_36_473 VGND VGND VPWR VPWR sky130_fd_sc_hd__decap_3
XFILLER_63_270 VGND VGND VPWR VPWR sky130_fd_sc_hd__decap_3
XFILLER_63_281 VGND VGND VPWR VPWR sky130_fd_sc_hd__decap_3
XFILLER_11_318 VGND VGND VPWR VPWR sky130_fd_sc_hd__decap_3
XFILLER_51_476 VGND VGND VPWR VPWR sky130_fd_sc_hd__decap_3
X_6726_ _6709_/A _6709_/B _3597_/A VGND VGND VPWR VPWR _6727_/B sky130_fd_sc_hd__o21ai_2
X_4987_ _5162_/A _4985_/B _5066_/B _4984_/X VGND VGND VPWR VPWR _4988_/B sky130_fd_sc_hd__a31o_2
X_3938_ _3938_/A _3938_/B _3938_/C VGND VGND VPWR VPWR _3940_/A sky130_fd_sc_hd__nor3_2
X_6657_ _6656_/X _6657_/B VGND VGND VPWR VPWR _6657_/X sky130_fd_sc_hd__and2b_2
X_3869_ _6275_/B _6929_/A _6175_/B _3869_/D VGND VGND VPWR VPWR _3871_/A sky130_fd_sc_hd__and4_2
XTAP_TAPCELL_ROW_98_1245 VGND VPWR sky130_fd_sc_hd__tapvpwrvgnd_1
XFILLER_11_12 VGND VGND VPWR VPWR sky130_fd_sc_hd__decap_3
X_6588_ _6589_/A _6588_/B VGND VGND VPWR VPWR _6867_/B sky130_fd_sc_hd__nand2_2
X_5608_ _5608_/A _5608_/B _5602_/X VGND VGND VPWR VPWR _5608_/Y sky130_fd_sc_hd__nor3b_2
X_5539_ _5540_/A _5540_/B VGND VGND VPWR VPWR _5539_/Y sky130_fd_sc_hd__nand2_2
XFILLER_78_318 VGND VGND VPWR VPWR sky130_fd_sc_hd__decap_3
XFILLER_87_38 VGND VGND VPWR VPWR sky130_fd_sc_hd__decap_3
Xfanout331 input47/X VGND VGND VPWR VPWR _4334_/C sky130_fd_sc_hd__dlymetal6s4s_1
Xfanout353 _6831_/S VGND VGND VPWR VPWR _3868_/B sky130_fd_sc_hd__dlymetal6s4s_1
XFILLER_19_429 VGND VGND VPWR VPWR sky130_fd_sc_hd__decap_3
XFILLER_46_215 VGND VGND VPWR VPWR sky130_fd_sc_hd__decap_3
XFILLER_74_524 VGND VGND VPWR VPWR sky130_fd_sc_hd__decap_3
Xfanout386 _4482_/C VGND VGND VPWR VPWR _4616_/C sky130_fd_sc_hd__dlymetal6s2s_1
Xfanout397 _6711_/A2 VGND VGND VPWR VPWR _5983_/B sky130_fd_sc_hd__clkdlybuf4s25_1
XFILLER_46_237 VGND VGND VPWR VPWR sky130_fd_sc_hd__decap_3
XFILLER_86_395 VGND VGND VPWR VPWR sky130_fd_sc_hd__decap_3
XFILLER_36_53 VGND VGND VPWR VPWR sky130_fd_sc_hd__decap_3
XFILLER_74_568 VGND VGND VPWR VPWR sky130_fd_sc_hd__decap_3
XFILLER_14_101 VGND VGND VPWR VPWR sky130_fd_sc_hd__decap_3
XFILLER_27_473 VGND VGND VPWR VPWR sky130_fd_sc_hd__fill_1
XFILLER_42_421 VGND VGND VPWR VPWR sky130_fd_sc_hd__decap_3
XFILLER_14_156 VGND VGND VPWR VPWR sky130_fd_sc_hd__decap_3
XFILLER_52_85 VGND VGND VPWR VPWR sky130_fd_sc_hd__decap_3
XTAP_TAPCELL_ROW_40_633 VGND VPWR sky130_fd_sc_hd__tapvpwrvgnd_1
Xinput17 A[24] VGND VGND VPWR VPWR input17/X sky130_fd_sc_hd__clkdlybuf4s25_1
Xinput28 A[5] VGND VGND VPWR VPWR input28/X sky130_fd_sc_hd__buf_4
XTAP_TAPCELL_ROW_12_346 VGND VPWR sky130_fd_sc_hd__tapvpwrvgnd_1
Xinput39 B[15] VGND VGND VPWR VPWR input39/X sky130_fd_sc_hd__clkbuf_2
XFILLER_77_82 VGND VGND VPWR VPWR sky130_fd_sc_hd__decap_3
XFILLER_37_215 VGND VGND VPWR VPWR sky130_fd_sc_hd__decap_3
XFILLER_77_384 VGND VGND VPWR VPWR sky130_fd_sc_hd__decap_3
XFILLER_65_557 VGND VGND VPWR VPWR sky130_fd_sc_hd__decap_3
XFILLER_92_332 VGND VGND VPWR VPWR sky130_fd_sc_hd__decap_3
XTAP_TAPCELL_ROW_48_722 VGND VPWR sky130_fd_sc_hd__tapvpwrvgnd_1
XFILLER_18_462 VGND VGND VPWR VPWR sky130_fd_sc_hd__fill_1
XFILLER_80_505 VGND VGND VPWR VPWR sky130_fd_sc_hd__decap_3
XFILLER_92_365 VGND VGND VPWR VPWR sky130_fd_sc_hd__decap_3
XFILLER_18_473 VGND VGND VPWR VPWR sky130_fd_sc_hd__decap_3
XFILLER_18_495 VGND VGND VPWR VPWR sky130_fd_sc_hd__decap_3
XFILLER_45_281 VGND VGND VPWR VPWR sky130_fd_sc_hd__decap_3
XFILLER_52_218 VGND VGND VPWR VPWR sky130_fd_sc_hd__decap_3
XFILLER_80_527 VGND VGND VPWR VPWR sky130_fd_sc_hd__decap_3
XFILLER_80_549 VGND VGND VPWR VPWR sky130_fd_sc_hd__decap_3
X_5890_ _5888_/B _5891_/C1 _5890_/B1 _5883_/Y VGND VGND VPWR VPWR _5892_/B sky130_fd_sc_hd__o211ai_2
X_4910_ _4906_/Y _4908_/X _4868_/A _4870_/B VGND VGND VPWR VPWR _4911_/D sky130_fd_sc_hd__o211ai_2
XFILLER_93_70 VGND VGND VPWR VPWR sky130_fd_sc_hd__fill_2
XFILLER_33_443 VGND VGND VPWR VPWR sky130_fd_sc_hd__decap_3
XFILLER_60_240 VGND VGND VPWR VPWR sky130_fd_sc_hd__decap_3
X_4841_ _4841_/A _4841_/B _4841_/C VGND VGND VPWR VPWR _4845_/A sky130_fd_sc_hd__and3_2
XFILLER_60_262 VGND VGND VPWR VPWR sky130_fd_sc_hd__decap_3
XTAP_TAPCELL_ROW_82_1079 VGND VPWR sky130_fd_sc_hd__tapvpwrvgnd_1
XFILLER_20_137 VGND VGND VPWR VPWR sky130_fd_sc_hd__decap_3
X_4772_ _4808_/B _4771_/C _4771_/A VGND VGND VPWR VPWR _4773_/C sky130_fd_sc_hd__a21o_2
X_6511_ _6372_/B _6505_/X _6509_/Y _6510_/X _6498_/X VGND VGND VPWR VPWR _6512_/C
+ sky130_fd_sc_hd__a2111o_2
X_3723_ _3723_/A _3723_/B _3723_/C VGND VGND VPWR VPWR _3747_/A sky130_fd_sc_hd__nand3_2
X_6442_ _6126_/Y _6441_/B _6853_/A VGND VGND VPWR VPWR _6442_/X sky130_fd_sc_hd__a21o_2
X_3654_ _3652_/A _3652_/B _3652_/C VGND VGND VPWR VPWR _3674_/B sky130_fd_sc_hd__a21oi_2
X_6373_ _6373_/A _6373_/B VGND VGND VPWR VPWR _6375_/B sky130_fd_sc_hd__or2_2
X_3585_ _3585_/A _5983_/B _3814_/C _3814_/D VGND VGND VPWR VPWR _3590_/A sky130_fd_sc_hd__and4_2
X_5324_ _5321_/X _5324_/B VGND VGND VPWR VPWR _5572_/B sky130_fd_sc_hd__and2b_2
X_5255_ _5174_/Y _5253_/X _5252_/X _5250_/X VGND VGND VPWR VPWR _5255_/X sky130_fd_sc_hd__o211a_2
XTAP_TAPCELL_ROW_93_1197 VGND VPWR sky130_fd_sc_hd__tapvpwrvgnd_1
XFILLER_87_159 VGND VGND VPWR VPWR sky130_fd_sc_hd__decap_3
X_4206_ _4197_/A _4197_/C _4197_/B VGND VGND VPWR VPWR _4206_/X sky130_fd_sc_hd__o21a_2
XFILLER_56_502 VGND VGND VPWR VPWR sky130_fd_sc_hd__decap_3
X_5186_ _5186_/A _5186_/B VGND VGND VPWR VPWR _5187_/B sky130_fd_sc_hd__nand2_2
XFILLER_56_546 VGND VGND VPWR VPWR sky130_fd_sc_hd__decap_3
X_4137_ _4132_/Y _4228_/A _4113_/X _4114_/Y VGND VGND VPWR VPWR _4139_/C sky130_fd_sc_hd__a211oi_2
XFILLER_71_505 VGND VGND VPWR VPWR sky130_fd_sc_hd__decap_3
XFILLER_83_365 VGND VGND VPWR VPWR sky130_fd_sc_hd__decap_3
X_4068_ _4068_/A _4108_/A VGND VGND VPWR VPWR _4070_/B sky130_fd_sc_hd__xor2_2
XFILLER_24_421 VGND VGND VPWR VPWR sky130_fd_sc_hd__decap_3
XFILLER_24_465 VGND VGND VPWR VPWR sky130_fd_sc_hd__decap_3
XFILLER_51_284 VGND VGND VPWR VPWR sky130_fd_sc_hd__decap_3
XFILLER_11_148 VGND VGND VPWR VPWR sky130_fd_sc_hd__decap_3
XFILLER_7_108 VGND VGND VPWR VPWR sky130_fd_sc_hd__decap_3
X_6709_ _6709_/A _6709_/B VGND VGND VPWR VPWR _6709_/Y sky130_fd_sc_hd__xnor2_2
XFILLER_22_44 VGND VGND VPWR VPWR sky130_fd_sc_hd__decap_3
XFILLER_22_66 VGND VGND VPWR VPWR sky130_fd_sc_hd__decap_3
XFILLER_59_340 VGND VGND VPWR VPWR sky130_fd_sc_hd__decap_3
XFILLER_78_137 VGND VGND VPWR VPWR sky130_fd_sc_hd__decap_3
XFILLER_78_159 VGND VGND VPWR VPWR sky130_fd_sc_hd__decap_3
XFILLER_59_373 VGND VGND VPWR VPWR sky130_fd_sc_hd__decap_3
Xfanout150 _6932_/B VGND VGND VPWR VPWR _6853_/A sky130_fd_sc_hd__clkdlybuf4s25_1
Xfanout172 fanout174/X VGND VGND VPWR VPWR _6848_/S sky130_fd_sc_hd__clkdlybuf4s25_1
XFILLER_47_41 VGND VGND VPWR VPWR sky130_fd_sc_hd__fill_2
XFILLER_74_321 VGND VGND VPWR VPWR sky130_fd_sc_hd__decap_3
XFILLER_86_192 VGND VGND VPWR VPWR sky130_fd_sc_hd__decap_3
Xfanout194 fanout194/A VGND VGND VPWR VPWR _6025_/B sky130_fd_sc_hd__clkdlybuf4s25_1
XFILLER_19_259 VGND VGND VPWR VPWR sky130_fd_sc_hd__decap_3
XFILLER_47_96 VGND VGND VPWR VPWR sky130_fd_sc_hd__decap_3
XFILLER_34_218 VGND VGND VPWR VPWR sky130_fd_sc_hd__decap_3
XFILLER_62_549 VGND VGND VPWR VPWR sky130_fd_sc_hd__decap_3
XFILLER_63_51 VGND VGND VPWR VPWR sky130_fd_sc_hd__decap_3
XFILLER_42_251 VGND VGND VPWR VPWR sky130_fd_sc_hd__fill_1
XFILLER_63_84 VGND VGND VPWR VPWR sky130_fd_sc_hd__decap_3
XFILLER_97_9 VGND VGND VPWR VPWR sky130_fd_sc_hd__fill_2
XFILLER_30_424 VGND VGND VPWR VPWR sky130_fd_sc_hd__fill_1
XTAP_TAPCELL_ROW_25_482 VGND VPWR sky130_fd_sc_hd__tapvpwrvgnd_1
XFILLER_30_457 VGND VGND VPWR VPWR sky130_fd_sc_hd__decap_3
XFILLER_8_35 VGND VGND VPWR VPWR sky130_fd_sc_hd__decap_3
XFILLER_6_152 VGND VGND VPWR VPWR sky130_fd_sc_hd__decap_3
Xwire573 wire573/A VGND VGND VPWR VPWR _4006_/A sky130_fd_sc_hd__buf_4
XFILLER_88_81 VGND VGND VPWR VPWR sky130_fd_sc_hd__decap_3
XFILLER_2_391 VGND VGND VPWR VPWR sky130_fd_sc_hd__decap_3
XFILLER_69_137 VGND VGND VPWR VPWR sky130_fd_sc_hd__decap_3
XFILLER_69_159 VGND VGND VPWR VPWR sky130_fd_sc_hd__decap_3
X_5040_ _5038_/X _5040_/B VGND VGND VPWR VPWR _5104_/A sky130_fd_sc_hd__and2b_2
XFILLER_97_446 VGND VGND VPWR VPWR sky130_fd_sc_hd__fill_2
XFILLER_38_513 VGND VGND VPWR VPWR sky130_fd_sc_hd__decap_3
XFILLER_65_321 VGND VGND VPWR VPWR sky130_fd_sc_hd__fill_1
XFILLER_38_568 VGND VGND VPWR VPWR sky130_fd_sc_hd__decap_3
XFILLER_53_505 VGND VGND VPWR VPWR sky130_fd_sc_hd__decap_3
XFILLER_65_343 VGND VGND VPWR VPWR sky130_fd_sc_hd__decap_3
X_6991_ _6991_/A _6991_/B _6991_/C VGND VGND VPWR VPWR _6992_/D sky130_fd_sc_hd__or3_4
XFILLER_53_538 VGND VGND VPWR VPWR sky130_fd_sc_hd__fill_1
XFILLER_80_302 VGND VGND VPWR VPWR sky130_fd_sc_hd__decap_3
X_5942_ _4204_/A _4204_/B _4202_/X VGND VGND VPWR VPWR _6057_/A sky130_fd_sc_hd__a21oi_2
XFILLER_80_357 VGND VGND VPWR VPWR sky130_fd_sc_hd__decap_3
XFILLER_80_368 VGND VGND VPWR VPWR sky130_fd_sc_hd__decap_3
XFILLER_33_240 VGND VGND VPWR VPWR sky130_fd_sc_hd__decap_3
X_5873_ _5871_/B _6754_/B _5871_/A VGND VGND VPWR VPWR _6775_/B sky130_fd_sc_hd__o21ba_2
XFILLER_61_593 VGND VGND VPWR VPWR sky130_fd_sc_hd__decap_3
X_4824_ _6254_/B _4782_/B _4791_/B _4789_/X VGND VGND VPWR VPWR _4825_/B sky130_fd_sc_hd__a31o_2
Xrebuffer706 _5511_/X VGND VGND VPWR VPWR _5517_/C1 sky130_fd_sc_hd__buf_2
X_4755_ _5054_/A _4965_/A _4755_/C _4755_/D VGND VGND VPWR VPWR _4758_/A sky130_fd_sc_hd__nand4_2
Xrebuffer717 _5081_/A VGND VGND VPWR VPWR _5165_/A1 sky130_fd_sc_hd__buf_2
Xrebuffer728 _5464_/X VGND VGND VPWR VPWR _5466_/B sky130_fd_sc_hd__buf_4
Xrebuffer739 _5856_/B VGND VGND VPWR VPWR _5843_/B sky130_fd_sc_hd__buf_2
X_3706_ _3706_/A _3708_/A _3706_/C VGND VGND VPWR VPWR _3706_/X sky130_fd_sc_hd__and3_2
X_4686_ _4925_/A _4925_/C _4685_/D _4685_/A VGND VGND VPWR VPWR _4686_/Y sky130_fd_sc_hd__a22oi_2
XTAP_TAPCELL_ROW_95_1215 VGND VPWR sky130_fd_sc_hd__tapvpwrvgnd_1
X_6425_ _6391_/Y _6770_/B _6730_/B VGND VGND VPWR VPWR _6425_/Y sky130_fd_sc_hd__o21ai_2
X_3637_ _3613_/B _3611_/C _3611_/B VGND VGND VPWR VPWR _3652_/B sky130_fd_sc_hd__a21o_2
X_6356_ _6673_/A2 _6105_/A _6401_/S VGND VGND VPWR VPWR _6356_/X sky130_fd_sc_hd__mux2_1
X_3568_ _3567_/B _3567_/C _3567_/A VGND VGND VPWR VPWR _3584_/B sky130_fd_sc_hd__a21o_2
XFILLER_88_402 VGND VGND VPWR VPWR sky130_fd_sc_hd__fill_2
XFILLER_88_424 VGND VGND VPWR VPWR sky130_fd_sc_hd__decap_3
X_5307_ _5383_/A _5134_/B _5382_/D _5329_/A VGND VGND VPWR VPWR _5308_/C sky130_fd_sc_hd__a22oi_2
XFILLER_88_468 VGND VGND VPWR VPWR sky130_fd_sc_hd__decap_3
X_6287_ _6970_/A _6285_/X _6286_/X VGND VGND VPWR VPWR _6290_/B sky130_fd_sc_hd__a21boi_2
X_3499_ _6498_/A VGND VGND VPWR VPWR _3499_/Y sky130_fd_sc_hd__inv_2
XFILLER_29_502 VGND VGND VPWR VPWR sky130_fd_sc_hd__fill_2
X_5238_ _5238_/A _5238_/B VGND VGND VPWR VPWR _5240_/B sky130_fd_sc_hd__xnor2_2
XFILLER_68_170 VGND VGND VPWR VPWR sky130_fd_sc_hd__decap_3
X_5169_ _5166_/X _5167_/Y _5146_/X _5245_/A1 VGND VGND VPWR VPWR _5170_/C sky130_fd_sc_hd__a211o_4
XTAP_TAPCELL_ROW_59_839 VGND VPWR sky130_fd_sc_hd__tapvpwrvgnd_1
XFILLER_29_557 VGND VGND VPWR VPWR sky130_fd_sc_hd__decap_3
XFILLER_56_365 VGND VGND VPWR VPWR sky130_fd_sc_hd__decap_3
XFILLER_83_140 VGND VGND VPWR VPWR sky130_fd_sc_hd__decap_3
XFILLER_71_302 VGND VGND VPWR VPWR sky130_fd_sc_hd__decap_3
XFILLER_71_346 VGND VGND VPWR VPWR sky130_fd_sc_hd__decap_3
XFILLER_83_195 VGND VGND VPWR VPWR sky130_fd_sc_hd__decap_3
XFILLER_24_251 VGND VGND VPWR VPWR sky130_fd_sc_hd__fill_1
XFILLER_12_424 VGND VGND VPWR VPWR sky130_fd_sc_hd__decap_3
XFILLER_12_457 VGND VGND VPWR VPWR sky130_fd_sc_hd__decap_3
XFILLER_8_417 VGND VGND VPWR VPWR sky130_fd_sc_hd__decap_3
XTAP_TAPCELL_ROW_22_452 VGND VPWR sky130_fd_sc_hd__tapvpwrvgnd_1
XFILLER_3_133 VGND VGND VPWR VPWR sky130_fd_sc_hd__decap_3
XFILLER_79_402 VGND VGND VPWR VPWR sky130_fd_sc_hd__decap_3
XFILLER_79_435 VGND VGND VPWR VPWR sky130_fd_sc_hd__decap_3
XFILLER_79_479 VGND VGND VPWR VPWR sky130_fd_sc_hd__decap_3
XFILLER_94_427 VGND VGND VPWR VPWR sky130_fd_sc_hd__decap_3
XFILLER_94_405 VGND VGND VPWR VPWR sky130_fd_sc_hd__decap_3
XFILLER_12_9 VGND VGND VPWR VPWR sky130_fd_sc_hd__fill_2
XFILLER_47_310 VGND VGND VPWR VPWR sky130_fd_sc_hd__decap_3
XFILLER_35_505 VGND VGND VPWR VPWR sky130_fd_sc_hd__decap_3
XFILLER_62_302 VGND VGND VPWR VPWR sky130_fd_sc_hd__decap_3
XFILLER_62_324 VGND VGND VPWR VPWR sky130_fd_sc_hd__decap_3
XFILLER_74_162 VGND VGND VPWR VPWR sky130_fd_sc_hd__decap_3
XFILLER_74_195 VGND VGND VPWR VPWR sky130_fd_sc_hd__fill_1
XFILLER_74_72 VGND VGND VPWR VPWR sky130_fd_sc_hd__decap_3
XFILLER_74_83 VGND VGND VPWR VPWR sky130_fd_sc_hd__fill_1
XFILLER_15_273 VGND VGND VPWR VPWR sky130_fd_sc_hd__decap_3
XFILLER_30_221 VGND VGND VPWR VPWR sky130_fd_sc_hd__decap_3
XFILLER_30_243 VGND VGND VPWR VPWR sky130_fd_sc_hd__decap_3
X_4540_ _4538_/A _4978_/C _4978_/D _6254_/B VGND VGND VPWR VPWR _4541_/B sky130_fd_sc_hd__a22o_2
Xmax_cap114 _5086_/Y VGND VGND VPWR VPWR _5089_/C sky130_fd_sc_hd__clkbuf_2
X_4471_ _4473_/A _4473_/C _4473_/B VGND VGND VPWR VPWR _4471_/Y sky130_fd_sc_hd__a21oi_2
X_6210_ _6386_/A VGND VGND VPWR VPWR _6210_/Y sky130_fd_sc_hd__inv_2
XFILLER_99_91 VGND VGND VPWR VPWR sky130_fd_sc_hd__decap_3
X_6141_ _6141_/A _6141_/B VGND VGND VPWR VPWR _6655_/A sky130_fd_sc_hd__nand2_2
Xload_slew320 _5374_/A VGND VGND VPWR VPWR _3664_/A sky130_fd_sc_hd__buf_4
XFILLER_97_232 VGND VGND VPWR VPWR sky130_fd_sc_hd__decap_3
XFILLER_85_405 VGND VGND VPWR VPWR sky130_fd_sc_hd__decap_3
Xload_slew364 _6453_/S VGND VGND VPWR VPWR _6876_/S1 sky130_fd_sc_hd__clkbuf_4
Xload_slew342 _3574_/A2 VGND VGND VPWR VPWR _6266_/A sky130_fd_sc_hd__buf_4
X_6072_ _6073_/A _6205_/A VGND VGND VPWR VPWR _6074_/A sky130_fd_sc_hd__nand2_2
XTAP_TAPCELL_ROW_90_1167 VGND VPWR sky130_fd_sc_hd__tapvpwrvgnd_1
XFILLER_57_129 VGND VGND VPWR VPWR sky130_fd_sc_hd__decap_3
XFILLER_78_490 VGND VGND VPWR VPWR sky130_fd_sc_hd__decap_3
XFILLER_85_449 VGND VGND VPWR VPWR sky130_fd_sc_hd__decap_3
Xload_slew375 _3638_/D VGND VGND VPWR VPWR _4646_/C sky130_fd_sc_hd__buf_4
X_5023_ _5023_/A _5023_/B VGND VGND VPWR VPWR _5107_/B sky130_fd_sc_hd__xnor2_2
XFILLER_65_140 VGND VGND VPWR VPWR sky130_fd_sc_hd__decap_3
XTAP_TAPCELL_ROW_56_809 VGND VPWR sky130_fd_sc_hd__tapvpwrvgnd_1
XFILLER_38_365 VGND VGND VPWR VPWR sky130_fd_sc_hd__decap_3
XFILLER_93_482 VGND VGND VPWR VPWR sky130_fd_sc_hd__decap_3
XFILLER_0_80 VGND VGND VPWR VPWR sky130_fd_sc_hd__decap_3
XFILLER_53_346 VGND VGND VPWR VPWR sky130_fd_sc_hd__decap_3
XFILLER_65_184 VGND VGND VPWR VPWR sky130_fd_sc_hd__fill_2
X_6974_ _6303_/Y _6848_/X _6715_/Y VGND VGND VPWR VPWR _6974_/X sky130_fd_sc_hd__a21bo_2
XFILLER_41_508 VGND VGND VPWR VPWR sky130_fd_sc_hd__decap_3
X_5925_ _4565_/B _5919_/X _5921_/Y _5927_/A VGND VGND VPWR VPWR _5934_/B sky130_fd_sc_hd__o211a_2
XTAP_TAPCELL_ROW_64_886 VGND VPWR sky130_fd_sc_hd__tapvpwrvgnd_1
XFILLER_61_390 VGND VGND VPWR VPWR sky130_fd_sc_hd__fill_2
X_5856_ _5856_/A _5856_/B _5855_/B _5874_/B VGND VGND VPWR VPWR _5856_/X sky130_fd_sc_hd__or4bb_4
XTAP_TAPCELL_ROW_36_599 VGND VPWR sky130_fd_sc_hd__tapvpwrvgnd_1
XFILLER_21_254 VGND VGND VPWR VPWR sky130_fd_sc_hd__decap_3
X_4807_ _4675_/A _4674_/B _4672_/X VGND VGND VPWR VPWR _4816_/A sky130_fd_sc_hd__a21o_2
XPHY_EDGE_ROW_3_Right_3 VGND VGND VPWR VPWR sky130_fd_sc_hd__decap_3
XFILLER_21_287 VGND VGND VPWR VPWR sky130_fd_sc_hd__fill_2
X_5787_ _5784_/B _5787_/B VGND VGND VPWR VPWR _5788_/B sky130_fd_sc_hd__and2b_2
X_4738_ _5151_/B _4767_/A _4738_/C _4755_/D VGND VGND VPWR VPWR _4764_/A sky130_fd_sc_hd__nand4_2
X_4669_ _4669_/A _4669_/B _4669_/C VGND VGND VPWR VPWR _4700_/A sky130_fd_sc_hd__or3_2
X_6408_ _6393_/Y _6407_/X _6353_/X _6388_/Y VGND VGND VPWR VPWR _6990_/A sky130_fd_sc_hd__a211o_2
XFILLER_88_221 VGND VGND VPWR VPWR sky130_fd_sc_hd__decap_3
X_6339_ _6506_/B VGND VGND VPWR VPWR _6339_/Y sky130_fd_sc_hd__inv_2
XFILLER_0_169 VGND VGND VPWR VPWR sky130_fd_sc_hd__decap_3
XFILLER_88_276 VGND VGND VPWR VPWR sky130_fd_sc_hd__decap_3
XFILLER_48_118 VGND VGND VPWR VPWR sky130_fd_sc_hd__decap_3
XFILLER_17_505 VGND VGND VPWR VPWR sky130_fd_sc_hd__decap_3
XFILLER_17_538 VGND VGND VPWR VPWR sky130_fd_sc_hd__decap_3
XFILLER_28_76 VGND VGND VPWR VPWR sky130_fd_sc_hd__decap_3
XFILLER_29_387 VGND VGND VPWR VPWR sky130_fd_sc_hd__decap_3
XFILLER_56_162 VGND VGND VPWR VPWR sky130_fd_sc_hd__decap_3
XFILLER_84_460 VGND VGND VPWR VPWR sky130_fd_sc_hd__decap_3
XTAP_TAPCELL_ROW_27_500 VGND VPWR sky130_fd_sc_hd__tapvpwrvgnd_1
XFILLER_56_195 VGND VGND VPWR VPWR sky130_fd_sc_hd__fill_1
XFILLER_71_110 VGND VGND VPWR VPWR sky130_fd_sc_hd__fill_2
XFILLER_32_508 VGND VGND VPWR VPWR sky130_fd_sc_hd__fill_1
XFILLER_44_368 VGND VGND VPWR VPWR sky130_fd_sc_hd__fill_2
XFILLER_44_379 VGND VGND VPWR VPWR sky130_fd_sc_hd__decap_3
XFILLER_44_64 VGND VGND VPWR VPWR sky130_fd_sc_hd__decap_3
XFILLER_71_187 VGND VGND VPWR VPWR sky130_fd_sc_hd__decap_3
XFILLER_40_541 VGND VGND VPWR VPWR sky130_fd_sc_hd__decap_3
XFILLER_100_81 VGND VGND VPWR VPWR sky130_fd_sc_hd__decap_3
XFILLER_8_236 VGND VGND VPWR VPWR sky130_fd_sc_hd__decap_3
XFILLER_60_52 VGND VGND VPWR VPWR sky130_fd_sc_hd__decap_3
XFILLER_4_475 VGND VGND VPWR VPWR sky130_fd_sc_hd__fill_1
XFILLER_5_69 VGND VGND VPWR VPWR sky130_fd_sc_hd__decap_3
XFILLER_79_221 VGND VGND VPWR VPWR sky130_fd_sc_hd__decap_3
XFILLER_79_276 VGND VGND VPWR VPWR sky130_fd_sc_hd__decap_3
XFILLER_39_129 VGND VGND VPWR VPWR sky130_fd_sc_hd__fill_1
XFILLER_67_449 VGND VGND VPWR VPWR sky130_fd_sc_hd__fill_2
XTAP_TAPCELL_ROW_7_291 VGND VPWR sky130_fd_sc_hd__tapvpwrvgnd_1
XFILLER_10_6 VGND VGND VPWR VPWR sky130_fd_sc_hd__decap_3
XFILLER_82_408 VGND VGND VPWR VPWR sky130_fd_sc_hd__decap_3
XFILLER_85_60 VGND VGND VPWR VPWR sky130_fd_sc_hd__fill_1
XFILLER_94_268 VGND VGND VPWR VPWR sky130_fd_sc_hd__decap_3
XFILLER_85_93 VGND VGND VPWR VPWR sky130_fd_sc_hd__decap_3
XFILLER_35_335 VGND VGND VPWR VPWR sky130_fd_sc_hd__fill_1
XFILLER_35_346 VGND VGND VPWR VPWR sky130_fd_sc_hd__decap_3
XFILLER_90_441 VGND VGND VPWR VPWR sky130_fd_sc_hd__decap_3
XFILLER_23_508 VGND VGND VPWR VPWR sky130_fd_sc_hd__decap_3
XFILLER_90_474 VGND VGND VPWR VPWR sky130_fd_sc_hd__fill_2
X_3971_ _3971_/A _3971_/B VGND VGND VPWR VPWR _3973_/A sky130_fd_sc_hd__nor2_2
XFILLER_50_327 VGND VGND VPWR VPWR sky130_fd_sc_hd__decap_3
X_5710_ _5710_/A _5748_/B _5710_/C VGND VGND VPWR VPWR _5739_/A sky130_fd_sc_hd__nand3_2
XFILLER_31_541 VGND VGND VPWR VPWR sky130_fd_sc_hd__fill_2
X_6690_ _3738_/Y _6104_/X _6146_/Y _6778_/B1 _6689_/Y VGND VGND VPWR VPWR _6690_/X
+ sky130_fd_sc_hd__a311o_2
XTAP_TAPCELL_ROW_61_856 VGND VPWR sky130_fd_sc_hd__tapvpwrvgnd_1
X_5641_ _5678_/A _5641_/B VGND VGND VPWR VPWR _5655_/B sky130_fd_sc_hd__xnor2_2
X_5572_ _5572_/A _5572_/B VGND VGND VPWR VPWR _5618_/A sky130_fd_sc_hd__xnor2_2
X_4523_ _4523_/A _4523_/B _4523_/C VGND VGND VPWR VPWR _4529_/A sky130_fd_sc_hd__nand3_2
X_4454_ _4378_/C _4378_/B _4378_/D _4378_/A VGND VGND VPWR VPWR _4454_/X sky130_fd_sc_hd__o22a_2
X_4385_ _4266_/A _4266_/C _4266_/B VGND VGND VPWR VPWR _4386_/B sky130_fd_sc_hd__o21ai_2
X_6124_ _6124_/A _6124_/B VGND VGND VPWR VPWR _6381_/D sky130_fd_sc_hd__nand2_2
XFILLER_85_202 VGND VGND VPWR VPWR sky130_fd_sc_hd__decap_3
X_6055_ _6055_/A _6055_/B VGND VGND VPWR VPWR _6056_/B sky130_fd_sc_hd__xnor2_2
XTAP_TAPCELL_ROW_69_945 VGND VPWR sky130_fd_sc_hd__tapvpwrvgnd_1
XFILLER_85_246 VGND VGND VPWR VPWR sky130_fd_sc_hd__decap_3
X_5006_ _4880_/Y _5003_/X _5002_/Y _5000_/Y VGND VGND VPWR VPWR _5007_/A sky130_fd_sc_hd__a211o_2
XFILLER_26_346 VGND VGND VPWR VPWR sky130_fd_sc_hd__decap_3
XFILLER_38_195 VGND VGND VPWR VPWR sky130_fd_sc_hd__fill_1
XFILLER_93_290 VGND VGND VPWR VPWR sky130_fd_sc_hd__decap_3
XFILLER_14_519 VGND VGND VPWR VPWR sky130_fd_sc_hd__decap_3
XFILLER_26_368 VGND VGND VPWR VPWR sky130_fd_sc_hd__decap_3
XFILLER_53_143 VGND VGND VPWR VPWR sky130_fd_sc_hd__decap_3
XFILLER_81_452 VGND VGND VPWR VPWR sky130_fd_sc_hd__decap_3
X_6957_ _6957_/A _6957_/B VGND VGND VPWR VPWR _6957_/Y sky130_fd_sc_hd__xnor2_2
XFILLER_41_327 VGND VGND VPWR VPWR sky130_fd_sc_hd__decap_3
XFILLER_22_552 VGND VGND VPWR VPWR sky130_fd_sc_hd__decap_3
XFILLER_34_390 VGND VGND VPWR VPWR sky130_fd_sc_hd__decap_3
X_6888_ _5911_/X _5914_/Y _6872_/Y _6887_/Y _6923_/A VGND VGND VPWR VPWR _6888_/X
+ sky130_fd_sc_hd__o311a_2
X_5908_ _5912_/A _5912_/B VGND VGND VPWR VPWR _5908_/Y sky130_fd_sc_hd__nor2_2
XFILLER_14_56 VGND VGND VPWR VPWR sky130_fd_sc_hd__decap_3
X_5839_ _5252_/X _5835_/Y _5833_/Y _5839_/C1 VGND VGND VPWR VPWR _5840_/C sky130_fd_sc_hd__a211oi_2
XFILLER_5_206 VGND VGND VPWR VPWR sky130_fd_sc_hd__decap_3
XFILLER_30_44 VGND VGND VPWR VPWR sky130_fd_sc_hd__decap_3
XFILLER_30_77 VGND VGND VPWR VPWR sky130_fd_sc_hd__decap_3
XFILLER_30_88 VGND VGND VPWR VPWR sky130_fd_sc_hd__decap_3
XFILLER_1_423 VGND VGND VPWR VPWR sky130_fd_sc_hd__decap_3
XFILLER_39_20 VGND VGND VPWR VPWR sky130_fd_sc_hd__fill_1
XFILLER_39_75 VGND VGND VPWR VPWR sky130_fd_sc_hd__fill_1
XFILLER_49_449 VGND VGND VPWR VPWR sky130_fd_sc_hd__decap_3
XFILLER_76_224 VGND VGND VPWR VPWR sky130_fd_sc_hd__decap_3
XFILLER_39_97 VGND VGND VPWR VPWR sky130_fd_sc_hd__fill_2
XFILLER_76_268 VGND VGND VPWR VPWR sky130_fd_sc_hd__decap_3
XFILLER_91_216 VGND VGND VPWR VPWR sky130_fd_sc_hd__decap_3
XTAP_TAPCELL_ROW_4_261 VGND VPWR sky130_fd_sc_hd__tapvpwrvgnd_1
XFILLER_55_41 VGND VGND VPWR VPWR sky130_fd_sc_hd__fill_2
XFILLER_57_482 VGND VGND VPWR VPWR sky130_fd_sc_hd__decap_3
XFILLER_91_249 VGND VGND VPWR VPWR sky130_fd_sc_hd__decap_3
XFILLER_44_132 VGND VGND VPWR VPWR sky130_fd_sc_hd__decap_3
XFILLER_55_63 VGND VGND VPWR VPWR sky130_fd_sc_hd__decap_3
XFILLER_72_452 VGND VGND VPWR VPWR sky130_fd_sc_hd__decap_3
XFILLER_72_474 VGND VGND VPWR VPWR sky130_fd_sc_hd__fill_2
XFILLER_32_316 VGND VGND VPWR VPWR sky130_fd_sc_hd__decap_3
XFILLER_72_485 VGND VGND VPWR VPWR sky130_fd_sc_hd__fill_2
XFILLER_13_541 VGND VGND VPWR VPWR sky130_fd_sc_hd__decap_3
XFILLER_25_390 VGND VGND VPWR VPWR sky130_fd_sc_hd__fill_2
XFILLER_40_360 VGND VGND VPWR VPWR sky130_fd_sc_hd__decap_3
XFILLER_71_51 VGND VGND VPWR VPWR sky130_fd_sc_hd__decap_3
XTAP_TAPCELL_ROW_30_528 VGND VPWR sky130_fd_sc_hd__tapvpwrvgnd_1
XFILLER_9_534 VGND VGND VPWR VPWR sky130_fd_sc_hd__fill_2
XFILLER_9_567 VGND VGND VPWR VPWR sky130_fd_sc_hd__fill_1
XTAP_TAPCELL_ROW_78_1040 VGND VPWR sky130_fd_sc_hd__tapvpwrvgnd_1
XFILLER_58_6 VGND VGND VPWR VPWR sky130_fd_sc_hd__decap_3
XFILLER_4_272 VGND VGND VPWR VPWR sky130_fd_sc_hd__decap_3
XFILLER_99_349 VGND VGND VPWR VPWR sky130_fd_sc_hd__decap_3
X_4170_ _4170_/A _4170_/B _4170_/C VGND VGND VPWR VPWR _4272_/A sky130_fd_sc_hd__nand3_2
XFILLER_67_202 VGND VGND VPWR VPWR sky130_fd_sc_hd__decap_3
XFILLER_96_92 VGND VGND VPWR VPWR sky130_fd_sc_hd__decap_3
XFILLER_95_544 VGND VGND VPWR VPWR sky130_fd_sc_hd__decap_3
XTAP_TAPCELL_ROW_66_915 VGND VPWR sky130_fd_sc_hd__tapvpwrvgnd_1
XTAP_TAPCELL_ROW_38_617 VGND VPWR sky130_fd_sc_hd__tapvpwrvgnd_1
XFILLER_75_290 VGND VGND VPWR VPWR sky130_fd_sc_hd__decap_3
XFILLER_23_305 VGND VGND VPWR VPWR sky130_fd_sc_hd__decap_3
XFILLER_35_165 VGND VGND VPWR VPWR sky130_fd_sc_hd__decap_3
X_6811_ _6087_/A _6927_/B1 _6928_/A2 _3941_/A _6810_/X VGND VGND VPWR VPWR _6812_/C
+ sky130_fd_sc_hd__o221a_2
XFILLER_23_327 VGND VGND VPWR VPWR sky130_fd_sc_hd__decap_3
XFILLER_35_187 VGND VGND VPWR VPWR sky130_fd_sc_hd__fill_2
XFILLER_90_271 VGND VGND VPWR VPWR sky130_fd_sc_hd__fill_1
XTAP_TAPCELL_ROW_74_992 VGND VPWR sky130_fd_sc_hd__tapvpwrvgnd_1
XFILLER_23_349 VGND VGND VPWR VPWR sky130_fd_sc_hd__decap_3
XFILLER_50_146 VGND VGND VPWR VPWR sky130_fd_sc_hd__fill_2
X_6742_ _6255_/A _6155_/X _6157_/X _6778_/B1 VGND VGND VPWR VPWR _6742_/Y sky130_fd_sc_hd__a31oi_2
X_3954_ _3955_/A _4003_/C VGND VGND VPWR VPWR _3954_/Y sky130_fd_sc_hd__nand2_2
X_6673_ _6711_/A2 _6105_/A _6673_/A2 _6673_/A3 _6395_/S _6938_/S1 VGND VGND VPWR VPWR
+ _6673_/X sky130_fd_sc_hd__mux4_2
X_3885_ _3886_/A _3886_/B VGND VGND VPWR VPWR _3885_/Y sky130_fd_sc_hd__nand2_2
X_5624_ _5701_/A _5778_/C VGND VGND VPWR VPWR _5626_/B sky130_fd_sc_hd__and2_2
X_5555_ _5555_/A _5555_/B VGND VGND VPWR VPWR _5557_/C sky130_fd_sc_hd__or2_2
X_5486_ _5486_/A _5486_/B VGND VGND VPWR VPWR _5525_/A sky130_fd_sc_hd__xor2_2
X_4506_ _4662_/A _4608_/B VGND VGND VPWR VPWR _4509_/B sky130_fd_sc_hd__nand2_2
X_4437_ _4436_/A _4436_/Y _4382_/A _4383_/X VGND VGND VPWR VPWR _4441_/A sky130_fd_sc_hd__a211o_2
Xfanout513 input3/X VGND VGND VPWR VPWR wire514/A sky130_fd_sc_hd__buf_6
XFILLER_58_224 VGND VGND VPWR VPWR sky130_fd_sc_hd__decap_3
XFILLER_76_29 VGND VGND VPWR VPWR sky130_fd_sc_hd__fill_2
XFILLER_86_533 VGND VGND VPWR VPWR sky130_fd_sc_hd__fill_1
Xfanout535 _6606_/A3 VGND VGND VPWR VPWR _5734_/A sky130_fd_sc_hd__buf_4
X_6107_ _6108_/A _6108_/B VGND VGND VPWR VPWR _6383_/B sky130_fd_sc_hd__nor2_2
X_4368_ _4368_/A _4491_/A VGND VGND VPWR VPWR _4370_/C sky130_fd_sc_hd__nand2_2
XFILLER_100_321 VGND VGND VPWR VPWR sky130_fd_sc_hd__decap_3
XFILLER_86_555 VGND VGND VPWR VPWR sky130_fd_sc_hd__decap_3
Xfanout568 _4634_/A VGND VGND VPWR VPWR _4592_/A sky130_fd_sc_hd__clkbuf_4
Xfanout579 wire590/X VGND VGND VPWR VPWR _4685_/A sky130_fd_sc_hd__buf_6
X_4299_ _4299_/A _4299_/B _4299_/C VGND VGND VPWR VPWR _4302_/A sky130_fd_sc_hd__or3_4
XFILLER_100_354 VGND VGND VPWR VPWR sky130_fd_sc_hd__decap_3
XFILLER_46_419 VGND VGND VPWR VPWR sky130_fd_sc_hd__fill_1
XFILLER_58_268 VGND VGND VPWR VPWR sky130_fd_sc_hd__decap_3
X_6038_ _4029_/A _4029_/B _4028_/A VGND VGND VPWR VPWR _6045_/A sky130_fd_sc_hd__a21o_2
XFILLER_54_430 VGND VGND VPWR VPWR sky130_fd_sc_hd__decap_3
XTAP_TAPCELL_ROW_1_231 VGND VPWR sky130_fd_sc_hd__tapvpwrvgnd_1
XFILLER_26_132 VGND VGND VPWR VPWR sky130_fd_sc_hd__decap_3
XFILLER_25_33 VGND VGND VPWR VPWR sky130_fd_sc_hd__decap_3
XFILLER_26_165 VGND VGND VPWR VPWR sky130_fd_sc_hd__decap_3
XFILLER_81_293 VGND VGND VPWR VPWR sky130_fd_sc_hd__decap_3
XFILLER_10_511 VGND VGND VPWR VPWR sky130_fd_sc_hd__fill_2
XFILLER_10_533 VGND VGND VPWR VPWR sky130_fd_sc_hd__decap_3
XFILLER_41_54 VGND VGND VPWR VPWR sky130_fd_sc_hd__fill_2
XFILLER_6_504 VGND VGND VPWR VPWR sky130_fd_sc_hd__decap_3
XFILLER_6_515 VGND VGND VPWR VPWR sky130_fd_sc_hd__decap_3
XFILLER_2_26 VGND VGND VPWR VPWR sky130_fd_sc_hd__fill_2
XFILLER_89_360 VGND VGND VPWR VPWR sky130_fd_sc_hd__decap_3
XFILLER_49_246 VGND VGND VPWR VPWR sky130_fd_sc_hd__decap_3
XFILLER_89_393 VGND VGND VPWR VPWR sky130_fd_sc_hd__decap_3
XFILLER_49_279 VGND VGND VPWR VPWR sky130_fd_sc_hd__fill_1
XFILLER_64_227 VGND VGND VPWR VPWR sky130_fd_sc_hd__decap_3
XFILLER_17_165 VGND VGND VPWR VPWR sky130_fd_sc_hd__decap_3
XFILLER_72_271 VGND VGND VPWR VPWR sky130_fd_sc_hd__decap_3
XFILLER_72_282 VGND VGND VPWR VPWR sky130_fd_sc_hd__decap_3
XFILLER_60_433 VGND VGND VPWR VPWR sky130_fd_sc_hd__decap_3
XTAP_TAPCELL_ROW_71_962 VGND VPWR sky130_fd_sc_hd__tapvpwrvgnd_1
XFILLER_20_319 VGND VGND VPWR VPWR sky130_fd_sc_hd__decap_3
XFILLER_60_488 VGND VGND VPWR VPWR sky130_fd_sc_hd__fill_1
XFILLER_60_499 VGND VGND VPWR VPWR sky130_fd_sc_hd__decap_3
XFILLER_82_94 VGND VGND VPWR VPWR sky130_fd_sc_hd__fill_2
XTAP_TAPCELL_ROW_43_664 VGND VPWR sky130_fd_sc_hd__tapvpwrvgnd_1
XTAP_TAPCELL_ROW_15_377 VGND VPWR sky130_fd_sc_hd__tapvpwrvgnd_1
XFILLER_13_382 VGND VGND VPWR VPWR sky130_fd_sc_hd__fill_2
XFILLER_13_393 VGND VGND VPWR VPWR sky130_fd_sc_hd__decap_3
XFILLER_9_320 VGND VGND VPWR VPWR sky130_fd_sc_hd__decap_3
X_3670_ _3724_/A _3670_/B VGND VGND VPWR VPWR _3672_/B sky130_fd_sc_hd__nor2_2
XFILLER_9_353 VGND VGND VPWR VPWR sky130_fd_sc_hd__decap_3
XFILLER_56_3 VGND VGND VPWR VPWR sky130_fd_sc_hd__decap_3
X_5340_ _5340_/A _5340_/B VGND VGND VPWR VPWR _5344_/A sky130_fd_sc_hd__nand2_2
X_5271_ _5272_/B _5272_/A VGND VGND VPWR VPWR _5455_/A sky130_fd_sc_hd__and2b_2
XFILLER_99_113 VGND VGND VPWR VPWR sky130_fd_sc_hd__fill_2
X_4222_ _4222_/A _4222_/B VGND VGND VPWR VPWR _4223_/C sky130_fd_sc_hd__or2_2
XFILLER_68_511 VGND VGND VPWR VPWR sky130_fd_sc_hd__decap_3
XFILLER_87_319 VGND VGND VPWR VPWR sky130_fd_sc_hd__decap_3
X_4153_ _4146_/A _4146_/B _4152_/B _4248_/A _4248_/B VGND VGND VPWR VPWR _4155_/B
+ sky130_fd_sc_hd__a32o_2
XFILLER_55_216 VGND VGND VPWR VPWR sky130_fd_sc_hd__decap_3
XFILLER_83_525 VGND VGND VPWR VPWR sky130_fd_sc_hd__decap_3
X_4084_ _4079_/A _4079_/C _4079_/D _4080_/A VGND VGND VPWR VPWR _4084_/X sky130_fd_sc_hd__a22o_2
XFILLER_95_385 VGND VGND VPWR VPWR sky130_fd_sc_hd__decap_3
XFILLER_83_558 VGND VGND VPWR VPWR sky130_fd_sc_hd__fill_2
XTAP_TAPCELL_ROW_87_1128 VGND VPWR sky130_fd_sc_hd__tapvpwrvgnd_1
XFILLER_95_396 VGND VGND VPWR VPWR sky130_fd_sc_hd__decap_3
XFILLER_36_430 VGND VGND VPWR VPWR sky130_fd_sc_hd__decap_3
XFILLER_63_293 VGND VGND VPWR VPWR sky130_fd_sc_hd__decap_3
X_4986_ _4986_/A _4986_/B VGND VGND VPWR VPWR _5066_/B sky130_fd_sc_hd__xnor2_2
XFILLER_23_179 VGND VGND VPWR VPWR sky130_fd_sc_hd__fill_1
XFILLER_51_499 VGND VGND VPWR VPWR sky130_fd_sc_hd__decap_3
X_6725_ _6727_/A _6725_/B VGND VGND VPWR VPWR _6725_/Y sky130_fd_sc_hd__xnor2_2
X_3937_ _3937_/A _3937_/B VGND VGND VPWR VPWR _3938_/C sky130_fd_sc_hd__xnor2_2
X_6656_ _6700_/A _6496_/X _6625_/Y _6494_/X VGND VGND VPWR VPWR _6656_/X sky130_fd_sc_hd__a22o_2
X_3868_ _3868_/A _3868_/B VGND VGND VPWR VPWR _3878_/A sky130_fd_sc_hd__nand2_2
XTAP_TAPCELL_ROW_98_1246 VGND VPWR sky130_fd_sc_hd__tapvpwrvgnd_1
X_6587_ _6489_/X _6493_/B _6924_/S VGND VGND VPWR VPWR _6588_/B sky130_fd_sc_hd__mux2_1
X_5607_ _5606_/A _5606_/C _5606_/B VGND VGND VPWR VPWR _5608_/B sky130_fd_sc_hd__a21oi_2
X_3799_ _3799_/A _3799_/B VGND VGND VPWR VPWR _3806_/A sky130_fd_sc_hd__xnor2_2
XFILLER_11_57 VGND VGND VPWR VPWR sky130_fd_sc_hd__fill_1
X_5538_ _5636_/A _5536_/B _5583_/B _5535_/X VGND VGND VPWR VPWR _5540_/B sky130_fd_sc_hd__a31o_2
X_5469_ _5467_/X _5466_/Y _5441_/A _5517_/A1 VGND VGND VPWR VPWR _5469_/Y sky130_fd_sc_hd__a211oi_4
XFILLER_59_511 VGND VGND VPWR VPWR sky130_fd_sc_hd__decap_3
Xfanout321 _3663_/A VGND VGND VPWR VPWR _5983_/D sky130_fd_sc_hd__clkdlybuf4s25_1
XFILLER_86_341 VGND VGND VPWR VPWR sky130_fd_sc_hd__decap_3
Xfanout343 input45/X VGND VGND VPWR VPWR _3552_/B sky130_fd_sc_hd__buf_4
Xfanout354 _6499_/S VGND VGND VPWR VPWR _6446_/A sky130_fd_sc_hd__clkdlybuf4s25_1
Xfanout365 _6938_/S1 VGND VGND VPWR VPWR _6311_/A sky130_fd_sc_hd__clkdlybuf4s25_1
XFILLER_86_363 VGND VGND VPWR VPWR sky130_fd_sc_hd__fill_1
XFILLER_86_374 VGND VGND VPWR VPWR sky130_fd_sc_hd__decap_3
Xfanout376 _5983_/C VGND VGND VPWR VPWR _3909_/D sky130_fd_sc_hd__clkdlybuf4s25_1
Xfanout398 input4/X VGND VGND VPWR VPWR _6711_/A2 sky130_fd_sc_hd__clkdlybuf4s25_1
XFILLER_74_536 VGND VGND VPWR VPWR sky130_fd_sc_hd__fill_1
XFILLER_27_441 VGND VGND VPWR VPWR sky130_fd_sc_hd__decap_3
XFILLER_36_76 VGND VGND VPWR VPWR sky130_fd_sc_hd__decap_3
XFILLER_54_260 VGND VGND VPWR VPWR sky130_fd_sc_hd__decap_3
XFILLER_54_271 VGND VGND VPWR VPWR sky130_fd_sc_hd__decap_3
XTAP_TAPCELL_ROW_40_634 VGND VPWR sky130_fd_sc_hd__tapvpwrvgnd_1
XFILLER_22_190 VGND VGND VPWR VPWR sky130_fd_sc_hd__decap_3
XFILLER_52_97 VGND VGND VPWR VPWR sky130_fd_sc_hd__decap_3
Xinput18 A[25] VGND VGND VPWR VPWR input18/X sky130_fd_sc_hd__clkdlybuf4s25_1
XTAP_TAPCELL_ROW_12_347 VGND VPWR sky130_fd_sc_hd__tapvpwrvgnd_1
XFILLER_6_312 VGND VGND VPWR VPWR sky130_fd_sc_hd__fill_2
Xinput29 A[6] VGND VGND VPWR VPWR input29/X sky130_fd_sc_hd__buf_4
XFILLER_6_345 VGND VGND VPWR VPWR sky130_fd_sc_hd__decap_3
XFILLER_6_378 VGND VGND VPWR VPWR sky130_fd_sc_hd__decap_3
XFILLER_69_308 VGND VGND VPWR VPWR sky130_fd_sc_hd__decap_3
XFILLER_2_562 VGND VGND VPWR VPWR sky130_fd_sc_hd__fill_2
XFILLER_2_595 VGND VGND VPWR VPWR sky130_fd_sc_hd__decap_3
XFILLER_89_190 VGND VGND VPWR VPWR sky130_fd_sc_hd__fill_2
XFILLER_65_503 VGND VGND VPWR VPWR sky130_fd_sc_hd__fill_1
XTAP_TAPCELL_ROW_48_723 VGND VPWR sky130_fd_sc_hd__tapvpwrvgnd_1
XFILLER_18_441 VGND VGND VPWR VPWR sky130_fd_sc_hd__decap_3
XFILLER_92_344 VGND VGND VPWR VPWR sky130_fd_sc_hd__decap_3
XFILLER_80_539 VGND VGND VPWR VPWR sky130_fd_sc_hd__fill_2
XFILLER_92_377 VGND VGND VPWR VPWR sky130_fd_sc_hd__decap_3
XFILLER_93_93 VGND VGND VPWR VPWR sky130_fd_sc_hd__decap_3
XFILLER_33_422 VGND VGND VPWR VPWR sky130_fd_sc_hd__decap_3
XFILLER_33_455 VGND VGND VPWR VPWR sky130_fd_sc_hd__decap_3
X_4840_ _4625_/A _4625_/C _4625_/B VGND VGND VPWR VPWR _4841_/C sky130_fd_sc_hd__a21bo_2
XFILLER_60_274 VGND VGND VPWR VPWR sky130_fd_sc_hd__fill_2
X_6510_ _6731_/B _6495_/X _6504_/X _6586_/A VGND VGND VPWR VPWR _6510_/X sky130_fd_sc_hd__a22o_2
X_4771_ _4771_/A _4808_/B _4771_/C VGND VGND VPWR VPWR _4773_/B sky130_fd_sc_hd__nand3_2
X_3722_ _3717_/A _3717_/C _3717_/B VGND VGND VPWR VPWR _3723_/C sky130_fd_sc_hd__a21o_2
X_6441_ _6441_/A _6441_/B VGND VGND VPWR VPWR _6441_/Y sky130_fd_sc_hd__nor2_2
X_3653_ _3674_/A VGND VGND VPWR VPWR _3653_/Y sky130_fd_sc_hd__inv_2
X_6372_ _6372_/A _6372_/B VGND VGND VPWR VPWR _6388_/A sky130_fd_sc_hd__nand2_2
X_5323_ _5321_/B _5321_/C _5321_/D _5321_/A VGND VGND VPWR VPWR _5324_/B sky130_fd_sc_hd__a22o_2
X_3584_ _3584_/A _3584_/B _3584_/C VGND VGND VPWR VPWR _4070_/A sky130_fd_sc_hd__nand3_2
XFILLER_87_105 VGND VGND VPWR VPWR sky130_fd_sc_hd__fill_2
X_5254_ _5250_/X _5252_/X _5253_/X _5174_/Y VGND VGND VPWR VPWR _5257_/A sky130_fd_sc_hd__a211oi_2
XTAP_TAPCELL_ROW_93_1198 VGND VPWR sky130_fd_sc_hd__tapvpwrvgnd_1
X_5185_ _5170_/B _5170_/C _5170_/A VGND VGND VPWR VPWR _5250_/B sky130_fd_sc_hd__a21oi_2
X_4205_ _4201_/A _4199_/Y _4143_/Y _4195_/A VGND VGND VPWR VPWR _4205_/X sky130_fd_sc_hd__o211a_2
XFILLER_56_514 VGND VGND VPWR VPWR sky130_fd_sc_hd__decap_3
XFILLER_68_374 VGND VGND VPWR VPWR sky130_fd_sc_hd__decap_3
X_4136_ _4113_/X _4114_/Y _4132_/Y _4228_/A VGND VGND VPWR VPWR _4139_/B sky130_fd_sc_hd__o211a_2
XFILLER_83_311 VGND VGND VPWR VPWR sky130_fd_sc_hd__fill_2
XFILLER_83_322 VGND VGND VPWR VPWR sky130_fd_sc_hd__decap_3
X_4067_ _4067_/A _6178_/A _4067_/C VGND VGND VPWR VPWR _4108_/A sky130_fd_sc_hd__nand3_2
XFILLER_36_260 VGND VGND VPWR VPWR sky130_fd_sc_hd__decap_3
XFILLER_71_517 VGND VGND VPWR VPWR sky130_fd_sc_hd__decap_3
XFILLER_83_377 VGND VGND VPWR VPWR sky130_fd_sc_hd__decap_3
XFILLER_83_388 VGND VGND VPWR VPWR sky130_fd_sc_hd__decap_3
XFILLER_24_488 VGND VGND VPWR VPWR sky130_fd_sc_hd__decap_3
XFILLER_51_296 VGND VGND VPWR VPWR sky130_fd_sc_hd__fill_1
X_4969_ _4963_/A _4963_/C _4963_/B VGND VGND VPWR VPWR _4970_/C sky130_fd_sc_hd__a21o_4
X_6708_ _3663_/Y _3738_/Y _6146_/Y _6104_/B VGND VGND VPWR VPWR _6709_/B sky130_fd_sc_hd__a31o_2
X_6639_ _6639_/A0 _5981_/B _5992_/B wire507/A _6744_/S0 _6876_/S1 VGND VGND VPWR VPWR
+ _6639_/X sky130_fd_sc_hd__mux4_2
XFILLER_3_315 VGND VGND VPWR VPWR sky130_fd_sc_hd__fill_2
XFILLER_3_326 VGND VGND VPWR VPWR sky130_fd_sc_hd__decap_3
XFILLER_98_27 VGND VGND VPWR VPWR sky130_fd_sc_hd__fill_1
Xfanout140 _6332_/X VGND VGND VPWR VPWR _6978_/A2 sky130_fd_sc_hd__clkdlybuf4s25_1
XFILLER_47_514 VGND VGND VPWR VPWR sky130_fd_sc_hd__decap_3
XFILLER_59_363 VGND VGND VPWR VPWR sky130_fd_sc_hd__fill_1
XFILLER_93_108 VGND VGND VPWR VPWR sky130_fd_sc_hd__decap_3
Xfanout151 _6542_/B2 VGND VGND VPWR VPWR wire152/A sky130_fd_sc_hd__clkdlybuf4s25_1
XFILLER_59_385 VGND VGND VPWR VPWR sky130_fd_sc_hd__decap_3
Xfanout184 fanout186/A VGND VGND VPWR VPWR _6098_/B sky130_fd_sc_hd__clkdlybuf4s25_1
XFILLER_74_355 VGND VGND VPWR VPWR sky130_fd_sc_hd__fill_1
XFILLER_62_517 VGND VGND VPWR VPWR sky130_fd_sc_hd__decap_3
XFILLER_74_377 VGND VGND VPWR VPWR sky130_fd_sc_hd__decap_3
XFILLER_15_422 VGND VGND VPWR VPWR sky130_fd_sc_hd__decap_3
XFILLER_42_230 VGND VGND VPWR VPWR sky130_fd_sc_hd__decap_3
XFILLER_63_63 VGND VGND VPWR VPWR sky130_fd_sc_hd__fill_1
XFILLER_70_550 VGND VGND VPWR VPWR sky130_fd_sc_hd__decap_3
XFILLER_30_436 VGND VGND VPWR VPWR sky130_fd_sc_hd__decap_3
XFILLER_70_583 VGND VGND VPWR VPWR sky130_fd_sc_hd__decap_3
XTAP_TAPCELL_ROW_53_770 VGND VPWR sky130_fd_sc_hd__tapvpwrvgnd_1
XTAP_TAPCELL_ROW_25_483 VGND VPWR sky130_fd_sc_hd__tapvpwrvgnd_1
XFILLER_6_197 VGND VGND VPWR VPWR sky130_fd_sc_hd__decap_3
XFILLER_69_116 VGND VGND VPWR VPWR sky130_fd_sc_hd__decap_3
Xload_slew502 _6214_/B VGND VGND VPWR VPWR _5659_/A sky130_fd_sc_hd__buf_4
XFILLER_97_425 VGND VGND VPWR VPWR sky130_fd_sc_hd__decap_3
Xload_slew546 input28/X VGND VGND VPWR VPWR _4694_/A sky130_fd_sc_hd__buf_8
Xload_slew524 _5707_/A VGND VGND VPWR VPWR _5630_/A sky130_fd_sc_hd__buf_4
XFILLER_19_3 VGND VGND VPWR VPWR sky130_fd_sc_hd__decap_3
XFILLER_38_536 VGND VGND VPWR VPWR sky130_fd_sc_hd__decap_3
XFILLER_65_300 VGND VGND VPWR VPWR sky130_fd_sc_hd__decap_3
XFILLER_65_333 VGND VGND VPWR VPWR sky130_fd_sc_hd__decap_3
XFILLER_65_355 VGND VGND VPWR VPWR sky130_fd_sc_hd__decap_3
XFILLER_92_141 VGND VGND VPWR VPWR sky130_fd_sc_hd__decap_3
X_6990_ _6990_/A _6990_/B _6990_/C VGND VGND VPWR VPWR _6991_/C sky130_fd_sc_hd__or3_4
XFILLER_53_517 VGND VGND VPWR VPWR sky130_fd_sc_hd__fill_2
XFILLER_65_377 VGND VGND VPWR VPWR sky130_fd_sc_hd__decap_3
XFILLER_65_399 VGND VGND VPWR VPWR sky130_fd_sc_hd__decap_3
XFILLER_92_185 VGND VGND VPWR VPWR sky130_fd_sc_hd__decap_3
X_5941_ _5938_/X _5936_/X _6969_/A _5939_/A VGND VGND VPWR VPWR _5941_/X sky130_fd_sc_hd__a211o_4
XFILLER_18_282 VGND VGND VPWR VPWR sky130_fd_sc_hd__decap_3
XFILLER_80_336 VGND VGND VPWR VPWR sky130_fd_sc_hd__decap_3
XFILLER_33_252 VGND VGND VPWR VPWR sky130_fd_sc_hd__decap_3
XFILLER_61_561 VGND VGND VPWR VPWR sky130_fd_sc_hd__decap_3
X_5872_ _6774_/A1 _5820_/Y _5871_/X _5856_/X _5570_/Y VGND VGND VPWR VPWR _5872_/X
+ sky130_fd_sc_hd__a2111o_2
X_4823_ _4823_/A _4823_/B VGND VGND VPWR VPWR _4825_/A sky130_fd_sc_hd__xnor2_2
X_4754_ _4754_/A _4754_/B _4754_/C VGND VGND VPWR VPWR _4760_/A sky130_fd_sc_hd__nand3_2
Xrebuffer718 _5172_/X VGND VGND VPWR VPWR _5179_/C1 sky130_fd_sc_hd__buf_2
Xrebuffer729 _4967_/B VGND VGND VPWR VPWR _5051_/A1 sky130_fd_sc_hd__buf_2
Xrebuffer707 _4350_/A VGND VGND VPWR VPWR _4251_/A2 sky130_fd_sc_hd__buf_2
X_3705_ _3706_/A _3708_/A _3706_/C VGND VGND VPWR VPWR _3705_/Y sky130_fd_sc_hd__a21oi_2
X_4685_ _4685_/A _4925_/A _4925_/C _4685_/D VGND VGND VPWR VPWR _4688_/A sky130_fd_sc_hd__and4_2
XTAP_TAPCELL_ROW_95_1216 VGND VPWR sky130_fd_sc_hd__tapvpwrvgnd_1
X_6424_ _5585_/B _6423_/X _6421_/B VGND VGND VPWR VPWR _6424_/X sky130_fd_sc_hd__a21bo_2
X_3636_ _4054_/B _3634_/X _3584_/A _4070_/A VGND VGND VPWR VPWR _3636_/X sky130_fd_sc_hd__o211a_2
X_6355_ _6228_/A _6606_/A3 _6621_/A3 _6621_/A2 _6439_/B _6126_/B VGND VGND VPWR VPWR
+ _6355_/X sky130_fd_sc_hd__mux4_2
X_3567_ _3567_/A _3567_/B _3567_/C VGND VGND VPWR VPWR _3584_/A sky130_fd_sc_hd__nand3_2
XFILLER_0_318 VGND VGND VPWR VPWR sky130_fd_sc_hd__decap_3
X_6286_ _6286_/A _6286_/B VGND VGND VPWR VPWR _6286_/X sky130_fd_sc_hd__or2_2
X_5306_ _5306_/A _5313_/B VGND VGND VPWR VPWR _5308_/B sky130_fd_sc_hd__nand2_2
XFILLER_88_436 VGND VGND VPWR VPWR sky130_fd_sc_hd__decap_3
X_5237_ _5237_/A _5237_/B _5237_/C VGND VGND VPWR VPWR _5826_/B sky130_fd_sc_hd__and3_4
X_3498_ _4432_/A VGND VGND VPWR VPWR _3498_/Y sky130_fd_sc_hd__inv_2
XFILLER_29_525 VGND VGND VPWR VPWR sky130_fd_sc_hd__decap_3
XFILLER_68_182 VGND VGND VPWR VPWR sky130_fd_sc_hd__decap_3
XFILLER_84_29 VGND VGND VPWR VPWR sky130_fd_sc_hd__decap_3
X_5168_ _5146_/X _5245_/A1 _5253_/B1 _5167_/Y VGND VGND VPWR VPWR _5170_/B sky130_fd_sc_hd__o211ai_2
XFILLER_96_480 VGND VGND VPWR VPWR sky130_fd_sc_hd__fill_1
XFILLER_44_506 VGND VGND VPWR VPWR sky130_fd_sc_hd__decap_3
X_5099_ _5100_/A _5100_/B VGND VGND VPWR VPWR _6856_/A sky130_fd_sc_hd__nor2_2
X_4119_ _4116_/X _4119_/B VGND VGND VPWR VPWR _4216_/B sky130_fd_sc_hd__and2b_2
XFILLER_17_34 VGND VGND VPWR VPWR sky130_fd_sc_hd__decap_3
XFILLER_44_528 VGND VGND VPWR VPWR sky130_fd_sc_hd__decap_3
XFILLER_44_539 VGND VGND VPWR VPWR sky130_fd_sc_hd__decap_3
XFILLER_56_377 VGND VGND VPWR VPWR sky130_fd_sc_hd__decap_3
XFILLER_71_314 VGND VGND VPWR VPWR sky130_fd_sc_hd__decap_3
XFILLER_83_152 VGND VGND VPWR VPWR sky130_fd_sc_hd__decap_3
XFILLER_17_78 VGND VGND VPWR VPWR sky130_fd_sc_hd__decap_3
XFILLER_37_591 VGND VGND VPWR VPWR sky130_fd_sc_hd__decap_3
XFILLER_24_230 VGND VGND VPWR VPWR sky130_fd_sc_hd__fill_2
XFILLER_71_369 VGND VGND VPWR VPWR sky130_fd_sc_hd__decap_3
XFILLER_12_436 VGND VGND VPWR VPWR sky130_fd_sc_hd__decap_3
XFILLER_24_274 VGND VGND VPWR VPWR sky130_fd_sc_hd__decap_3
XFILLER_24_296 VGND VGND VPWR VPWR sky130_fd_sc_hd__decap_3
XFILLER_12_469 VGND VGND VPWR VPWR sky130_fd_sc_hd__decap_3
XTAP_TAPCELL_ROW_50_740 VGND VPWR sky130_fd_sc_hd__tapvpwrvgnd_1
XTAP_TAPCELL_ROW_22_453 VGND VPWR sky130_fd_sc_hd__tapvpwrvgnd_1
XFILLER_3_167 VGND VGND VPWR VPWR sky130_fd_sc_hd__fill_1
XFILLER_3_178 VGND VGND VPWR VPWR sky130_fd_sc_hd__decap_3
XFILLER_79_414 VGND VGND VPWR VPWR sky130_fd_sc_hd__decap_3
XFILLER_79_447 VGND VGND VPWR VPWR sky130_fd_sc_hd__fill_1
XFILLER_79_458 VGND VGND VPWR VPWR sky130_fd_sc_hd__decap_3
XFILLER_58_63 VGND VGND VPWR VPWR sky130_fd_sc_hd__decap_3
XFILLER_94_417 VGND VGND VPWR VPWR sky130_fd_sc_hd__decap_3
XFILLER_58_85 VGND VGND VPWR VPWR sky130_fd_sc_hd__decap_3
XFILLER_94_439 VGND VGND VPWR VPWR sky130_fd_sc_hd__decap_3
XFILLER_74_141 VGND VGND VPWR VPWR sky130_fd_sc_hd__decap_3
XFILLER_35_517 VGND VGND VPWR VPWR sky130_fd_sc_hd__fill_1
XFILLER_47_377 VGND VGND VPWR VPWR sky130_fd_sc_hd__decap_3
XFILLER_74_174 VGND VGND VPWR VPWR sky130_fd_sc_hd__decap_3
XFILLER_47_399 VGND VGND VPWR VPWR sky130_fd_sc_hd__fill_2
XFILLER_62_336 VGND VGND VPWR VPWR sky130_fd_sc_hd__decap_3
XFILLER_43_561 VGND VGND VPWR VPWR sky130_fd_sc_hd__decap_3
XFILLER_30_200 VGND VGND VPWR VPWR sky130_fd_sc_hd__decap_3
XFILLER_70_391 VGND VGND VPWR VPWR sky130_fd_sc_hd__decap_3
Xmax_cap115 _5513_/A VGND VGND VPWR VPWR _5514_/A sky130_fd_sc_hd__clkbuf_2
X_4470_ _4373_/B _4373_/A _4373_/C VGND VGND VPWR VPWR _4473_/C sky130_fd_sc_hd__o21ai_2
X_6140_ _6635_/A _6213_/B _6140_/C VGND VGND VPWR VPWR _6141_/B sky130_fd_sc_hd__or3_2
XTAP_TAPCELL_ROW_90_1157 VGND VPWR sky130_fd_sc_hd__tapvpwrvgnd_1
XFILLER_57_108 VGND VGND VPWR VPWR sky130_fd_sc_hd__decap_3
XFILLER_85_417 VGND VGND VPWR VPWR sky130_fd_sc_hd__decap_3
Xload_slew332 _4334_/C VGND VGND VPWR VPWR _6264_/A sky130_fd_sc_hd__clkbuf_4
X_6071_ _6196_/A _6196_/B VGND VGND VPWR VPWR _6071_/Y sky130_fd_sc_hd__nor2_2
XFILLER_97_255 VGND VGND VPWR VPWR sky130_fd_sc_hd__fill_2
Xload_slew387 _4616_/C VGND VGND VPWR VPWR _4361_/C sky130_fd_sc_hd__buf_6
X_5022_ _5022_/A _5022_/B VGND VGND VPWR VPWR _5107_/A sky130_fd_sc_hd__xor2_2
XFILLER_93_461 VGND VGND VPWR VPWR sky130_fd_sc_hd__decap_3
XFILLER_0_70 VGND VGND VPWR VPWR sky130_fd_sc_hd__decap_3
XFILLER_80_122 VGND VGND VPWR VPWR sky130_fd_sc_hd__decap_3
X_6973_ _6970_/A _6285_/X _6972_/X VGND VGND VPWR VPWR _6973_/Y sky130_fd_sc_hd__a21boi_2
X_5924_ _5921_/Y _5927_/A _4565_/B _5919_/X VGND VGND VPWR VPWR _5934_/A sky130_fd_sc_hd__a211oi_2
XTAP_TAPCELL_ROW_64_887 VGND VPWR sky130_fd_sc_hd__tapvpwrvgnd_1
XFILLER_21_211 VGND VGND VPWR VPWR sky130_fd_sc_hd__decap_3
X_5855_ _5874_/B _5855_/B VGND VGND VPWR VPWR _6775_/A sky130_fd_sc_hd__nand2_2
X_4806_ _4806_/A _4806_/B _4806_/C VGND VGND VPWR VPWR _4993_/A sky130_fd_sc_hd__nand3_2
X_5786_ _5786_/A _5788_/A VGND VGND VPWR VPWR _5786_/X sky130_fd_sc_hd__xor2_2
X_4737_ _4728_/A _4728_/C _4728_/B VGND VGND VPWR VPWR _4742_/A sky130_fd_sc_hd__a21bo_2
X_4668_ _5306_/A _4694_/C _4944_/D _4748_/A VGND VGND VPWR VPWR _4669_/C sky130_fd_sc_hd__a22oi_2
X_6407_ _6396_/X _6521_/B _6403_/X _6406_/X wire299/X _6608_/S VGND VGND VPWR VPWR
+ _6407_/X sky130_fd_sc_hd__mux4_2
X_3619_ _3812_/A _3628_/C _3933_/B _3933_/D VGND VGND VPWR VPWR _3831_/A sky130_fd_sc_hd__and4_2
XFILLER_88_200 VGND VGND VPWR VPWR sky130_fd_sc_hd__decap_3
X_4599_ _4457_/B _4457_/C _4457_/D _4593_/B VGND VGND VPWR VPWR _4600_/B sky130_fd_sc_hd__a22oi_2
XFILLER_88_233 VGND VGND VPWR VPWR sky130_fd_sc_hd__decap_3
X_6338_ _6338_/A _6338_/B _6342_/A VGND VGND VPWR VPWR _6338_/X sky130_fd_sc_hd__or3_2
XFILLER_76_406 VGND VGND VPWR VPWR sky130_fd_sc_hd__decap_3
X_6269_ _6842_/A _6268_/Y _6860_/B VGND VGND VPWR VPWR _6269_/X sky130_fd_sc_hd__a21o_2
XFILLER_69_480 VGND VGND VPWR VPWR sky130_fd_sc_hd__decap_3
XFILLER_88_299 VGND VGND VPWR VPWR sky130_fd_sc_hd__decap_3
XFILLER_28_44 VGND VGND VPWR VPWR sky130_fd_sc_hd__decap_3
XFILLER_91_409 VGND VGND VPWR VPWR sky130_fd_sc_hd__decap_3
XFILLER_17_517 VGND VGND VPWR VPWR sky130_fd_sc_hd__decap_3
XFILLER_29_377 VGND VGND VPWR VPWR sky130_fd_sc_hd__decap_3
XFILLER_44_303 VGND VGND VPWR VPWR sky130_fd_sc_hd__decap_3
XFILLER_56_141 VGND VGND VPWR VPWR sky130_fd_sc_hd__decap_3
XFILLER_56_174 VGND VGND VPWR VPWR sky130_fd_sc_hd__decap_3
XFILLER_84_472 VGND VGND VPWR VPWR sky130_fd_sc_hd__decap_3
XTAP_TAPCELL_ROW_27_501 VGND VPWR sky130_fd_sc_hd__tapvpwrvgnd_1
XFILLER_71_133 VGND VGND VPWR VPWR sky130_fd_sc_hd__decap_3
XFILLER_25_561 VGND VGND VPWR VPWR sky130_fd_sc_hd__decap_3
XFILLER_71_166 VGND VGND VPWR VPWR sky130_fd_sc_hd__fill_2
XFILLER_25_594 VGND VGND VPWR VPWR sky130_fd_sc_hd__decap_3
XFILLER_52_380 VGND VGND VPWR VPWR sky130_fd_sc_hd__decap_3
XFILLER_12_244 VGND VGND VPWR VPWR sky130_fd_sc_hd__fill_2
XFILLER_40_586 VGND VGND VPWR VPWR sky130_fd_sc_hd__fill_2
XFILLER_8_248 VGND VGND VPWR VPWR sky130_fd_sc_hd__decap_3
XFILLER_79_299 VGND VGND VPWR VPWR sky130_fd_sc_hd__decap_3
XTAP_TAPCELL_ROW_7_292 VGND VPWR sky130_fd_sc_hd__tapvpwrvgnd_1
XFILLER_94_225 VGND VGND VPWR VPWR sky130_fd_sc_hd__decap_3
XFILLER_47_130 VGND VGND VPWR VPWR sky130_fd_sc_hd__decap_3
XPHY_EDGE_ROW_13_Right_13 VGND VGND VPWR VPWR sky130_fd_sc_hd__decap_3
XFILLER_47_163 VGND VGND VPWR VPWR sky130_fd_sc_hd__decap_3
XFILLER_85_72 VGND VGND VPWR VPWR sky130_fd_sc_hd__decap_3
XFILLER_75_494 VGND VGND VPWR VPWR sky130_fd_sc_hd__decap_3
XFILLER_50_306 VGND VGND VPWR VPWR sky130_fd_sc_hd__fill_2
XFILLER_90_453 VGND VGND VPWR VPWR sky130_fd_sc_hd__decap_3
X_3970_ _5992_/B _3969_/B _3969_/C _3969_/D VGND VGND VPWR VPWR _3971_/B sky130_fd_sc_hd__a22oi_2
XFILLER_50_339 VGND VGND VPWR VPWR sky130_fd_sc_hd__decap_3
XFILLER_62_177 VGND VGND VPWR VPWR sky130_fd_sc_hd__decap_3
XTAP_TAPCELL_ROW_61_857 VGND VPWR sky130_fd_sc_hd__tapvpwrvgnd_1
XTAP_TAPCELL_ROW_33_559 VGND VPWR sky130_fd_sc_hd__tapvpwrvgnd_1
XFILLER_31_564 VGND VGND VPWR VPWR sky130_fd_sc_hd__decap_3
XFILLER_86_3 VGND VGND VPWR VPWR sky130_fd_sc_hd__fill_2
X_5640_ _5678_/A _5641_/B VGND VGND VPWR VPWR _5654_/A sky130_fd_sc_hd__nor2_2
XPHY_EDGE_ROW_28_Left_129 VGND VGND VPWR VPWR sky130_fd_sc_hd__decap_3
X_5571_ _5571_/A1 _5565_/X _5409_/X _5411_/Y VGND VGND VPWR VPWR _5571_/Y sky130_fd_sc_hd__o211ai_2
XPHY_EDGE_ROW_22_Right_22 VGND VGND VPWR VPWR sky130_fd_sc_hd__decap_3
X_4522_ _4409_/A _4409_/C _4409_/B VGND VGND VPWR VPWR _4523_/C sky130_fd_sc_hd__o21ai_2
X_4453_ _4441_/A _4441_/B _4441_/C VGND VGND VPWR VPWR _4453_/Y sky130_fd_sc_hd__a21oi_2
X_4384_ _4272_/X _4286_/Y _4397_/A _4285_/A VGND VGND VPWR VPWR _4384_/X sky130_fd_sc_hd__o211a_2
X_6123_ _6123_/A _6123_/B VGND VGND VPWR VPWR _6124_/B sky130_fd_sc_hd__or2_2
XPHY_EDGE_ROW_0_Left_101 VGND VGND VPWR VPWR sky130_fd_sc_hd__decap_3
XFILLER_100_514 VGND VGND VPWR VPWR sky130_fd_sc_hd__decap_3
XFILLER_100_536 VGND VGND VPWR VPWR sky130_fd_sc_hd__decap_3
XFILLER_85_214 VGND VGND VPWR VPWR sky130_fd_sc_hd__decap_3
XFILLER_85_225 VGND VGND VPWR VPWR sky130_fd_sc_hd__decap_3
Xload_slew173 _6848_/S VGND VGND VPWR VPWR _6783_/S sky130_fd_sc_hd__clkbuf_4
X_6054_ _6054_/A _6054_/B VGND VGND VPWR VPWR _6055_/B sky130_fd_sc_hd__xnor2_2
XPHY_EDGE_ROW_37_Left_138 VGND VGND VPWR VPWR sky130_fd_sc_hd__decap_3
XPHY_EDGE_ROW_31_Right_31 VGND VGND VPWR VPWR sky130_fd_sc_hd__decap_3
XFILLER_98_586 VGND VGND VPWR VPWR sky130_fd_sc_hd__fill_2
XFILLER_100_569 VGND VGND VPWR VPWR sky130_fd_sc_hd__decap_3
X_5005_ _4825_/A _4825_/B _4826_/X VGND VGND VPWR VPWR _5012_/A sky130_fd_sc_hd__a21oi_2
XTAP_TAPCELL_ROW_69_946 VGND VPWR sky130_fd_sc_hd__tapvpwrvgnd_1
XFILLER_66_461 VGND VGND VPWR VPWR sky130_fd_sc_hd__decap_3
XFILLER_73_409 VGND VGND VPWR VPWR sky130_fd_sc_hd__decap_3
XFILLER_38_174 VGND VGND VPWR VPWR sky130_fd_sc_hd__decap_3
XFILLER_53_100 VGND VGND VPWR VPWR sky130_fd_sc_hd__decap_3
XFILLER_66_483 VGND VGND VPWR VPWR sky130_fd_sc_hd__decap_3
XFILLER_53_155 VGND VGND VPWR VPWR sky130_fd_sc_hd__decap_3
X_6956_ _3484_/Y _6205_/A _6284_/X VGND VGND VPWR VPWR _6957_/B sky130_fd_sc_hd__a21oi_2
XFILLER_53_177 VGND VGND VPWR VPWR sky130_fd_sc_hd__decap_3
XFILLER_81_486 VGND VGND VPWR VPWR sky130_fd_sc_hd__decap_3
X_5907_ _5907_/A _5907_/B VGND VGND VPWR VPWR _5912_/B sky130_fd_sc_hd__or2_2
XFILLER_22_531 VGND VGND VPWR VPWR sky130_fd_sc_hd__fill_1
XFILLER_34_380 VGND VGND VPWR VPWR sky130_fd_sc_hd__decap_3
X_6887_ _5914_/Y _6872_/Y _5911_/X VGND VGND VPWR VPWR _6887_/Y sky130_fd_sc_hd__o21ai_2
XPHY_EDGE_ROW_46_Left_147 VGND VGND VPWR VPWR sky130_fd_sc_hd__decap_3
XFILLER_14_46 VGND VGND VPWR VPWR sky130_fd_sc_hd__decap_3
XFILLER_14_68 VGND VGND VPWR VPWR sky130_fd_sc_hd__decap_3
XFILLER_22_564 VGND VGND VPWR VPWR sky130_fd_sc_hd__decap_3
X_5838_ _5161_/A _5161_/B _5162_/X VGND VGND VPWR VPWR _5840_/B sky130_fd_sc_hd__a21oi_2
XPHY_EDGE_ROW_40_Right_40 VGND VGND VPWR VPWR sky130_fd_sc_hd__decap_3
X_5769_ _5769_/A _5769_/B VGND VGND VPWR VPWR _5773_/B sky130_fd_sc_hd__xor2_2
XFILLER_30_56 VGND VGND VPWR VPWR sky130_fd_sc_hd__fill_1
XFILLER_89_531 VGND VGND VPWR VPWR sky130_fd_sc_hd__decap_3
XPHY_EDGE_ROW_55_Left_156 VGND VGND VPWR VPWR sky130_fd_sc_hd__decap_3
XFILLER_39_54 VGND VGND VPWR VPWR sky130_fd_sc_hd__fill_2
XFILLER_89_597 VGND VGND VPWR VPWR sky130_fd_sc_hd__fill_1
XFILLER_76_236 VGND VGND VPWR VPWR sky130_fd_sc_hd__decap_3
XTAP_TAPCELL_ROW_4_262 VGND VPWR sky130_fd_sc_hd__tapvpwrvgnd_1
XFILLER_57_494 VGND VGND VPWR VPWR sky130_fd_sc_hd__decap_3
XFILLER_91_228 VGND VGND VPWR VPWR sky130_fd_sc_hd__decap_3
XFILLER_17_347 VGND VGND VPWR VPWR sky130_fd_sc_hd__decap_3
XFILLER_44_144 VGND VGND VPWR VPWR sky130_fd_sc_hd__decap_3
XFILLER_55_86 VGND VGND VPWR VPWR sky130_fd_sc_hd__decap_3
XFILLER_32_306 VGND VGND VPWR VPWR sky130_fd_sc_hd__fill_2
XFILLER_44_177 VGND VGND VPWR VPWR sky130_fd_sc_hd__fill_1
XFILLER_72_497 VGND VGND VPWR VPWR sky130_fd_sc_hd__decap_3
XPHY_EDGE_ROW_64_Left_165 VGND VGND VPWR VPWR sky130_fd_sc_hd__decap_3
XFILLER_13_553 VGND VGND VPWR VPWR sky130_fd_sc_hd__decap_3
XTAP_TAPCELL_ROW_30_529 VGND VPWR sky130_fd_sc_hd__tapvpwrvgnd_1
XTAP_TAPCELL_ROW_78_1041 VGND VPWR sky130_fd_sc_hd__tapvpwrvgnd_1
XFILLER_4_240 VGND VGND VPWR VPWR sky130_fd_sc_hd__decap_3
XFILLER_99_306 VGND VGND VPWR VPWR sky130_fd_sc_hd__decap_3
XFILLER_4_284 VGND VGND VPWR VPWR sky130_fd_sc_hd__decap_3
XPHY_EDGE_ROW_73_Left_174 VGND VGND VPWR VPWR sky130_fd_sc_hd__decap_3
XFILLER_67_225 VGND VGND VPWR VPWR sky130_fd_sc_hd__decap_3
XFILLER_95_501 VGND VGND VPWR VPWR sky130_fd_sc_hd__decap_3
XFILLER_67_269 VGND VGND VPWR VPWR sky130_fd_sc_hd__decap_3
XFILLER_82_217 VGND VGND VPWR VPWR sky130_fd_sc_hd__decap_3
XTAP_TAPCELL_ROW_66_905 VGND VPWR sky130_fd_sc_hd__tapvpwrvgnd_1
XTAP_TAPCELL_ROW_38_618 VGND VPWR sky130_fd_sc_hd__tapvpwrvgnd_1
XFILLER_95_578 VGND VGND VPWR VPWR sky130_fd_sc_hd__decap_3
XFILLER_63_464 VGND VGND VPWR VPWR sky130_fd_sc_hd__decap_3
X_6810_ _6767_/B _6625_/B _6680_/A _6810_/B1 _6807_/A VGND VGND VPWR VPWR _6810_/X
+ sky130_fd_sc_hd__o32a_2
XPHY_EDGE_ROW_82_Left_183 VGND VGND VPWR VPWR sky130_fd_sc_hd__decap_3
XFILLER_50_103 VGND VGND VPWR VPWR sky130_fd_sc_hd__decap_3
XTAP_TAPCELL_ROW_74_993 VGND VPWR sky130_fd_sc_hd__tapvpwrvgnd_1
X_6741_ _6255_/A _6255_/C _6740_/Y VGND VGND VPWR VPWR _6741_/Y sky130_fd_sc_hd__a21oi_2
X_3953_ _3953_/A _3953_/B VGND VGND VPWR VPWR _4040_/A sky130_fd_sc_hd__xor2_2
XTAP_TAPCELL_ROW_46_695 VGND VPWR sky130_fd_sc_hd__tapvpwrvgnd_1
X_6672_ _6672_/A _6672_/B VGND VGND VPWR VPWR _6672_/X sky130_fd_sc_hd__or2_2
X_3884_ _3884_/A _3884_/B VGND VGND VPWR VPWR _3886_/B sky130_fd_sc_hd__xnor2_2
X_5623_ _6123_/A _5779_/A _5695_/C _5725_/C VGND VGND VPWR VPWR _5626_/A sky130_fd_sc_hd__nand4_2
X_5554_ _5574_/A _5574_/B VGND VGND VPWR VPWR _5557_/B sky130_fd_sc_hd__nand2_2
X_5485_ _5486_/B _5486_/A VGND VGND VPWR VPWR _5485_/Y sky130_fd_sc_hd__nand2_2
X_4505_ _4607_/B _4505_/B _6019_/A _6019_/C VGND VGND VPWR VPWR _4509_/A sky130_fd_sc_hd__and4_2
XPHY_EDGE_ROW_91_Left_192 VGND VGND VPWR VPWR sky130_fd_sc_hd__decap_3
X_4436_ _4436_/A _4436_/B _4436_/C VGND VGND VPWR VPWR _4436_/Y sky130_fd_sc_hd__nand3_2
Xfanout503 input30/X VGND VGND VPWR VPWR _6621_/A2 sky130_fd_sc_hd__clkbuf_2
X_4367_ _4368_/A _4367_/B _4367_/C VGND VGND VPWR VPWR _4491_/A sky130_fd_sc_hd__nand3_2
XFILLER_58_203 VGND VGND VPWR VPWR sky130_fd_sc_hd__decap_3
Xfanout525 _6621_/A3 VGND VGND VPWR VPWR _6232_/B sky130_fd_sc_hd__clkdlybuf4s25_1
Xfanout547 _5383_/A VGND VGND VPWR VPWR _5340_/A sky130_fd_sc_hd__clkbuf_4
X_6106_ _6238_/B _6106_/B VGND VGND VPWR VPWR _6108_/B sky130_fd_sc_hd__nor2_2
XFILLER_58_236 VGND VGND VPWR VPWR sky130_fd_sc_hd__decap_3
Xfanout569 _4006_/A VGND VGND VPWR VPWR _4634_/A sky130_fd_sc_hd__clkbuf_2
X_4298_ _6265_/B _5953_/A2 _4297_/B _4294_/X VGND VGND VPWR VPWR _4299_/C sky130_fd_sc_hd__a31oi_2
XFILLER_73_206 VGND VGND VPWR VPWR sky130_fd_sc_hd__decap_3
XFILLER_86_589 VGND VGND VPWR VPWR sky130_fd_sc_hd__decap_3
X_6037_ _3953_/A _3953_/B _3951_/B VGND VGND VPWR VPWR _6042_/B sky130_fd_sc_hd__a21oi_2
XTAP_TAPCELL_ROW_1_232 VGND VPWR sky130_fd_sc_hd__tapvpwrvgnd_1
XFILLER_66_291 VGND VGND VPWR VPWR sky130_fd_sc_hd__decap_3
XFILLER_14_306 VGND VGND VPWR VPWR sky130_fd_sc_hd__fill_2
XFILLER_54_475 VGND VGND VPWR VPWR sky130_fd_sc_hd__fill_1
XFILLER_81_250 VGND VGND VPWR VPWR sky130_fd_sc_hd__fill_2
XFILLER_25_78 VGND VGND VPWR VPWR sky130_fd_sc_hd__decap_3
XFILLER_41_136 VGND VGND VPWR VPWR sky130_fd_sc_hd__fill_1
X_6939_ _6876_/X _6938_/X _6939_/S VGND VGND VPWR VPWR _6939_/X sky130_fd_sc_hd__mux2_1
XFILLER_22_361 VGND VGND VPWR VPWR sky130_fd_sc_hd__decap_3
XFILLER_41_169 VGND VGND VPWR VPWR sky130_fd_sc_hd__decap_3
XFILLER_22_394 VGND VGND VPWR VPWR sky130_fd_sc_hd__fill_1
XFILLER_41_22 VGND VGND VPWR VPWR sky130_fd_sc_hd__decap_3
XFILLER_6_527 VGND VGND VPWR VPWR sky130_fd_sc_hd__decap_3
XFILLER_6_538 VGND VGND VPWR VPWR sky130_fd_sc_hd__decap_3
XFILLER_1_210 VGND VGND VPWR VPWR sky130_fd_sc_hd__fill_2
XTAP_TAPCELL_ROW_9_310 VGND VPWR sky130_fd_sc_hd__tapvpwrvgnd_1
XFILLER_1_243 VGND VGND VPWR VPWR sky130_fd_sc_hd__decap_3
XFILLER_96_309 VGND VGND VPWR VPWR sky130_fd_sc_hd__decap_3
XFILLER_49_214 VGND VGND VPWR VPWR sky130_fd_sc_hd__decap_3
XFILLER_49_225 VGND VGND VPWR VPWR sky130_fd_sc_hd__decap_3
XFILLER_49_258 VGND VGND VPWR VPWR sky130_fd_sc_hd__decap_3
XFILLER_64_206 VGND VGND VPWR VPWR sky130_fd_sc_hd__decap_3
XFILLER_77_567 VGND VGND VPWR VPWR sky130_fd_sc_hd__decap_3
XFILLER_64_239 VGND VGND VPWR VPWR sky130_fd_sc_hd__decap_3
XFILLER_66_85 VGND VGND VPWR VPWR sky130_fd_sc_hd__decap_3
XFILLER_92_559 VGND VGND VPWR VPWR sky130_fd_sc_hd__fill_1
XFILLER_45_464 VGND VGND VPWR VPWR sky130_fd_sc_hd__fill_2
XFILLER_72_250 VGND VGND VPWR VPWR sky130_fd_sc_hd__fill_2
XFILLER_32_125 VGND VGND VPWR VPWR sky130_fd_sc_hd__decap_3
XFILLER_32_147 VGND VGND VPWR VPWR sky130_fd_sc_hd__decap_3
XFILLER_72_294 VGND VGND VPWR VPWR sky130_fd_sc_hd__decap_3
XFILLER_82_73 VGND VGND VPWR VPWR sky130_fd_sc_hd__decap_3
XTAP_TAPCELL_ROW_71_963 VGND VPWR sky130_fd_sc_hd__tapvpwrvgnd_1
XTAP_TAPCELL_ROW_43_665 VGND VPWR sky130_fd_sc_hd__tapvpwrvgnd_1
XFILLER_13_372 VGND VGND VPWR VPWR sky130_fd_sc_hd__decap_3
XFILLER_40_180 VGND VGND VPWR VPWR sky130_fd_sc_hd__decap_3
XTAP_TAPCELL_ROW_15_378 VGND VPWR sky130_fd_sc_hd__tapvpwrvgnd_1
XFILLER_40_191 VGND VGND VPWR VPWR sky130_fd_sc_hd__decap_3
XFILLER_9_365 VGND VGND VPWR VPWR sky130_fd_sc_hd__decap_3
X_5270_ _5270_/A _5270_/B VGND VGND VPWR VPWR _5272_/A sky130_fd_sc_hd__xnor2_2
XFILLER_99_125 VGND VGND VPWR VPWR sky130_fd_sc_hd__decap_3
XFILLER_99_103 VGND VGND VPWR VPWR sky130_fd_sc_hd__fill_1
XFILLER_49_3 VGND VGND VPWR VPWR sky130_fd_sc_hd__decap_3
X_4221_ _4346_/A _4221_/B VGND VGND VPWR VPWR _4222_/B sky130_fd_sc_hd__nor2_2
XFILLER_68_545 VGND VGND VPWR VPWR sky130_fd_sc_hd__decap_3
X_4152_ _4152_/A _4152_/B VGND VGND VPWR VPWR _4248_/B sky130_fd_sc_hd__xnor2_2
XFILLER_68_589 VGND VGND VPWR VPWR sky130_fd_sc_hd__decap_3
X_4083_ _4083_/A _4083_/B VGND VGND VPWR VPWR _4203_/A sky130_fd_sc_hd__xnor2_2
XFILLER_95_364 VGND VGND VPWR VPWR sky130_fd_sc_hd__fill_1
XFILLER_55_228 VGND VGND VPWR VPWR sky130_fd_sc_hd__fill_2
XTAP_TAPCELL_ROW_87_1129 VGND VPWR sky130_fd_sc_hd__tapvpwrvgnd_1
XFILLER_36_442 VGND VGND VPWR VPWR sky130_fd_sc_hd__decap_3
XFILLER_70_209 VGND VGND VPWR VPWR sky130_fd_sc_hd__decap_3
XFILLER_63_261 VGND VGND VPWR VPWR sky130_fd_sc_hd__decap_3
X_4985_ _5162_/A _4985_/B VGND VGND VPWR VPWR _5066_/A sky130_fd_sc_hd__nand2_2
XFILLER_11_309 VGND VGND VPWR VPWR sky130_fd_sc_hd__decap_3
XFILLER_23_169 VGND VGND VPWR VPWR sky130_fd_sc_hd__decap_3
X_6724_ _6724_/A _6724_/B VGND VGND VPWR VPWR _6724_/Y sky130_fd_sc_hd__xnor2_2
X_3936_ _6019_/D _6014_/A VGND VGND VPWR VPWR _3937_/B sky130_fd_sc_hd__nand2_2
X_6655_ _6655_/A _6655_/B VGND VGND VPWR VPWR _6655_/Y sky130_fd_sc_hd__nand2_2
X_3867_ _3867_/A _3867_/B VGND VGND VPWR VPWR _3882_/A sky130_fd_sc_hd__nand2_2
X_6586_ _6586_/A _6586_/B VGND VGND VPWR VPWR _6594_/A sky130_fd_sc_hd__nand2_2
X_5606_ _5606_/A _5606_/B _5606_/C VGND VGND VPWR VPWR _5608_/A sky130_fd_sc_hd__and3_2
X_3798_ _3799_/B _3799_/A VGND VGND VPWR VPWR _3798_/X sky130_fd_sc_hd__and2b_2
XTAP_TAPCELL_ROW_98_1247 VGND VPWR sky130_fd_sc_hd__tapvpwrvgnd_1
XFILLER_11_36 VGND VGND VPWR VPWR sky130_fd_sc_hd__decap_3
X_5537_ _5537_/A _5537_/B VGND VGND VPWR VPWR _5583_/B sky130_fd_sc_hd__xnor2_2
XFILLER_78_309 VGND VGND VPWR VPWR sky130_fd_sc_hd__decap_3
X_5468_ _5441_/A _5441_/Y _5466_/Y _5467_/X VGND VGND VPWR VPWR _5468_/X sky130_fd_sc_hd__o211a_4
XFILLER_59_501 VGND VGND VPWR VPWR sky130_fd_sc_hd__decap_3
Xfanout300 input55/X VGND VGND VPWR VPWR fanout300/X sky130_fd_sc_hd__buf_6
Xfanout311 _5993_/A VGND VGND VPWR VPWR _6175_/A sky130_fd_sc_hd__clkdlybuf4s25_1
Xfanout322 input5/X VGND VGND VPWR VPWR _6102_/A sky130_fd_sc_hd__clkdlybuf4s25_1
X_5399_ _5636_/A _5399_/B VGND VGND VPWR VPWR _5495_/A sky130_fd_sc_hd__nand2_2
X_4419_ _6264_/B _6832_/S _4294_/X _4295_/Y VGND VGND VPWR VPWR _4425_/B sky130_fd_sc_hd__o22a_2
XFILLER_59_556 VGND VGND VPWR VPWR sky130_fd_sc_hd__decap_3
XFILLER_86_320 VGND VGND VPWR VPWR sky130_fd_sc_hd__decap_3
Xfanout333 _5981_/C VGND VGND VPWR VPWR _4211_/D sky130_fd_sc_hd__clkdlybuf4s25_1
XFILLER_100_141 VGND VGND VPWR VPWR sky130_fd_sc_hd__decap_3
XFILLER_59_578 VGND VGND VPWR VPWR sky130_fd_sc_hd__decap_3
Xfanout377 input42/X VGND VGND VPWR VPWR _6093_/A sky130_fd_sc_hd__clkdlybuf4s25_1
Xfanout388 _4925_/C VGND VGND VPWR VPWR _4482_/C sky130_fd_sc_hd__buf_4
XFILLER_27_420 VGND VGND VPWR VPWR sky130_fd_sc_hd__decap_3
XFILLER_86_386 VGND VGND VPWR VPWR sky130_fd_sc_hd__decap_3
XFILLER_36_44 VGND VGND VPWR VPWR sky130_fd_sc_hd__decap_3
XFILLER_74_559 VGND VGND VPWR VPWR sky130_fd_sc_hd__decap_3
XFILLER_27_464 VGND VGND VPWR VPWR sky130_fd_sc_hd__decap_3
XFILLER_36_88 VGND VGND VPWR VPWR sky130_fd_sc_hd__decap_3
XFILLER_42_401 VGND VGND VPWR VPWR sky130_fd_sc_hd__fill_1
XFILLER_82_592 VGND VGND VPWR VPWR sky130_fd_sc_hd__decap_3
XFILLER_52_32 VGND VGND VPWR VPWR sky130_fd_sc_hd__fill_1
XTAP_TAPCELL_ROW_40_635 VGND VPWR sky130_fd_sc_hd__tapvpwrvgnd_1
Xinput19 A[26] VGND VGND VPWR VPWR input19/X sky130_fd_sc_hd__clkdlybuf4s25_1
XTAP_TAPCELL_ROW_12_348 VGND VPWR sky130_fd_sc_hd__tapvpwrvgnd_1
XFILLER_10_397 VGND VGND VPWR VPWR sky130_fd_sc_hd__decap_3
XFILLER_6_357 VGND VGND VPWR VPWR sky130_fd_sc_hd__decap_3
XTAP_TAPCELL_ROW_75_1000 VGND VPWR sky130_fd_sc_hd__tapvpwrvgnd_1
XFILLER_77_320 VGND VGND VPWR VPWR sky130_fd_sc_hd__decap_3
XFILLER_77_73 VGND VGND VPWR VPWR sky130_fd_sc_hd__decap_3
XFILLER_37_206 VGND VGND VPWR VPWR sky130_fd_sc_hd__decap_3
XFILLER_65_515 VGND VGND VPWR VPWR sky130_fd_sc_hd__decap_3
XFILLER_37_228 VGND VGND VPWR VPWR sky130_fd_sc_hd__decap_3
XFILLER_92_312 VGND VGND VPWR VPWR sky130_fd_sc_hd__decap_3
XFILLER_92_323 VGND VGND VPWR VPWR sky130_fd_sc_hd__decap_3
XTAP_TAPCELL_ROW_48_724 VGND VPWR sky130_fd_sc_hd__tapvpwrvgnd_1
XFILLER_92_356 VGND VGND VPWR VPWR sky130_fd_sc_hd__decap_3
XFILLER_18_486 VGND VGND VPWR VPWR sky130_fd_sc_hd__decap_3
XFILLER_80_518 VGND VGND VPWR VPWR sky130_fd_sc_hd__decap_3
XFILLER_92_389 VGND VGND VPWR VPWR sky130_fd_sc_hd__decap_3
XFILLER_33_434 VGND VGND VPWR VPWR sky130_fd_sc_hd__decap_3
XFILLER_60_231 VGND VGND VPWR VPWR sky130_fd_sc_hd__decap_3
XFILLER_20_128 VGND VGND VPWR VPWR sky130_fd_sc_hd__decap_3
XFILLER_33_489 VGND VGND VPWR VPWR sky130_fd_sc_hd__decap_3
XFILLER_60_297 VGND VGND VPWR VPWR sky130_fd_sc_hd__decap_3
X_4770_ _4808_/A _4769_/C _4766_/Y VGND VGND VPWR VPWR _4771_/C sky130_fd_sc_hd__a21bo_2
X_3721_ _3721_/A _3754_/A VGND VGND VPWR VPWR _3723_/B sky130_fd_sc_hd__nand2_2
X_6440_ _5777_/Y _6439_/Y _6777_/A _6465_/A VGND VGND VPWR VPWR _6440_/Y sky130_fd_sc_hd__a211oi_2
X_3652_ _3652_/A _3652_/B _3652_/C VGND VGND VPWR VPWR _3674_/A sky130_fd_sc_hd__and3_2
X_6371_ _6767_/A _6746_/A VGND VGND VPWR VPWR _6371_/Y sky130_fd_sc_hd__nor2_2
X_3583_ _3583_/A _4094_/A VGND VGND VPWR VPWR _3584_/C sky130_fd_sc_hd__nand2_2
X_5322_ _5382_/A _5322_/B VGND VGND VPWR VPWR _5572_/A sky130_fd_sc_hd__nand2_2
X_5253_ _5172_/X _5173_/Y _5253_/B1 _5170_/B VGND VGND VPWR VPWR _5253_/X sky130_fd_sc_hd__o211a_2
X_5184_ _5184_/A _5184_/B VGND VGND VPWR VPWR _5262_/A sky130_fd_sc_hd__and2_2
X_4204_ _4204_/A _4204_/B VGND VGND VPWR VPWR _4323_/A sky130_fd_sc_hd__xnor2_2
X_4135_ _4135_/A _4135_/B _4135_/C VGND VGND VPWR VPWR _4228_/A sky130_fd_sc_hd__or3_4
XFILLER_28_239 VGND VGND VPWR VPWR sky130_fd_sc_hd__decap_3
X_4066_ _4066_/A _4066_/B VGND VGND VPWR VPWR _4067_/C sky130_fd_sc_hd__xnor2_2
XFILLER_43_209 VGND VGND VPWR VPWR sky130_fd_sc_hd__fill_1
XFILLER_51_220 VGND VGND VPWR VPWR sky130_fd_sc_hd__decap_3
XFILLER_51_231 VGND VGND VPWR VPWR sky130_fd_sc_hd__fill_1
XFILLER_64_592 VGND VGND VPWR VPWR sky130_fd_sc_hd__decap_3
X_4968_ _5051_/A1 _5052_/A VGND VGND VPWR VPWR _4970_/B sky130_fd_sc_hd__nand2b_2
XFILLER_11_139 VGND VGND VPWR VPWR sky130_fd_sc_hd__decap_3
X_6707_ _6709_/A _6707_/B VGND VGND VPWR VPWR _6707_/Y sky130_fd_sc_hd__xnor2_2
X_4899_ _4899_/A _4899_/B VGND VGND VPWR VPWR _4900_/C sky130_fd_sc_hd__xor2_2
X_3919_ _3923_/B _6024_/A _3816_/B _3814_/X VGND VGND VPWR VPWR _3930_/A sky130_fd_sc_hd__a31o_2
XFILLER_22_57 VGND VGND VPWR VPWR sky130_fd_sc_hd__decap_3
X_6638_ _6638_/A _6638_/B VGND VGND VPWR VPWR _6638_/Y sky130_fd_sc_hd__nand2_2
XFILLER_98_17 VGND VGND VPWR VPWR sky130_fd_sc_hd__fill_2
X_6569_ _6569_/A _6569_/B _6569_/C VGND VGND VPWR VPWR _6569_/X sky130_fd_sc_hd__and3_2
XFILLER_0_6 VGND VGND VPWR VPWR sky130_fd_sc_hd__decap_3
XFILLER_59_331 VGND VGND VPWR VPWR sky130_fd_sc_hd__decap_3
Xfanout130 _6928_/B1 VGND VGND VPWR VPWR _6979_/B1 sky130_fd_sc_hd__clkdlybuf4s25_1
Xfanout141 _6963_/A2 VGND VGND VPWR VPWR _6717_/B sky130_fd_sc_hd__clkdlybuf4s25_1
Xfanout174 _3501_/Y VGND VGND VPWR VPWR fanout174/X sky130_fd_sc_hd__clkdlybuf4s25_1
XFILLER_19_217 VGND VGND VPWR VPWR sky130_fd_sc_hd__decap_3
XFILLER_47_32 VGND VGND VPWR VPWR sky130_fd_sc_hd__decap_3
XFILLER_74_312 VGND VGND VPWR VPWR sky130_fd_sc_hd__decap_3
XFILLER_86_183 VGND VGND VPWR VPWR sky130_fd_sc_hd__decap_3
XFILLER_47_87 VGND VGND VPWR VPWR sky130_fd_sc_hd__decap_3
XFILLER_34_209 VGND VGND VPWR VPWR sky130_fd_sc_hd__decap_3
XFILLER_62_529 VGND VGND VPWR VPWR sky130_fd_sc_hd__decap_3
XFILLER_15_412 VGND VGND VPWR VPWR sky130_fd_sc_hd__decap_3
XFILLER_27_272 VGND VGND VPWR VPWR sky130_fd_sc_hd__decap_3
XFILLER_27_294 VGND VGND VPWR VPWR sky130_fd_sc_hd__fill_2
XFILLER_55_592 VGND VGND VPWR VPWR sky130_fd_sc_hd__decap_3
XFILLER_63_42 VGND VGND VPWR VPWR sky130_fd_sc_hd__decap_3
XFILLER_15_467 VGND VGND VPWR VPWR sky130_fd_sc_hd__decap_3
XFILLER_42_242 VGND VGND VPWR VPWR sky130_fd_sc_hd__decap_3
XFILLER_42_264 VGND VGND VPWR VPWR sky130_fd_sc_hd__fill_1
XFILLER_70_562 VGND VGND VPWR VPWR sky130_fd_sc_hd__decap_3
XPHY_EDGE_ROW_69_Right_69 VGND VGND VPWR VPWR sky130_fd_sc_hd__decap_3
XFILLER_42_286 VGND VGND VPWR VPWR sky130_fd_sc_hd__decap_3
XFILLER_70_595 VGND VGND VPWR VPWR sky130_fd_sc_hd__decap_3
XTAP_TAPCELL_ROW_53_771 VGND VPWR sky130_fd_sc_hd__tapvpwrvgnd_1
XTAP_TAPCELL_ROW_25_484 VGND VPWR sky130_fd_sc_hd__tapvpwrvgnd_1
XFILLER_30_448 VGND VGND VPWR VPWR sky130_fd_sc_hd__decap_3
XFILLER_8_26 VGND VGND VPWR VPWR sky130_fd_sc_hd__fill_2
XTAP_TAPCELL_ROW_81_1070 VGND VPWR sky130_fd_sc_hd__tapvpwrvgnd_1
XFILLER_10_161 VGND VGND VPWR VPWR sky130_fd_sc_hd__fill_2
XPHY_EDGE_ROW_78_Right_78 VGND VGND VPWR VPWR sky130_fd_sc_hd__decap_3
XFILLER_69_106 VGND VGND VPWR VPWR sky130_fd_sc_hd__decap_3
XFILLER_97_415 VGND VGND VPWR VPWR sky130_fd_sc_hd__decap_3
XFILLER_69_128 VGND VGND VPWR VPWR sky130_fd_sc_hd__decap_3
Xload_slew536 _5734_/A VGND VGND VPWR VPWR _5588_/A sky130_fd_sc_hd__buf_6
XFILLER_38_504 VGND VGND VPWR VPWR sky130_fd_sc_hd__decap_3
XFILLER_65_312 VGND VGND VPWR VPWR sky130_fd_sc_hd__decap_3
XFILLER_77_161 VGND VGND VPWR VPWR sky130_fd_sc_hd__decap_3
XFILLER_38_548 VGND VGND VPWR VPWR sky130_fd_sc_hd__decap_3
XFILLER_65_389 VGND VGND VPWR VPWR sky130_fd_sc_hd__decap_3
XFILLER_80_315 VGND VGND VPWR VPWR sky130_fd_sc_hd__decap_3
XFILLER_92_153 VGND VGND VPWR VPWR sky130_fd_sc_hd__fill_2
X_5940_ _6951_/B _5938_/X _5939_/A VGND VGND VPWR VPWR _6969_/B sky130_fd_sc_hd__a21o_2
XFILLER_80_348 VGND VGND VPWR VPWR sky130_fd_sc_hd__decap_3
XPHY_EDGE_ROW_87_Right_87 VGND VGND VPWR VPWR sky130_fd_sc_hd__decap_3
XFILLER_33_231 VGND VGND VPWR VPWR sky130_fd_sc_hd__decap_3
XFILLER_61_551 VGND VGND VPWR VPWR sky130_fd_sc_hd__decap_3
X_5871_ _5871_/A _5871_/B _5871_/C _5871_/D VGND VGND VPWR VPWR _5871_/X sky130_fd_sc_hd__or4_4
XFILLER_21_437 VGND VGND VPWR VPWR sky130_fd_sc_hd__decap_3
XFILLER_33_275 VGND VGND VPWR VPWR sky130_fd_sc_hd__decap_3
X_4822_ _4822_/A _4989_/B VGND VGND VPWR VPWR _4827_/A sky130_fd_sc_hd__nand2_2
X_4753_ _4735_/B _4735_/C _4735_/A VGND VGND VPWR VPWR _4754_/C sky130_fd_sc_hd__o21ai_2
Xrebuffer719 _5470_/Y VGND VGND VPWR VPWR _5520_/B1 sky130_fd_sc_hd__buf_2
Xrebuffer708 fanout402/A VGND VGND VPWR VPWR _6025_/A sky130_fd_sc_hd__buf_2
X_3704_ _3704_/A _3704_/B VGND VGND VPWR VPWR _3706_/C sky130_fd_sc_hd__xnor2_2
X_6423_ _6589_/B _6547_/B _6417_/X VGND VGND VPWR VPWR _6423_/X sky130_fd_sc_hd__a21o_2
X_4684_ _4678_/A _4678_/C _4678_/B VGND VGND VPWR VPWR _4684_/Y sky130_fd_sc_hd__o21ai_2
XTAP_TAPCELL_ROW_95_1217 VGND VPWR sky130_fd_sc_hd__tapvpwrvgnd_1
X_3635_ _3584_/A _4070_/A _4054_/B _3634_/X VGND VGND VPWR VPWR _3635_/Y sky130_fd_sc_hd__a211oi_2
XPHY_EDGE_ROW_96_Right_96 VGND VGND VPWR VPWR sky130_fd_sc_hd__decap_3
X_6354_ _6373_/A _6569_/A _6354_/C VGND VGND VPWR VPWR _6372_/A sky130_fd_sc_hd__and3_2
X_3566_ _3565_/A _3565_/B _3565_/C VGND VGND VPWR VPWR _3567_/C sky130_fd_sc_hd__a21o_2
X_6285_ _6957_/A _6284_/X _6206_/X VGND VGND VPWR VPWR _6285_/X sky130_fd_sc_hd__a21bo_2
X_5305_ _5383_/A _5329_/A _5311_/C _5311_/D VGND VGND VPWR VPWR _5308_/A sky130_fd_sc_hd__and4_2
X_3497_ _6110_/B VGND VGND VPWR VPWR _3497_/Y sky130_fd_sc_hd__inv_2
XFILLER_88_459 VGND VGND VPWR VPWR sky130_fd_sc_hd__decap_3
X_5236_ _5236_/A _5236_/B VGND VGND VPWR VPWR _5237_/C sky130_fd_sc_hd__xnor2_2
XFILLER_29_537 VGND VGND VPWR VPWR sky130_fd_sc_hd__decap_3
XFILLER_56_312 VGND VGND VPWR VPWR sky130_fd_sc_hd__decap_3
XFILLER_68_161 VGND VGND VPWR VPWR sky130_fd_sc_hd__decap_3
XFILLER_84_19 VGND VGND VPWR VPWR sky130_fd_sc_hd__decap_3
X_5167_ _5166_/B _5166_/C _5166_/A VGND VGND VPWR VPWR _5167_/Y sky130_fd_sc_hd__o21ai_2
XFILLER_83_131 VGND VGND VPWR VPWR sky130_fd_sc_hd__decap_3
X_5098_ _5098_/A _5098_/B VGND VGND VPWR VPWR _5100_/B sky130_fd_sc_hd__nor2_2
X_4118_ _4482_/A _4593_/C _4593_/D _4617_/A VGND VGND VPWR VPWR _4119_/B sky130_fd_sc_hd__a22o_2
XFILLER_56_389 VGND VGND VPWR VPWR sky130_fd_sc_hd__decap_3
XFILLER_83_164 VGND VGND VPWR VPWR sky130_fd_sc_hd__decap_3
X_4049_ _4049_/A _4065_/A VGND VGND VPWR VPWR _4050_/B sky130_fd_sc_hd__or2_2
XFILLER_71_326 VGND VGND VPWR VPWR sky130_fd_sc_hd__decap_3
XFILLER_83_186 VGND VGND VPWR VPWR sky130_fd_sc_hd__decap_3
XFILLER_24_253 VGND VGND VPWR VPWR sky130_fd_sc_hd__decap_3
XFILLER_24_286 VGND VGND VPWR VPWR sky130_fd_sc_hd__decap_3
XFILLER_52_595 VGND VGND VPWR VPWR sky130_fd_sc_hd__decap_3
XFILLER_12_448 VGND VGND VPWR VPWR sky130_fd_sc_hd__decap_3
XFILLER_8_408 VGND VGND VPWR VPWR sky130_fd_sc_hd__decap_3
XTAP_TAPCELL_ROW_50_741 VGND VPWR sky130_fd_sc_hd__tapvpwrvgnd_1
XTAP_TAPCELL_ROW_22_443 VGND VPWR sky130_fd_sc_hd__tapvpwrvgnd_1
XFILLER_79_426 VGND VGND VPWR VPWR sky130_fd_sc_hd__decap_3
XFILLER_58_75 VGND VGND VPWR VPWR sky130_fd_sc_hd__fill_1
XFILLER_59_172 VGND VGND VPWR VPWR sky130_fd_sc_hd__decap_3
XFILLER_47_345 VGND VGND VPWR VPWR sky130_fd_sc_hd__decap_3
XFILLER_74_120 VGND VGND VPWR VPWR sky130_fd_sc_hd__decap_3
XFILLER_74_131 VGND VGND VPWR VPWR sky130_fd_sc_hd__fill_1
XTAP_TAPCELL_ROW_58_830 VGND VPWR sky130_fd_sc_hd__tapvpwrvgnd_1
XFILLER_47_389 VGND VGND VPWR VPWR sky130_fd_sc_hd__decap_3
XFILLER_62_315 VGND VGND VPWR VPWR sky130_fd_sc_hd__decap_3
XFILLER_74_153 VGND VGND VPWR VPWR sky130_fd_sc_hd__decap_3
XFILLER_28_592 VGND VGND VPWR VPWR sky130_fd_sc_hd__fill_2
XFILLER_74_186 VGND VGND VPWR VPWR sky130_fd_sc_hd__decap_3
XFILLER_74_197 VGND VGND VPWR VPWR sky130_fd_sc_hd__decap_3
XFILLER_43_540 VGND VGND VPWR VPWR sky130_fd_sc_hd__decap_3
XFILLER_74_96 VGND VGND VPWR VPWR sky130_fd_sc_hd__decap_3
XFILLER_15_264 VGND VGND VPWR VPWR sky130_fd_sc_hd__fill_2
XFILLER_15_297 VGND VGND VPWR VPWR sky130_fd_sc_hd__decap_3
XFILLER_30_256 VGND VGND VPWR VPWR sky130_fd_sc_hd__fill_2
XFILLER_7_452 VGND VGND VPWR VPWR sky130_fd_sc_hd__decap_3
Xmax_cap105 _5470_/Y VGND VGND VPWR VPWR _5869_/C1 sky130_fd_sc_hd__buf_6
XFILLER_99_71 VGND VGND VPWR VPWR sky130_fd_sc_hd__decap_3
XFILLER_31_3 VGND VGND VPWR VPWR sky130_fd_sc_hd__decap_3
Xload_slew355 _6446_/A VGND VGND VPWR VPWR _6831_/S sky130_fd_sc_hd__clkbuf_4
X_6070_ _6200_/A _6977_/A VGND VGND VPWR VPWR _6970_/A sky130_fd_sc_hd__nand2_2
XTAP_TAPCELL_ROW_90_1158 VGND VPWR sky130_fd_sc_hd__tapvpwrvgnd_1
XFILLER_38_312 VGND VGND VPWR VPWR sky130_fd_sc_hd__decap_3
XFILLER_85_429 VGND VGND VPWR VPWR sky130_fd_sc_hd__decap_3
X_5021_ _5240_/A _5103_/B VGND VGND VPWR VPWR _5022_/B sky130_fd_sc_hd__nand2b_2
XFILLER_38_323 VGND VGND VPWR VPWR sky130_fd_sc_hd__decap_3
XFILLER_65_131 VGND VGND VPWR VPWR sky130_fd_sc_hd__decap_3
Xload_slew399 _6711_/A2 VGND VGND VPWR VPWR _6144_/A sky130_fd_sc_hd__buf_4
XFILLER_93_440 VGND VGND VPWR VPWR sky130_fd_sc_hd__decap_3
XFILLER_26_518 VGND VGND VPWR VPWR sky130_fd_sc_hd__decap_3
XFILLER_38_356 VGND VGND VPWR VPWR sky130_fd_sc_hd__fill_1
XFILLER_38_389 VGND VGND VPWR VPWR sky130_fd_sc_hd__fill_2
XFILLER_65_164 VGND VGND VPWR VPWR sky130_fd_sc_hd__decap_3
XFILLER_93_473 VGND VGND VPWR VPWR sky130_fd_sc_hd__decap_3
XFILLER_65_175 VGND VGND VPWR VPWR sky130_fd_sc_hd__decap_3
XFILLER_65_197 VGND VGND VPWR VPWR sky130_fd_sc_hd__decap_3
XFILLER_80_134 VGND VGND VPWR VPWR sky130_fd_sc_hd__decap_3
X_6972_ _6970_/A _6285_/X _6291_/A VGND VGND VPWR VPWR _6972_/X sky130_fd_sc_hd__o21a_2
XFILLER_0_93 VGND VGND VPWR VPWR sky130_fd_sc_hd__decap_3
X_5923_ _4430_/X _5926_/C1 _5921_/Y _5922_/X VGND VGND VPWR VPWR _5927_/A sky130_fd_sc_hd__o211ai_2
XFILLER_34_573 VGND VGND VPWR VPWR sky130_fd_sc_hd__decap_3
XFILLER_61_381 VGND VGND VPWR VPWR sky130_fd_sc_hd__decap_3
X_5854_ _5840_/X _5844_/Y _5854_/B1 _5852_/Y VGND VGND VPWR VPWR _5855_/B sky130_fd_sc_hd__a211o_2
XTAP_TAPCELL_ROW_64_888 VGND VPWR sky130_fd_sc_hd__tapvpwrvgnd_1
XFILLER_21_223 VGND VGND VPWR VPWR sky130_fd_sc_hd__fill_1
XFILLER_21_234 VGND VGND VPWR VPWR sky130_fd_sc_hd__decap_3
X_4805_ _4805_/A _4805_/B VGND VGND VPWR VPWR _4806_/C sky130_fd_sc_hd__xnor2_2
XFILLER_21_267 VGND VGND VPWR VPWR sky130_fd_sc_hd__decap_3
XFILLER_21_278 VGND VGND VPWR VPWR sky130_fd_sc_hd__fill_2
X_5785_ _5786_/A _5788_/A VGND VGND VPWR VPWR _5806_/A sky130_fd_sc_hd__nand2b_2
X_4736_ _4735_/B _4736_/B VGND VGND VPWR VPWR _4744_/A sky130_fd_sc_hd__nand2b_2
X_4667_ _4748_/B _4695_/B VGND VGND VPWR VPWR _4669_/B sky130_fd_sc_hd__nand2_2
X_6406_ _6404_/Y _6405_/X _6456_/S VGND VGND VPWR VPWR _6406_/X sky130_fd_sc_hd__mux2_1
X_3618_ _3618_/A _3618_/B VGND VGND VPWR VPWR _3632_/A sky130_fd_sc_hd__xnor2_2
X_6337_ _6337_/A _6367_/A VGND VGND VPWR VPWR _6337_/Y sky130_fd_sc_hd__nand2_2
X_4598_ _4598_/A _4598_/B VGND VGND VPWR VPWR _4836_/A sky130_fd_sc_hd__xnor2_2
XFILLER_0_105 VGND VGND VPWR VPWR sky130_fd_sc_hd__decap_3
XFILLER_88_212 VGND VGND VPWR VPWR sky130_fd_sc_hd__decap_3
X_3549_ _5995_/B _5976_/A _3545_/Y _3547_/B VGND VGND VPWR VPWR _3555_/B sky130_fd_sc_hd__a22o_2
XFILLER_88_245 VGND VGND VPWR VPWR sky130_fd_sc_hd__decap_3
XFILLER_88_256 VGND VGND VPWR VPWR sky130_fd_sc_hd__decap_3
XFILLER_88_267 VGND VGND VPWR VPWR sky130_fd_sc_hd__decap_3
X_6268_ _6083_/A _3495_/Y _6266_/X VGND VGND VPWR VPWR _6268_/Y sky130_fd_sc_hd__o21ai_2
XFILLER_48_109 VGND VGND VPWR VPWR sky130_fd_sc_hd__decap_3
XFILLER_76_418 VGND VGND VPWR VPWR sky130_fd_sc_hd__fill_2
X_6199_ _6970_/A _6970_/B VGND VGND VPWR VPWR _6971_/A sky130_fd_sc_hd__or2_2
X_5219_ _5237_/A VGND VGND VPWR VPWR _5219_/Y sky130_fd_sc_hd__inv_2
XFILLER_29_334 VGND VGND VPWR VPWR sky130_fd_sc_hd__fill_2
XFILLER_17_529 VGND VGND VPWR VPWR sky130_fd_sc_hd__fill_1
XFILLER_56_153 VGND VGND VPWR VPWR sky130_fd_sc_hd__decap_3
XFILLER_84_451 VGND VGND VPWR VPWR sky130_fd_sc_hd__decap_3
XFILLER_44_337 VGND VGND VPWR VPWR sky130_fd_sc_hd__decap_3
XFILLER_56_186 VGND VGND VPWR VPWR sky130_fd_sc_hd__decap_3
XFILLER_56_197 VGND VGND VPWR VPWR sky130_fd_sc_hd__fill_2
XFILLER_84_495 VGND VGND VPWR VPWR sky130_fd_sc_hd__decap_3
XTAP_TAPCELL_ROW_27_502 VGND VPWR sky130_fd_sc_hd__tapvpwrvgnd_1
XFILLER_44_55 VGND VGND VPWR VPWR sky130_fd_sc_hd__decap_3
XFILLER_71_178 VGND VGND VPWR VPWR sky130_fd_sc_hd__decap_3
XFILLER_12_256 VGND VGND VPWR VPWR sky130_fd_sc_hd__fill_1
XFILLER_12_267 VGND VGND VPWR VPWR sky130_fd_sc_hd__decap_3
XFILLER_8_227 VGND VGND VPWR VPWR sky130_fd_sc_hd__fill_2
XFILLER_100_94 VGND VGND VPWR VPWR sky130_fd_sc_hd__decap_3
XFILLER_60_43 VGND VGND VPWR VPWR sky130_fd_sc_hd__decap_3
XFILLER_5_27 VGND VGND VPWR VPWR sky130_fd_sc_hd__decap_3
XFILLER_4_477 VGND VGND VPWR VPWR sky130_fd_sc_hd__decap_3
XFILLER_79_212 VGND VGND VPWR VPWR sky130_fd_sc_hd__decap_3
XFILLER_79_267 VGND VGND VPWR VPWR sky130_fd_sc_hd__fill_1
XTAP_TAPCELL_ROW_7_293 VGND VPWR sky130_fd_sc_hd__tapvpwrvgnd_1
XFILLER_94_259 VGND VGND VPWR VPWR sky130_fd_sc_hd__decap_3
XFILLER_85_84 VGND VGND VPWR VPWR sky130_fd_sc_hd__decap_3
XFILLER_35_337 VGND VGND VPWR VPWR sky130_fd_sc_hd__decap_3
XFILLER_47_175 VGND VGND VPWR VPWR sky130_fd_sc_hd__decap_3
XFILLER_62_123 VGND VGND VPWR VPWR sky130_fd_sc_hd__decap_3
XFILLER_90_410 VGND VGND VPWR VPWR sky130_fd_sc_hd__fill_2
XFILLER_90_432 VGND VGND VPWR VPWR sky130_fd_sc_hd__decap_3
XFILLER_35_359 VGND VGND VPWR VPWR sky130_fd_sc_hd__decap_3
XFILLER_90_465 VGND VGND VPWR VPWR sky130_fd_sc_hd__decap_3
XFILLER_50_318 VGND VGND VPWR VPWR sky130_fd_sc_hd__decap_3
XFILLER_62_189 VGND VGND VPWR VPWR sky130_fd_sc_hd__decap_3
XFILLER_16_595 VGND VGND VPWR VPWR sky130_fd_sc_hd__decap_3
XFILLER_31_532 VGND VGND VPWR VPWR sky130_fd_sc_hd__decap_3
XTAP_TAPCELL_ROW_61_858 VGND VPWR sky130_fd_sc_hd__tapvpwrvgnd_1
XFILLER_79_3 VGND VGND VPWR VPWR sky130_fd_sc_hd__fill_1
X_5570_ _6722_/A _5569_/X _5820_/A VGND VGND VPWR VPWR _5570_/Y sky130_fd_sc_hd__a21oi_2
X_4521_ _4518_/A _4518_/B _4520_/B _4517_/X VGND VGND VPWR VPWR _4523_/B sky130_fd_sc_hd__a31o_2
X_4452_ _4445_/A _4443_/Y _4382_/Y _4441_/A VGND VGND VPWR VPWR _4452_/X sky130_fd_sc_hd__o211a_2
X_4383_ _4308_/X _4380_/Y _4375_/X _4351_/Y VGND VGND VPWR VPWR _4383_/X sky130_fd_sc_hd__o211a_2
X_6122_ _6122_/A _6122_/B VGND VGND VPWR VPWR _6506_/A sky130_fd_sc_hd__or2_2
XFILLER_98_554 VGND VGND VPWR VPWR sky130_fd_sc_hd__decap_3
XFILLER_100_526 VGND VGND VPWR VPWR sky130_fd_sc_hd__decap_3
X_6053_ _6053_/A _6053_/B VGND VGND VPWR VPWR _6054_/B sky130_fd_sc_hd__xnor2_2
XFILLER_100_559 VGND VGND VPWR VPWR sky130_fd_sc_hd__fill_1
XFILLER_85_237 VGND VGND VPWR VPWR sky130_fd_sc_hd__decap_3
Xload_slew196 input8/X VGND VGND VPWR VPWR fanout194/A sky130_fd_sc_hd__buf_4
Xload_slew185 _6098_/B VGND VGND VPWR VPWR _3655_/A sky130_fd_sc_hd__clkbuf_4
X_5004_ _5000_/Y _5002_/Y _5003_/X _4880_/Y VGND VGND VPWR VPWR _5007_/B sky130_fd_sc_hd__o211ai_4
XFILLER_38_131 VGND VGND VPWR VPWR sky130_fd_sc_hd__decap_3
XFILLER_66_440 VGND VGND VPWR VPWR sky130_fd_sc_hd__decap_3
XFILLER_66_473 VGND VGND VPWR VPWR sky130_fd_sc_hd__decap_3
XFILLER_26_315 VGND VGND VPWR VPWR sky130_fd_sc_hd__fill_2
XFILLER_38_197 VGND VGND VPWR VPWR sky130_fd_sc_hd__fill_2
XFILLER_81_410 VGND VGND VPWR VPWR sky130_fd_sc_hd__decap_3
XFILLER_93_281 VGND VGND VPWR VPWR sky130_fd_sc_hd__decap_3
XFILLER_53_134 VGND VGND VPWR VPWR sky130_fd_sc_hd__decap_3
X_6955_ _6955_/A _6955_/B VGND VGND VPWR VPWR _6955_/Y sky130_fd_sc_hd__nor2_2
XFILLER_41_307 VGND VGND VPWR VPWR sky130_fd_sc_hd__fill_1
XFILLER_41_318 VGND VGND VPWR VPWR sky130_fd_sc_hd__decap_3
XFILLER_53_189 VGND VGND VPWR VPWR sky130_fd_sc_hd__decap_3
X_5906_ _5898_/X _5903_/Y _4913_/X _4915_/Y VGND VGND VPWR VPWR _5907_/B sky130_fd_sc_hd__a211oi_2
XFILLER_22_543 VGND VGND VPWR VPWR sky130_fd_sc_hd__decap_3
X_6886_ _6872_/Y _6873_/X _6885_/X VGND VGND VPWR VPWR _6991_/A sky130_fd_sc_hd__o21bai_2
X_5837_ _5839_/C1 _5833_/Y _5835_/Y _5252_/X VGND VGND VPWR VPWR _5837_/Y sky130_fd_sc_hd__o211ai_2
X_5768_ _5783_/A _5783_/B _5767_/A VGND VGND VPWR VPWR _5773_/A sky130_fd_sc_hd__o21a_2
X_4719_ _4719_/A _4719_/B _4719_/C VGND VGND VPWR VPWR _4950_/A sky130_fd_sc_hd__or3_4
X_5699_ _6124_/A _5698_/C _5698_/A VGND VGND VPWR VPWR _5700_/C sky130_fd_sc_hd__o21bai_2
XFILLER_89_554 VGND VGND VPWR VPWR sky130_fd_sc_hd__decap_3
XFILLER_39_66 VGND VGND VPWR VPWR sky130_fd_sc_hd__decap_3
XFILLER_76_204 VGND VGND VPWR VPWR sky130_fd_sc_hd__decap_3
XFILLER_76_215 VGND VGND VPWR VPWR sky130_fd_sc_hd__fill_2
XFILLER_89_576 VGND VGND VPWR VPWR sky130_fd_sc_hd__decap_3
XFILLER_76_248 VGND VGND VPWR VPWR sky130_fd_sc_hd__decap_3
XFILLER_76_259 VGND VGND VPWR VPWR sky130_fd_sc_hd__decap_3
XFILLER_17_304 VGND VGND VPWR VPWR sky130_fd_sc_hd__fill_2
XFILLER_57_462 VGND VGND VPWR VPWR sky130_fd_sc_hd__decap_3
XTAP_TAPCELL_ROW_4_263 VGND VPWR sky130_fd_sc_hd__tapvpwrvgnd_1
XFILLER_57_473 VGND VGND VPWR VPWR sky130_fd_sc_hd__decap_3
XFILLER_72_410 VGND VGND VPWR VPWR sky130_fd_sc_hd__decap_3
XFILLER_72_421 VGND VGND VPWR VPWR sky130_fd_sc_hd__decap_3
XFILLER_44_123 VGND VGND VPWR VPWR sky130_fd_sc_hd__decap_3
XFILLER_72_443 VGND VGND VPWR VPWR sky130_fd_sc_hd__decap_3
XFILLER_25_370 VGND VGND VPWR VPWR sky130_fd_sc_hd__decap_3
XFILLER_55_98 VGND VGND VPWR VPWR sky130_fd_sc_hd__decap_3
XFILLER_40_340 VGND VGND VPWR VPWR sky130_fd_sc_hd__fill_2
XFILLER_40_351 VGND VGND VPWR VPWR sky130_fd_sc_hd__decap_3
XFILLER_9_514 VGND VGND VPWR VPWR sky130_fd_sc_hd__fill_1
XFILLER_9_503 VGND VGND VPWR VPWR sky130_fd_sc_hd__fill_1
XFILLER_71_97 VGND VGND VPWR VPWR sky130_fd_sc_hd__decap_3
XTAP_TAPCELL_ROW_78_1031 VGND VPWR sky130_fd_sc_hd__tapvpwrvgnd_1
XFILLER_99_318 VGND VGND VPWR VPWR sky130_fd_sc_hd__decap_3
XFILLER_4_263 VGND VGND VPWR VPWR sky130_fd_sc_hd__decap_3
XFILLER_0_491 VGND VGND VPWR VPWR sky130_fd_sc_hd__decap_3
XFILLER_67_237 VGND VGND VPWR VPWR sky130_fd_sc_hd__decap_3
XFILLER_67_248 VGND VGND VPWR VPWR sky130_fd_sc_hd__decap_3
XFILLER_48_451 VGND VGND VPWR VPWR sky130_fd_sc_hd__decap_3
XTAP_TAPCELL_ROW_66_906 VGND VPWR sky130_fd_sc_hd__tapvpwrvgnd_1
XTAP_TAPCELL_ROW_38_619 VGND VPWR sky130_fd_sc_hd__tapvpwrvgnd_1
XFILLER_75_270 VGND VGND VPWR VPWR sky130_fd_sc_hd__decap_3
XFILLER_75_281 VGND VGND VPWR VPWR sky130_fd_sc_hd__decap_3
XFILLER_82_229 VGND VGND VPWR VPWR sky130_fd_sc_hd__decap_3
XFILLER_35_178 VGND VGND VPWR VPWR sky130_fd_sc_hd__decap_3
XFILLER_63_476 VGND VGND VPWR VPWR sky130_fd_sc_hd__decap_3
XFILLER_63_487 VGND VGND VPWR VPWR sky130_fd_sc_hd__fill_1
XFILLER_90_262 VGND VGND VPWR VPWR sky130_fd_sc_hd__decap_3
X_6740_ _6255_/A _6255_/C _6757_/C VGND VGND VPWR VPWR _6740_/Y sky130_fd_sc_hd__o21ai_2
XTAP_TAPCELL_ROW_74_994 VGND VPWR sky130_fd_sc_hd__tapvpwrvgnd_1
XFILLER_16_381 VGND VGND VPWR VPWR sky130_fd_sc_hd__fill_2
XFILLER_50_137 VGND VGND VPWR VPWR sky130_fd_sc_hd__decap_3
XFILLER_90_284 VGND VGND VPWR VPWR sky130_fd_sc_hd__decap_3
XFILLER_90_295 VGND VGND VPWR VPWR sky130_fd_sc_hd__decap_3
X_3952_ _3842_/A _3952_/B VGND VGND VPWR VPWR _3953_/B sky130_fd_sc_hd__nand2b_2
XTAP_TAPCELL_ROW_46_696 VGND VPWR sky130_fd_sc_hd__tapvpwrvgnd_1
X_6671_ _6672_/B _6212_/X _6240_/X _6757_/C _6670_/Y VGND VGND VPWR VPWR _6671_/X
+ sky130_fd_sc_hd__o311a_2
X_3883_ _3884_/A _3884_/B VGND VGND VPWR VPWR _3883_/Y sky130_fd_sc_hd__nand2b_2
X_5622_ _5594_/A _5594_/C _5594_/B VGND VGND VPWR VPWR _5634_/B sky130_fd_sc_hd__o21ai_2
X_5553_ _5555_/A _5553_/B VGND VGND VPWR VPWR _5574_/B sky130_fd_sc_hd__xnor2_2
X_4504_ _4392_/A _4391_/C _6378_/A VGND VGND VPWR VPWR _4504_/X sky130_fd_sc_hd__a21o_2
XFILLER_6_70 VGND VGND VPWR VPWR sky130_fd_sc_hd__decap_3
X_5484_ _5552_/A _5555_/A VGND VGND VPWR VPWR _5486_/A sky130_fd_sc_hd__nor2_4
X_4435_ _4436_/A _4436_/B _4436_/C VGND VGND VPWR VPWR _4435_/X sky130_fd_sc_hd__and3_2
Xfanout504 _5999_/A1 VGND VGND VPWR VPWR _3578_/A sky130_fd_sc_hd__clkdlybuf4s25_1
Xfanout515 _5976_/B VGND VGND VPWR VPWR _3647_/A sky130_fd_sc_hd__clkdlybuf4s25_1
X_4366_ _4360_/A _4360_/C _4360_/B VGND VGND VPWR VPWR _4367_/C sky130_fd_sc_hd__a21o_2
XFILLER_58_215 VGND VGND VPWR VPWR sky130_fd_sc_hd__decap_3
Xfanout526 input29/X VGND VGND VPWR VPWR _6621_/A3 sky130_fd_sc_hd__clkbuf_2
Xfanout537 _6606_/A3 VGND VGND VPWR VPWR _6217_/B sky130_fd_sc_hd__clkdlybuf4s25_1
Xfanout548 input27/X VGND VGND VPWR VPWR _5383_/A sky130_fd_sc_hd__buf_6
X_6105_ _6105_/A _6212_/B VGND VGND VPWR VPWR _6378_/B sky130_fd_sc_hd__nor2_2
XFILLER_98_384 VGND VGND VPWR VPWR sky130_fd_sc_hd__fill_2
XFILLER_100_312 VGND VGND VPWR VPWR sky130_fd_sc_hd__decap_3
XFILLER_58_248 VGND VGND VPWR VPWR sky130_fd_sc_hd__decap_3
X_4297_ _4294_/X _4297_/B _6265_/B _4539_/B VGND VGND VPWR VPWR _4425_/A sky130_fd_sc_hd__and4b_2
XFILLER_100_345 VGND VGND VPWR VPWR sky130_fd_sc_hd__decap_3
XFILLER_58_259 VGND VGND VPWR VPWR sky130_fd_sc_hd__decap_3
X_6036_ _6036_/A _6036_/B VGND VGND VPWR VPWR _6046_/B sky130_fd_sc_hd__xnor2_2
XFILLER_26_101 VGND VGND VPWR VPWR sky130_fd_sc_hd__fill_1
XFILLER_39_484 VGND VGND VPWR VPWR sky130_fd_sc_hd__fill_1
XFILLER_54_421 VGND VGND VPWR VPWR sky130_fd_sc_hd__decap_3
XFILLER_66_270 VGND VGND VPWR VPWR sky130_fd_sc_hd__decap_3
XFILLER_66_281 VGND VGND VPWR VPWR sky130_fd_sc_hd__decap_3
XFILLER_73_218 VGND VGND VPWR VPWR sky130_fd_sc_hd__decap_3
XFILLER_54_454 VGND VGND VPWR VPWR sky130_fd_sc_hd__fill_2
XFILLER_14_318 VGND VGND VPWR VPWR sky130_fd_sc_hd__decap_3
XFILLER_41_104 VGND VGND VPWR VPWR sky130_fd_sc_hd__decap_3
XFILLER_25_57 VGND VGND VPWR VPWR sky130_fd_sc_hd__decap_3
XFILLER_41_126 VGND VGND VPWR VPWR sky130_fd_sc_hd__fill_2
XFILLER_81_284 VGND VGND VPWR VPWR sky130_fd_sc_hd__decap_3
X_6938_ _6205_/A input20/X input19/X input18/X input33/X _6938_/S1 VGND VGND VPWR
+ VPWR _6938_/X sky130_fd_sc_hd__mux4_2
XFILLER_41_159 VGND VGND VPWR VPWR sky130_fd_sc_hd__fill_1
X_6869_ _6900_/A3 _6860_/X _6861_/X _6868_/X _6859_/Y VGND VGND VPWR VPWR _6869_/X
+ sky130_fd_sc_hd__a311o_2
XFILLER_41_67 VGND VGND VPWR VPWR sky130_fd_sc_hd__decap_3
XTAP_TAPCELL_ROW_9_311 VGND VPWR sky130_fd_sc_hd__tapvpwrvgnd_1
XFILLER_9_3 VGND VGND VPWR VPWR sky130_fd_sc_hd__decap_3
XFILLER_1_266 VGND VGND VPWR VPWR sky130_fd_sc_hd__decap_3
XFILLER_1_299 VGND VGND VPWR VPWR sky130_fd_sc_hd__decap_3
XFILLER_49_237 VGND VGND VPWR VPWR sky130_fd_sc_hd__decap_3
XFILLER_66_42 VGND VGND VPWR VPWR sky130_fd_sc_hd__decap_3
XFILLER_57_281 VGND VGND VPWR VPWR sky130_fd_sc_hd__fill_2
XFILLER_64_218 VGND VGND VPWR VPWR sky130_fd_sc_hd__decap_3
XFILLER_57_292 VGND VGND VPWR VPWR sky130_fd_sc_hd__decap_3
XFILLER_72_262 VGND VGND VPWR VPWR sky130_fd_sc_hd__decap_3
XFILLER_82_41 VGND VGND VPWR VPWR sky130_fd_sc_hd__fill_1
XFILLER_32_137 VGND VGND VPWR VPWR sky130_fd_sc_hd__decap_3
XFILLER_60_457 VGND VGND VPWR VPWR sky130_fd_sc_hd__decap_3
XFILLER_82_85 VGND VGND VPWR VPWR sky130_fd_sc_hd__decap_3
XTAP_TAPCELL_ROW_71_964 VGND VPWR sky130_fd_sc_hd__tapvpwrvgnd_1
XTAP_TAPCELL_ROW_43_666 VGND VPWR sky130_fd_sc_hd__tapvpwrvgnd_1
XTAP_TAPCELL_ROW_15_379 VGND VPWR sky130_fd_sc_hd__tapvpwrvgnd_1
XFILLER_9_311 VGND VGND VPWR VPWR sky130_fd_sc_hd__decap_3
XFILLER_5_594 VGND VGND VPWR VPWR sky130_fd_sc_hd__decap_3
X_4220_ _4220_/A _4220_/B _4220_/C VGND VGND VPWR VPWR _4223_/B sky130_fd_sc_hd__and3_2
X_4151_ _4151_/A _4151_/B VGND VGND VPWR VPWR _4248_/A sky130_fd_sc_hd__xnor2_2
XFILLER_95_332 VGND VGND VPWR VPWR sky130_fd_sc_hd__decap_3
XFILLER_55_207 VGND VGND VPWR VPWR sky130_fd_sc_hd__decap_3
XFILLER_83_516 VGND VGND VPWR VPWR sky130_fd_sc_hd__decap_3
X_4082_ _4083_/B _4083_/A VGND VGND VPWR VPWR _4082_/X sky130_fd_sc_hd__and2b_2
XFILLER_95_376 VGND VGND VPWR VPWR sky130_fd_sc_hd__fill_1
XFILLER_48_292 VGND VGND VPWR VPWR sky130_fd_sc_hd__decap_3
XFILLER_51_413 VGND VGND VPWR VPWR sky130_fd_sc_hd__fill_1
XFILLER_63_240 VGND VGND VPWR VPWR sky130_fd_sc_hd__decap_3
XFILLER_63_273 VGND VGND VPWR VPWR sky130_fd_sc_hd__decap_3
XFILLER_63_284 VGND VGND VPWR VPWR sky130_fd_sc_hd__decap_3
X_4984_ _4986_/A _4986_/B VGND VGND VPWR VPWR _4984_/X sky130_fd_sc_hd__and2b_2
XFILLER_51_479 VGND VGND VPWR VPWR sky130_fd_sc_hd__decap_3
X_6723_ _5568_/Y _6723_/A2 _5820_/B VGND VGND VPWR VPWR _6724_/B sky130_fd_sc_hd__o21bai_2
X_3935_ _3935_/A _3935_/B VGND VGND VPWR VPWR _3937_/A sky130_fd_sc_hd__nor2_2
X_6654_ _6655_/A _6655_/B VGND VGND VPWR VPWR _6654_/X sky130_fd_sc_hd__or2_2
X_5605_ _5562_/A _5558_/C _5558_/A VGND VGND VPWR VPWR _5606_/C sky130_fd_sc_hd__o21ai_2
X_3866_ _3866_/A _3866_/B VGND VGND VPWR VPWR _3884_/A sky130_fd_sc_hd__xnor2_2
X_6585_ _6488_/X _6499_/X _6500_/X _6502_/X _6589_/A _6493_/A VGND VGND VPWR VPWR
+ _6586_/B sky130_fd_sc_hd__mux4_2
X_3797_ _3797_/A _3797_/B VGND VGND VPWR VPWR _3799_/B sky130_fd_sc_hd__nor2_2
XTAP_TAPCELL_ROW_98_1248 VGND VPWR sky130_fd_sc_hd__tapvpwrvgnd_1
X_5536_ _5636_/A _5536_/B VGND VGND VPWR VPWR _5583_/A sky130_fd_sc_hd__nand2_2
X_5467_ _5464_/X _5466_/C _5437_/B VGND VGND VPWR VPWR _5467_/X sky130_fd_sc_hd__a21bo_4
XFILLER_87_19 VGND VGND VPWR VPWR sky130_fd_sc_hd__fill_2
X_4418_ _4418_/A _4418_/B VGND VGND VPWR VPWR _4431_/A sky130_fd_sc_hd__nor2_4
Xfanout301 _6545_/A VGND VGND VPWR VPWR _6315_/A sky130_fd_sc_hd__clkdlybuf4s25_1
Xfanout312 input51/X VGND VGND VPWR VPWR _6178_/A sky130_fd_sc_hd__clkdlybuf4s25_1
X_5398_ _5630_/A _5659_/A _5398_/C _5490_/D VGND VGND VPWR VPWR _5398_/X sky130_fd_sc_hd__and4_2
XFILLER_59_535 VGND VGND VPWR VPWR sky130_fd_sc_hd__decap_3
XFILLER_86_332 VGND VGND VPWR VPWR sky130_fd_sc_hd__decap_3
Xfanout345 wire357/A VGND VGND VPWR VPWR _5536_/B sky130_fd_sc_hd__clkdlybuf4s25_1
Xfanout356 input44/X VGND VGND VPWR VPWR wire357/A sky130_fd_sc_hd__clkdlybuf4s25_1
X_4349_ _4249_/B _4249_/A _4249_/C VGND VGND VPWR VPWR _4350_/C sky130_fd_sc_hd__o21ai_2
XFILLER_86_354 VGND VGND VPWR VPWR sky130_fd_sc_hd__decap_3
XFILLER_86_365 VGND VGND VPWR VPWR sky130_fd_sc_hd__decap_3
Xfanout367 input44/X VGND VGND VPWR VPWR _6938_/S1 sky130_fd_sc_hd__clkbuf_4
Xfanout389 _3923_/A VGND VGND VPWR VPWR _4925_/C sky130_fd_sc_hd__buf_6
XFILLER_46_218 VGND VGND VPWR VPWR sky130_fd_sc_hd__decap_3
XFILLER_74_527 VGND VGND VPWR VPWR sky130_fd_sc_hd__decap_3
XFILLER_86_398 VGND VGND VPWR VPWR sky130_fd_sc_hd__decap_3
X_6019_ _6019_/A _6019_/B _6019_/C _6019_/D VGND VGND VPWR VPWR _6021_/D sky130_fd_sc_hd__and4_2
XFILLER_100_197 VGND VGND VPWR VPWR sky130_fd_sc_hd__fill_2
XFILLER_27_432 VGND VGND VPWR VPWR sky130_fd_sc_hd__fill_1
XFILLER_39_281 VGND VGND VPWR VPWR sky130_fd_sc_hd__decap_3
XFILLER_14_104 VGND VGND VPWR VPWR sky130_fd_sc_hd__decap_3
XFILLER_27_487 VGND VGND VPWR VPWR sky130_fd_sc_hd__decap_3
XFILLER_36_56 VGND VGND VPWR VPWR sky130_fd_sc_hd__decap_3
XFILLER_42_424 VGND VGND VPWR VPWR sky130_fd_sc_hd__decap_3
XFILLER_54_284 VGND VGND VPWR VPWR sky130_fd_sc_hd__fill_2
XFILLER_54_295 VGND VGND VPWR VPWR sky130_fd_sc_hd__decap_3
XFILLER_14_159 VGND VGND VPWR VPWR sky130_fd_sc_hd__fill_2
XTAP_TAPCELL_ROW_40_636 VGND VPWR sky130_fd_sc_hd__tapvpwrvgnd_1
XFILLER_10_321 VGND VGND VPWR VPWR sky130_fd_sc_hd__decap_3
XFILLER_52_88 VGND VGND VPWR VPWR sky130_fd_sc_hd__decap_3
XTAP_TAPCELL_ROW_12_338 VGND VPWR sky130_fd_sc_hd__tapvpwrvgnd_1
XFILLER_10_365 VGND VGND VPWR VPWR sky130_fd_sc_hd__decap_3
XFILLER_6_336 VGND VGND VPWR VPWR sky130_fd_sc_hd__fill_2
XTAP_TAPCELL_ROW_75_1001 VGND VPWR sky130_fd_sc_hd__tapvpwrvgnd_1
XFILLER_77_332 VGND VGND VPWR VPWR sky130_fd_sc_hd__decap_3
XFILLER_65_505 VGND VGND VPWR VPWR sky130_fd_sc_hd__fill_1
XFILLER_18_410 VGND VGND VPWR VPWR sky130_fd_sc_hd__fill_2
XFILLER_37_218 VGND VGND VPWR VPWR sky130_fd_sc_hd__decap_3
XFILLER_92_302 VGND VGND VPWR VPWR sky130_fd_sc_hd__decap_3
XTAP_TAPCELL_ROW_48_725 VGND VPWR sky130_fd_sc_hd__tapvpwrvgnd_1
XFILLER_18_421 VGND VGND VPWR VPWR sky130_fd_sc_hd__decap_3
XFILLER_80_508 VGND VGND VPWR VPWR sky130_fd_sc_hd__fill_2
XFILLER_92_335 VGND VGND VPWR VPWR sky130_fd_sc_hd__decap_3
XFILLER_45_251 VGND VGND VPWR VPWR sky130_fd_sc_hd__fill_1
XFILLER_92_368 VGND VGND VPWR VPWR sky130_fd_sc_hd__decap_3
XFILLER_33_446 VGND VGND VPWR VPWR sky130_fd_sc_hd__fill_2
XFILLER_60_243 VGND VGND VPWR VPWR sky130_fd_sc_hd__decap_3
X_3720_ _3720_/A _4526_/B _3721_/A _3720_/D VGND VGND VPWR VPWR _3754_/A sky130_fd_sc_hd__nand4_2
X_3651_ _3651_/A _4132_/A VGND VGND VPWR VPWR _3652_/C sky130_fd_sc_hd__nand2_2
XFILLER_61_3 VGND VGND VPWR VPWR sky130_fd_sc_hd__decap_3
X_6370_ _6370_/A _6586_/A VGND VGND VPWR VPWR _6370_/Y sky130_fd_sc_hd__nand2_2
X_3582_ _3583_/A _3582_/B _3582_/C VGND VGND VPWR VPWR _4094_/A sky130_fd_sc_hd__nand3_2
X_5321_ _5321_/A _5321_/B _5321_/C _5321_/D VGND VGND VPWR VPWR _5321_/X sky130_fd_sc_hd__and4_2
X_5252_ _5835_/B1 _5248_/B _5249_/Y _5251_/X VGND VGND VPWR VPWR _5252_/X sky130_fd_sc_hd__a211o_4
XTAP_TAPCELL_ROW_93_1189 VGND VPWR sky130_fd_sc_hd__tapvpwrvgnd_1
X_5183_ _5180_/A _5180_/C _5180_/B VGND VGND VPWR VPWR _5184_/B sky130_fd_sc_hd__a21o_2
X_4203_ _4203_/A _4203_/B VGND VGND VPWR VPWR _4204_/B sky130_fd_sc_hd__xnor2_2
XFILLER_3_82 VGND VGND VPWR VPWR sky130_fd_sc_hd__fill_1
XFILLER_56_505 VGND VGND VPWR VPWR sky130_fd_sc_hd__decap_3
X_4134_ _4134_/A _4134_/B VGND VGND VPWR VPWR _4135_/C sky130_fd_sc_hd__xnor2_2
XFILLER_28_218 VGND VGND VPWR VPWR sky130_fd_sc_hd__fill_2
XFILLER_83_302 VGND VGND VPWR VPWR sky130_fd_sc_hd__decap_3
XFILLER_56_549 VGND VGND VPWR VPWR sky130_fd_sc_hd__decap_3
XFILLER_83_346 VGND VGND VPWR VPWR sky130_fd_sc_hd__fill_2
X_4065_ _4065_/A _4065_/B VGND VGND VPWR VPWR _4068_/A sky130_fd_sc_hd__or2_2
XFILLER_71_508 VGND VGND VPWR VPWR sky130_fd_sc_hd__decap_3
XFILLER_83_368 VGND VGND VPWR VPWR sky130_fd_sc_hd__decap_3
XFILLER_24_424 VGND VGND VPWR VPWR sky130_fd_sc_hd__fill_2
XFILLER_24_435 VGND VGND VPWR VPWR sky130_fd_sc_hd__fill_1
XFILLER_24_468 VGND VGND VPWR VPWR sky130_fd_sc_hd__fill_1
XFILLER_51_287 VGND VGND VPWR VPWR sky130_fd_sc_hd__decap_3
X_4967_ _4967_/A _4967_/B _4967_/C VGND VGND VPWR VPWR _5052_/A sky130_fd_sc_hd__or3_4
X_6706_ _5568_/Y _6706_/A2 _5820_/B _6923_/A _6705_/Y VGND VGND VPWR VPWR _6706_/X
+ sky130_fd_sc_hd__o311a_2
X_4898_ _4826_/A _4568_/B _4577_/B _4575_/X VGND VGND VPWR VPWR _4899_/B sky130_fd_sc_hd__a31o_2
X_3918_ _3918_/A _4036_/A VGND VGND VPWR VPWR _3950_/A sky130_fd_sc_hd__nor2_2
XFILLER_22_47 VGND VGND VPWR VPWR sky130_fd_sc_hd__decap_3
X_6637_ _6453_/X _6567_/B _6477_/X _6478_/X _6589_/B _3500_/Y VGND VGND VPWR VPWR
+ _6638_/B sky130_fd_sc_hd__mux4_2
X_3849_ _3941_/C _6014_/C _3836_/B _3834_/X VGND VGND VPWR VPWR _3857_/A sky130_fd_sc_hd__a31o_2
XFILLER_22_69 VGND VGND VPWR VPWR sky130_fd_sc_hd__decap_3
X_6568_ _6569_/A _6457_/B _6567_/X _6608_/S VGND VGND VPWR VPWR _6568_/X sky130_fd_sc_hd__o211a_2
X_5519_ _5520_/B1 _5471_/X _5516_/X _5518_/Y VGND VGND VPWR VPWR _6722_/A sky130_fd_sc_hd__o211ai_2
XFILLER_98_29 VGND VGND VPWR VPWR sky130_fd_sc_hd__fill_1
X_6499_ _6427_/Y _6429_/X _6499_/S VGND VGND VPWR VPWR _6499_/X sky130_fd_sc_hd__mux2_1
XFILLER_59_310 VGND VGND VPWR VPWR sky130_fd_sc_hd__decap_3
Xfanout131 _6338_/X VGND VGND VPWR VPWR _6928_/B1 sky130_fd_sc_hd__clkdlybuf4s25_1
XFILLER_47_505 VGND VGND VPWR VPWR sky130_fd_sc_hd__decap_3
XFILLER_59_343 VGND VGND VPWR VPWR sky130_fd_sc_hd__fill_2
Xfanout142 _6330_/X VGND VGND VPWR VPWR _6963_/A2 sky130_fd_sc_hd__clkdlybuf4s25_1
Xfanout153 _6288_/Y VGND VGND VPWR VPWR _6542_/B2 sky130_fd_sc_hd__clkdlybuf4s25_1
XFILLER_59_376 VGND VGND VPWR VPWR sky130_fd_sc_hd__decap_3
XFILLER_74_324 VGND VGND VPWR VPWR sky130_fd_sc_hd__fill_2
XFILLER_86_151 VGND VGND VPWR VPWR sky130_fd_sc_hd__decap_3
Xfanout186 fanout186/A VGND VGND VPWR VPWR _6024_/B sky130_fd_sc_hd__clkdlybuf4s25_1
Xfanout197 _3748_/A VGND VGND VPWR VPWR _5452_/A sky130_fd_sc_hd__buf_4
XFILLER_86_195 VGND VGND VPWR VPWR sky130_fd_sc_hd__fill_1
XFILLER_47_99 VGND VGND VPWR VPWR sky130_fd_sc_hd__decap_3
XFILLER_55_582 VGND VGND VPWR VPWR sky130_fd_sc_hd__fill_1
XFILLER_63_54 VGND VGND VPWR VPWR sky130_fd_sc_hd__fill_2
XFILLER_70_541 VGND VGND VPWR VPWR sky130_fd_sc_hd__decap_3
XTAP_TAPCELL_ROW_53_772 VGND VPWR sky130_fd_sc_hd__tapvpwrvgnd_1
XTAP_TAPCELL_ROW_81_1071 VGND VPWR sky130_fd_sc_hd__tapvpwrvgnd_1
Xwire532 wire532/A VGND VGND VPWR VPWR _4482_/B sky130_fd_sc_hd__buf_4
XFILLER_6_111 VGND VGND VPWR VPWR sky130_fd_sc_hd__decap_3
Xwire576 _6068_/B VGND VGND VPWR VPWR _3867_/A sky130_fd_sc_hd__clkbuf_4
XFILLER_6_155 VGND VGND VPWR VPWR sky130_fd_sc_hd__decap_3
XFILLER_88_62 VGND VGND VPWR VPWR sky130_fd_sc_hd__decap_3
XFILLER_2_383 VGND VGND VPWR VPWR sky130_fd_sc_hd__fill_1
XFILLER_97_449 VGND VGND VPWR VPWR sky130_fd_sc_hd__decap_3
XFILLER_2_394 VGND VGND VPWR VPWR sky130_fd_sc_hd__fill_1
Xload_slew559 _4651_/A VGND VGND VPWR VPWR _6002_/A1 sky130_fd_sc_hd__buf_4
XFILLER_38_516 VGND VGND VPWR VPWR sky130_fd_sc_hd__decap_3
XFILLER_38_527 VGND VGND VPWR VPWR sky130_fd_sc_hd__decap_3
XFILLER_65_346 VGND VGND VPWR VPWR sky130_fd_sc_hd__decap_3
XFILLER_53_508 VGND VGND VPWR VPWR sky130_fd_sc_hd__decap_3
XFILLER_80_305 VGND VGND VPWR VPWR sky130_fd_sc_hd__decap_3
X_5870_ _5871_/C _5871_/D VGND VGND VPWR VPWR _6739_/B sky130_fd_sc_hd__or2_2
XFILLER_33_243 VGND VGND VPWR VPWR sky130_fd_sc_hd__decap_3
X_4821_ _4818_/X _4819_/Y _4775_/X _4777_/Y VGND VGND VPWR VPWR _4828_/B sky130_fd_sc_hd__a211o_2
XFILLER_61_596 VGND VGND VPWR VPWR sky130_fd_sc_hd__fill_2
X_4752_ _4749_/A _5680_/B _4751_/B _4748_/X VGND VGND VPWR VPWR _4754_/B sky130_fd_sc_hd__a31o_2
Xrebuffer709 _5143_/Y VGND VGND VPWR VPWR _5217_/A2 sky130_fd_sc_hd__buf_2
X_4683_ _4683_/A _4683_/B VGND VGND VPWR VPWR _4713_/A sky130_fd_sc_hd__xnor2_2
X_3703_ _3703_/A _3703_/B VGND VGND VPWR VPWR _3704_/B sky130_fd_sc_hd__xnor2_2
X_6422_ _6569_/B _6730_/A _6420_/B VGND VGND VPWR VPWR _6547_/B sky130_fd_sc_hd__o21ai_2
X_3634_ _4054_/A _3633_/B _3633_/C VGND VGND VPWR VPWR _3634_/X sky130_fd_sc_hd__o21a_2
XTAP_TAPCELL_ROW_95_1218 VGND VPWR sky130_fd_sc_hd__tapvpwrvgnd_1
X_6353_ _6384_/A _6336_/A _6353_/C _6353_/D VGND VGND VPWR VPWR _6353_/X sky130_fd_sc_hd__and4bb_2
X_3565_ _3565_/A _3565_/B _3565_/C VGND VGND VPWR VPWR _3567_/B sky130_fd_sc_hd__nand3_2
XFILLER_0_309 VGND VGND VPWR VPWR sky130_fd_sc_hd__decap_3
X_6284_ _6348_/C _6284_/B VGND VGND VPWR VPWR _6284_/X sky130_fd_sc_hd__and2_2
X_5304_ _5321_/B _5304_/B _5304_/C VGND VGND VPWR VPWR _5524_/A sky130_fd_sc_hd__and3_2
X_3496_ _6265_/B VGND VGND VPWR VPWR _6264_/B sky130_fd_sc_hd__inv_2
XFILLER_88_427 VGND VGND VPWR VPWR sky130_fd_sc_hd__decap_3
X_5235_ _5236_/A _5236_/B VGND VGND VPWR VPWR _5235_/Y sky130_fd_sc_hd__nand2b_2
XFILLER_29_505 VGND VGND VPWR VPWR sky130_fd_sc_hd__decap_3
XFILLER_29_516 VGND VGND VPWR VPWR sky130_fd_sc_hd__decap_3
XFILLER_56_302 VGND VGND VPWR VPWR sky130_fd_sc_hd__decap_3
XFILLER_68_173 VGND VGND VPWR VPWR sky130_fd_sc_hd__decap_3
X_5166_ _5166_/A _5166_/B _5166_/C VGND VGND VPWR VPWR _5166_/X sky130_fd_sc_hd__or3_4
X_5097_ _4802_/Y _4804_/Y _5098_/A _5096_/X VGND VGND VPWR VPWR _5098_/B sky130_fd_sc_hd__a211oi_2
X_4117_ _4483_/A _4476_/B VGND VGND VPWR VPWR _4216_/A sky130_fd_sc_hd__nand2_2
XFILLER_56_357 VGND VGND VPWR VPWR sky130_fd_sc_hd__decap_3
XFILLER_56_368 VGND VGND VPWR VPWR sky130_fd_sc_hd__decap_3
XFILLER_71_305 VGND VGND VPWR VPWR sky130_fd_sc_hd__decap_3
XFILLER_83_143 VGND VGND VPWR VPWR sky130_fd_sc_hd__decap_3
X_4048_ _4048_/A _4048_/B _4048_/C VGND VGND VPWR VPWR _4051_/B sky130_fd_sc_hd__nor3_2
XFILLER_71_349 VGND VGND VPWR VPWR sky130_fd_sc_hd__fill_2
XFILLER_83_198 VGND VGND VPWR VPWR sky130_fd_sc_hd__decap_3
XFILLER_12_427 VGND VGND VPWR VPWR sky130_fd_sc_hd__decap_3
XFILLER_52_574 VGND VGND VPWR VPWR sky130_fd_sc_hd__decap_3
XFILLER_52_585 VGND VGND VPWR VPWR sky130_fd_sc_hd__decap_3
X_5999_ _5999_/A1 _5992_/A _4015_/A _4013_/A VGND VGND VPWR VPWR _6000_/B sky130_fd_sc_hd__a31o_2
XFILLER_33_35 VGND VGND VPWR VPWR sky130_fd_sc_hd__decap_3
XFILLER_33_57 VGND VGND VPWR VPWR sky130_fd_sc_hd__decap_3
XTAP_TAPCELL_ROW_50_742 VGND VPWR sky130_fd_sc_hd__tapvpwrvgnd_1
XTAP_TAPCELL_ROW_22_444 VGND VPWR sky130_fd_sc_hd__tapvpwrvgnd_1
XFILLER_3_136 VGND VGND VPWR VPWR sky130_fd_sc_hd__fill_2
XFILLER_3_169 VGND VGND VPWR VPWR sky130_fd_sc_hd__fill_1
XFILLER_79_405 VGND VGND VPWR VPWR sky130_fd_sc_hd__decap_3
XFILLER_58_21 VGND VGND VPWR VPWR sky130_fd_sc_hd__fill_2
XFILLER_79_438 VGND VGND VPWR VPWR sky130_fd_sc_hd__decap_3
XFILLER_79_449 VGND VGND VPWR VPWR sky130_fd_sc_hd__decap_3
XFILLER_58_54 VGND VGND VPWR VPWR sky130_fd_sc_hd__decap_3
XFILLER_94_408 VGND VGND VPWR VPWR sky130_fd_sc_hd__decap_3
XFILLER_47_335 VGND VGND VPWR VPWR sky130_fd_sc_hd__fill_1
XTAP_TAPCELL_ROW_58_831 VGND VPWR sky130_fd_sc_hd__tapvpwrvgnd_1
XFILLER_35_508 VGND VGND VPWR VPWR sky130_fd_sc_hd__decap_3
XFILLER_47_357 VGND VGND VPWR VPWR sky130_fd_sc_hd__fill_1
XFILLER_62_305 VGND VGND VPWR VPWR sky130_fd_sc_hd__decap_3
XFILLER_74_165 VGND VGND VPWR VPWR sky130_fd_sc_hd__decap_3
XFILLER_62_327 VGND VGND VPWR VPWR sky130_fd_sc_hd__decap_3
XFILLER_74_75 VGND VGND VPWR VPWR sky130_fd_sc_hd__decap_3
XFILLER_15_221 VGND VGND VPWR VPWR sky130_fd_sc_hd__decap_3
XFILLER_43_552 VGND VGND VPWR VPWR sky130_fd_sc_hd__decap_3
XFILLER_55_390 VGND VGND VPWR VPWR sky130_fd_sc_hd__fill_2
XFILLER_15_276 VGND VGND VPWR VPWR sky130_fd_sc_hd__decap_3
XFILLER_30_224 VGND VGND VPWR VPWR sky130_fd_sc_hd__decap_3
XFILLER_30_246 VGND VGND VPWR VPWR sky130_fd_sc_hd__decap_3
XFILLER_70_382 VGND VGND VPWR VPWR sky130_fd_sc_hd__decap_3
XFILLER_11_460 VGND VGND VPWR VPWR sky130_fd_sc_hd__decap_3
XFILLER_90_85 VGND VGND VPWR VPWR sky130_fd_sc_hd__decap_3
XFILLER_90_96 VGND VGND VPWR VPWR sky130_fd_sc_hd__decap_3
XFILLER_11_482 VGND VGND VPWR VPWR sky130_fd_sc_hd__decap_3
Xmax_cap117 _4378_/Y VGND VGND VPWR VPWR _4439_/C1 sky130_fd_sc_hd__buf_1
Xmax_cap106 _5182_/A1 VGND VGND VPWR VPWR _5258_/B1 sky130_fd_sc_hd__buf_1
XFILLER_99_61 VGND VGND VPWR VPWR sky130_fd_sc_hd__fill_1
XFILLER_99_50 VGND VGND VPWR VPWR sky130_fd_sc_hd__fill_2
XFILLER_99_94 VGND VGND VPWR VPWR sky130_fd_sc_hd__decap_3
XFILLER_85_408 VGND VGND VPWR VPWR sky130_fd_sc_hd__decap_3
Xload_slew334 _4211_/D VGND VGND VPWR VPWR _6083_/A sky130_fd_sc_hd__clkbuf_4
Xload_slew323 _6102_/A VGND VGND VPWR VPWR _3663_/A sky130_fd_sc_hd__buf_4
X_5020_ _5020_/A _5020_/B VGND VGND VPWR VPWR _5103_/B sky130_fd_sc_hd__xnor2_2
XTAP_TAPCELL_ROW_90_1159 VGND VPWR sky130_fd_sc_hd__tapvpwrvgnd_1
XFILLER_97_235 VGND VGND VPWR VPWR sky130_fd_sc_hd__decap_3
XFILLER_24_3 VGND VGND VPWR VPWR sky130_fd_sc_hd__decap_3
XFILLER_38_302 VGND VGND VPWR VPWR sky130_fd_sc_hd__decap_3
XFILLER_78_460 VGND VGND VPWR VPWR sky130_fd_sc_hd__decap_3
Xload_slew378 _6093_/A VGND VGND VPWR VPWR _5983_/C sky130_fd_sc_hd__clkbuf_4
XFILLER_78_493 VGND VGND VPWR VPWR sky130_fd_sc_hd__decap_3
XFILLER_38_368 VGND VGND VPWR VPWR sky130_fd_sc_hd__fill_1
XFILLER_65_143 VGND VGND VPWR VPWR sky130_fd_sc_hd__fill_2
XFILLER_93_452 VGND VGND VPWR VPWR sky130_fd_sc_hd__decap_3
XFILLER_0_61 VGND VGND VPWR VPWR sky130_fd_sc_hd__decap_3
X_6971_ _6971_/A _6971_/B _6971_/C VGND VGND VPWR VPWR _6971_/X sky130_fd_sc_hd__and3_2
XFILLER_93_485 VGND VGND VPWR VPWR sky130_fd_sc_hd__decap_3
XFILLER_0_83 VGND VGND VPWR VPWR sky130_fd_sc_hd__fill_1
XFILLER_34_530 VGND VGND VPWR VPWR sky130_fd_sc_hd__fill_2
XFILLER_46_390 VGND VGND VPWR VPWR sky130_fd_sc_hd__fill_2
XFILLER_53_349 VGND VGND VPWR VPWR sky130_fd_sc_hd__decap_3
X_5922_ _4561_/Y _5920_/X _5892_/X _5889_/X VGND VGND VPWR VPWR _5922_/X sky130_fd_sc_hd__a211o_2
X_5853_ _5854_/B1 _5852_/Y _5840_/X _5844_/Y VGND VGND VPWR VPWR _5874_/B sky130_fd_sc_hd__o211ai_2
XTAP_TAPCELL_ROW_64_889 VGND VPWR sky130_fd_sc_hd__tapvpwrvgnd_1
XFILLER_34_596 VGND VGND VPWR VPWR sky130_fd_sc_hd__fill_2
XFILLER_61_393 VGND VGND VPWR VPWR sky130_fd_sc_hd__decap_3
X_5784_ _5787_/B _5784_/B VGND VGND VPWR VPWR _5788_/A sky130_fd_sc_hd__and2b_2
X_4804_ _4805_/A _4805_/B VGND VGND VPWR VPWR _4804_/Y sky130_fd_sc_hd__nand2b_2
XFILLER_21_257 VGND VGND VPWR VPWR sky130_fd_sc_hd__fill_2
X_4735_ _4735_/A _4735_/B _4735_/C VGND VGND VPWR VPWR _4736_/B sky130_fd_sc_hd__or3_4
X_4666_ _5306_/A _4748_/A _4694_/C _4944_/D VGND VGND VPWR VPWR _4669_/A sky130_fd_sc_hd__and4_2
X_6405_ _6016_/D _6014_/D _6405_/S VGND VGND VPWR VPWR _6405_/X sky130_fd_sc_hd__mux2_1
X_4597_ _4683_/A _4683_/B VGND VGND VPWR VPWR _4603_/A sky130_fd_sc_hd__nand2b_2
X_3617_ _3617_/A _3617_/B VGND VGND VPWR VPWR _3618_/B sky130_fd_sc_hd__nor2_2
X_6336_ _6336_/A _6353_/C _6384_/A VGND VGND VPWR VPWR _6625_/B sky130_fd_sc_hd__or3_2
X_3548_ _3797_/B VGND VGND VPWR VPWR _3555_/A sky130_fd_sc_hd__inv_2
XFILLER_88_224 VGND VGND VPWR VPWR sky130_fd_sc_hd__decap_3
XFILLER_0_128 VGND VGND VPWR VPWR sky130_fd_sc_hd__decap_3
X_6267_ _6083_/A _3495_/Y _6266_/X VGND VGND VPWR VPWR _6851_/C sky130_fd_sc_hd__o21a_2
XFILLER_88_279 VGND VGND VPWR VPWR sky130_fd_sc_hd__fill_2
X_6198_ _6074_/A _6936_/A _6197_/B _6071_/Y VGND VGND VPWR VPWR _6970_/B sky130_fd_sc_hd__a31o_2
X_5218_ _5200_/Y _5448_/A _5217_/X _5218_/C1 VGND VGND VPWR VPWR _5237_/A sky130_fd_sc_hd__a211o_4
XFILLER_84_430 VGND VGND VPWR VPWR sky130_fd_sc_hd__decap_3
X_5149_ _5162_/A _5452_/B VGND VGND VPWR VPWR _5163_/A sky130_fd_sc_hd__nand2_2
XFILLER_17_508 VGND VGND VPWR VPWR sky130_fd_sc_hd__decap_3
XFILLER_28_79 VGND VGND VPWR VPWR sky130_fd_sc_hd__decap_3
XFILLER_56_132 VGND VGND VPWR VPWR sky130_fd_sc_hd__fill_2
XFILLER_56_165 VGND VGND VPWR VPWR sky130_fd_sc_hd__fill_1
XFILLER_84_463 VGND VGND VPWR VPWR sky130_fd_sc_hd__decap_3
XFILLER_71_113 VGND VGND VPWR VPWR sky130_fd_sc_hd__decap_3
XTAP_TAPCELL_ROW_27_503 VGND VPWR sky130_fd_sc_hd__tapvpwrvgnd_1
XFILLER_25_552 VGND VGND VPWR VPWR sky130_fd_sc_hd__decap_3
XFILLER_40_500 VGND VGND VPWR VPWR sky130_fd_sc_hd__decap_3
XFILLER_44_67 VGND VGND VPWR VPWR sky130_fd_sc_hd__decap_3
XFILLER_40_544 VGND VGND VPWR VPWR sky130_fd_sc_hd__decap_3
XTAP_TAPCELL_ROW_35_580 VGND VPWR sky130_fd_sc_hd__tapvpwrvgnd_1
XFILLER_100_51 VGND VGND VPWR VPWR sky130_fd_sc_hd__decap_3
XFILLER_60_55 VGND VGND VPWR VPWR sky130_fd_sc_hd__decap_3
XFILLER_8_239 VGND VGND VPWR VPWR sky130_fd_sc_hd__decap_3
XFILLER_4_445 VGND VGND VPWR VPWR sky130_fd_sc_hd__decap_3
XFILLER_69_53 VGND VGND VPWR VPWR sky130_fd_sc_hd__decap_3
XFILLER_69_75 VGND VGND VPWR VPWR sky130_fd_sc_hd__decap_3
XFILLER_79_279 VGND VGND VPWR VPWR sky130_fd_sc_hd__fill_1
XFILLER_94_216 VGND VGND VPWR VPWR sky130_fd_sc_hd__decap_3
XFILLER_85_52 VGND VGND VPWR VPWR sky130_fd_sc_hd__decap_3
XTAP_TAPCELL_ROW_7_294 VGND VPWR sky130_fd_sc_hd__tapvpwrvgnd_1
XFILLER_94_249 VGND VGND VPWR VPWR sky130_fd_sc_hd__decap_3
XFILLER_75_485 VGND VGND VPWR VPWR sky130_fd_sc_hd__decap_3
XFILLER_85_96 VGND VGND VPWR VPWR sky130_fd_sc_hd__decap_3
XFILLER_35_349 VGND VGND VPWR VPWR sky130_fd_sc_hd__fill_2
XFILLER_90_444 VGND VGND VPWR VPWR sky130_fd_sc_hd__decap_3
XFILLER_16_585 VGND VGND VPWR VPWR sky130_fd_sc_hd__decap_3
XFILLER_31_511 VGND VGND VPWR VPWR sky130_fd_sc_hd__decap_3
XFILLER_62_168 VGND VGND VPWR VPWR sky130_fd_sc_hd__decap_3
XFILLER_90_477 VGND VGND VPWR VPWR sky130_fd_sc_hd__decap_3
XFILLER_43_393 VGND VGND VPWR VPWR sky130_fd_sc_hd__decap_3
XTAP_TAPCELL_ROW_61_859 VGND VPWR sky130_fd_sc_hd__tapvpwrvgnd_1
X_4520_ _4517_/X _4520_/B VGND VGND VPWR VPWR _4605_/B sky130_fd_sc_hd__and2b_2
X_4451_ _4451_/A _4451_/B VGND VGND VPWR VPWR _4567_/A sky130_fd_sc_hd__xnor2_2
X_6121_ _6219_/A _6121_/B VGND VGND VPWR VPWR _6122_/B sky130_fd_sc_hd__nor2_2
X_4382_ _4382_/A VGND VGND VPWR VPWR _4382_/Y sky130_fd_sc_hd__inv_2
XFILLER_100_505 VGND VGND VPWR VPWR sky130_fd_sc_hd__decap_3
XFILLER_85_205 VGND VGND VPWR VPWR sky130_fd_sc_hd__decap_3
X_6052_ _3888_/A _3888_/B _3885_/Y VGND VGND VPWR VPWR _6053_/B sky130_fd_sc_hd__o21ai_2
XPHY_EDGE_ROW_7_Right_7 VGND VGND VPWR VPWR sky130_fd_sc_hd__decap_3
XFILLER_98_577 VGND VGND VPWR VPWR sky130_fd_sc_hd__decap_3
XFILLER_100_549 VGND VGND VPWR VPWR sky130_fd_sc_hd__fill_2
XFILLER_85_249 VGND VGND VPWR VPWR sky130_fd_sc_hd__decap_3
Xload_slew175 fanout174/X VGND VGND VPWR VPWR _6939_/S sky130_fd_sc_hd__clkbuf_4
X_5003_ _4878_/Y _4879_/X _4830_/X _4834_/C VGND VGND VPWR VPWR _5003_/X sky130_fd_sc_hd__a211o_4
XTAP_TAPCELL_ROW_69_937 VGND VPWR sky130_fd_sc_hd__tapvpwrvgnd_1
XFILLER_66_452 VGND VGND VPWR VPWR sky130_fd_sc_hd__decap_3
XFILLER_93_260 VGND VGND VPWR VPWR sky130_fd_sc_hd__decap_3
XFILLER_26_349 VGND VGND VPWR VPWR sky130_fd_sc_hd__decap_3
XFILLER_53_146 VGND VGND VPWR VPWR sky130_fd_sc_hd__decap_3
XFILLER_81_455 VGND VGND VPWR VPWR sky130_fd_sc_hd__decap_3
XFILLER_93_293 VGND VGND VPWR VPWR sky130_fd_sc_hd__decap_3
X_6954_ _6074_/A _6936_/A _6957_/A _6203_/X VGND VGND VPWR VPWR _6955_/B sky130_fd_sc_hd__a31o_2
X_5905_ _4899_/A _4899_/B _4902_/A VGND VGND VPWR VPWR _5912_/A sky130_fd_sc_hd__a21oi_2
XFILLER_22_522 VGND VGND VPWR VPWR sky130_fd_sc_hd__decap_3
XFILLER_34_371 VGND VGND VPWR VPWR sky130_fd_sc_hd__decap_3
XFILLER_34_393 VGND VGND VPWR VPWR sky130_fd_sc_hd__decap_3
X_6885_ _6971_/B _6871_/Y _6884_/X VGND VGND VPWR VPWR _6885_/X sky130_fd_sc_hd__a21bo_2
XFILLER_14_37 VGND VGND VPWR VPWR sky130_fd_sc_hd__decap_3
XFILLER_14_59 VGND VGND VPWR VPWR sky130_fd_sc_hd__decap_3
XFILLER_22_555 VGND VGND VPWR VPWR sky130_fd_sc_hd__decap_3
X_5836_ _5839_/C1 _5833_/Y _5835_/Y _5252_/X VGND VGND VPWR VPWR _5840_/A sky130_fd_sc_hd__o211a_4
XTAP_TAPCELL_ROW_32_550 VGND VPWR sky130_fd_sc_hd__tapvpwrvgnd_1
X_5767_ _5767_/A _5767_/B VGND VGND VPWR VPWR _5783_/B sky130_fd_sc_hd__nand2_2
XFILLER_5_209 VGND VGND VPWR VPWR sky130_fd_sc_hd__decap_3
X_5698_ _5698_/A _6124_/A _5698_/C VGND VGND VPWR VPWR _5726_/C sky130_fd_sc_hd__or3_4
X_4718_ _5340_/A _5188_/C _5290_/C _5311_/A VGND VGND VPWR VPWR _4719_/C sky130_fd_sc_hd__a22oi_2
XFILLER_30_47 VGND VGND VPWR VPWR sky130_fd_sc_hd__decap_3
X_4649_ _5014_/A _4655_/B VGND VGND VPWR VPWR _4676_/A sky130_fd_sc_hd__and2_2
XFILLER_1_426 VGND VGND VPWR VPWR sky130_fd_sc_hd__decap_3
X_6319_ _6014_/D _6079_/B _6319_/S VGND VGND VPWR VPWR _6319_/X sky130_fd_sc_hd__mux2_1
XFILLER_49_408 VGND VGND VPWR VPWR sky130_fd_sc_hd__fill_1
XFILLER_89_588 VGND VGND VPWR VPWR sky130_fd_sc_hd__decap_3
XFILLER_76_227 VGND VGND VPWR VPWR sky130_fd_sc_hd__decap_3
XFILLER_29_132 VGND VGND VPWR VPWR sky130_fd_sc_hd__fill_2
XFILLER_29_154 VGND VGND VPWR VPWR sky130_fd_sc_hd__decap_3
XFILLER_69_290 VGND VGND VPWR VPWR sky130_fd_sc_hd__decap_3
XTAP_TAPCELL_ROW_4_264 VGND VPWR sky130_fd_sc_hd__tapvpwrvgnd_1
XFILLER_57_485 VGND VGND VPWR VPWR sky130_fd_sc_hd__decap_3
XFILLER_84_271 VGND VGND VPWR VPWR sky130_fd_sc_hd__decap_3
XFILLER_91_219 VGND VGND VPWR VPWR sky130_fd_sc_hd__decap_3
XFILLER_44_135 VGND VGND VPWR VPWR sky130_fd_sc_hd__decap_3
XFILLER_55_66 VGND VGND VPWR VPWR sky130_fd_sc_hd__decap_3
XFILLER_72_455 VGND VGND VPWR VPWR sky130_fd_sc_hd__decap_3
XFILLER_32_319 VGND VGND VPWR VPWR sky130_fd_sc_hd__fill_2
XFILLER_13_544 VGND VGND VPWR VPWR sky130_fd_sc_hd__decap_3
XFILLER_25_393 VGND VGND VPWR VPWR sky130_fd_sc_hd__decap_3
XFILLER_40_363 VGND VGND VPWR VPWR sky130_fd_sc_hd__fill_1
XFILLER_71_54 VGND VGND VPWR VPWR sky130_fd_sc_hd__fill_2
XTAP_TAPCELL_ROW_78_1032 VGND VPWR sky130_fd_sc_hd__tapvpwrvgnd_1
XFILLER_4_231 VGND VGND VPWR VPWR sky130_fd_sc_hd__decap_3
XFILLER_58_9 VGND VGND VPWR VPWR sky130_fd_sc_hd__decap_3
XFILLER_4_275 VGND VGND VPWR VPWR sky130_fd_sc_hd__decap_3
XFILLER_67_205 VGND VGND VPWR VPWR sky130_fd_sc_hd__fill_2
XFILLER_0_470 VGND VGND VPWR VPWR sky130_fd_sc_hd__decap_3
XFILLER_96_95 VGND VGND VPWR VPWR sky130_fd_sc_hd__fill_1
XFILLER_96_73 VGND VGND VPWR VPWR sky130_fd_sc_hd__fill_1
XFILLER_95_558 VGND VGND VPWR VPWR sky130_fd_sc_hd__fill_2
XFILLER_95_547 VGND VGND VPWR VPWR sky130_fd_sc_hd__decap_3
XFILLER_48_430 VGND VGND VPWR VPWR sky130_fd_sc_hd__decap_3
XFILLER_82_208 VGND VGND VPWR VPWR sky130_fd_sc_hd__decap_3
XTAP_TAPCELL_ROW_66_907 VGND VPWR sky130_fd_sc_hd__tapvpwrvgnd_1
XFILLER_35_113 VGND VGND VPWR VPWR sky130_fd_sc_hd__fill_2
XTAP_TAPCELL_ROW_89_1150 VGND VPWR sky130_fd_sc_hd__tapvpwrvgnd_1
XFILLER_35_135 VGND VGND VPWR VPWR sky130_fd_sc_hd__fill_2
XFILLER_75_293 VGND VGND VPWR VPWR sky130_fd_sc_hd__decap_3
XFILLER_90_230 VGND VGND VPWR VPWR sky130_fd_sc_hd__decap_3
XFILLER_23_308 VGND VGND VPWR VPWR sky130_fd_sc_hd__decap_3
X_3951_ _3951_/A _3951_/B VGND VGND VPWR VPWR _3953_/A sky130_fd_sc_hd__nor2_2
XFILLER_16_393 VGND VGND VPWR VPWR sky130_fd_sc_hd__decap_3
XTAP_TAPCELL_ROW_74_995 VGND VPWR sky130_fd_sc_hd__tapvpwrvgnd_1
XTAP_TAPCELL_ROW_46_697 VGND VPWR sky130_fd_sc_hd__tapvpwrvgnd_1
X_6670_ _6212_/X _6240_/X _6672_/B VGND VGND VPWR VPWR _6670_/Y sky130_fd_sc_hd__o21ai_2
X_3882_ _3882_/A _3882_/B VGND VGND VPWR VPWR _3884_/B sky130_fd_sc_hd__xnor2_2
X_5621_ _5657_/A _5621_/B VGND VGND VPWR VPWR _5638_/A sky130_fd_sc_hd__xnor2_2
X_5552_ _5552_/A _5555_/B VGND VGND VPWR VPWR _5553_/B sky130_fd_sc_hd__nand2_2
XFILLER_8_592 VGND VGND VPWR VPWR sky130_fd_sc_hd__fill_2
X_4503_ _4398_/A _4413_/Y _4516_/A _4412_/A VGND VGND VPWR VPWR _4503_/Y sky130_fd_sc_hd__o211ai_2
X_5483_ _5483_/A _5483_/B VGND VGND VPWR VPWR _5555_/A sky130_fd_sc_hd__xor2_2
X_4434_ _4434_/A _4434_/B VGND VGND VPWR VPWR _4436_/C sky130_fd_sc_hd__nor2_2
X_4365_ _4364_/A _4481_/A VGND VGND VPWR VPWR _4367_/B sky130_fd_sc_hd__nand2b_2
XFILLER_86_503 VGND VGND VPWR VPWR sky130_fd_sc_hd__fill_1
Xfanout527 _4482_/B VGND VGND VPWR VPWR _3640_/A1 sky130_fd_sc_hd__clkdlybuf4s25_1
Xfanout538 _4694_/A VGND VGND VPWR VPWR _6606_/A3 sky130_fd_sc_hd__buf_4
X_6104_ _6104_/A _6104_/B VGND VGND VPWR VPWR _6104_/X sky130_fd_sc_hd__or2_2
XFILLER_100_302 VGND VGND VPWR VPWR sky130_fd_sc_hd__decap_3
XFILLER_100_324 VGND VGND VPWR VPWR sky130_fd_sc_hd__decap_3
XFILLER_58_227 VGND VGND VPWR VPWR sky130_fd_sc_hd__decap_3
XFILLER_86_558 VGND VGND VPWR VPWR sky130_fd_sc_hd__decap_3
Xfanout549 _5765_/A VGND VGND VPWR VPWR _5529_/A sky130_fd_sc_hd__dlymetal6s2s_1
X_6035_ _6035_/A _6035_/B VGND VGND VPWR VPWR _6036_/B sky130_fd_sc_hd__xnor2_2
X_4296_ _6085_/B _4420_/C _4538_/D _4822_/A VGND VGND VPWR VPWR _4297_/B sky130_fd_sc_hd__a22o_2
XFILLER_100_357 VGND VGND VPWR VPWR sky130_fd_sc_hd__decap_3
XFILLER_39_452 VGND VGND VPWR VPWR sky130_fd_sc_hd__decap_3
XTAP_TAPCELL_ROW_1_223 VGND VPWR sky130_fd_sc_hd__tapvpwrvgnd_1
XFILLER_26_135 VGND VGND VPWR VPWR sky130_fd_sc_hd__decap_3
XFILLER_54_433 VGND VGND VPWR VPWR sky130_fd_sc_hd__decap_3
XFILLER_26_168 VGND VGND VPWR VPWR sky130_fd_sc_hd__fill_2
XFILLER_81_296 VGND VGND VPWR VPWR sky130_fd_sc_hd__decap_3
X_6937_ _6348_/C _6191_/X _6194_/X _6936_/Y VGND VGND VPWR VPWR _6937_/X sky130_fd_sc_hd__a31o_2
XFILLER_22_352 VGND VGND VPWR VPWR sky130_fd_sc_hd__decap_3
X_6868_ _6365_/Y _6862_/Y _6867_/Y _6363_/Y _6866_/X VGND VGND VPWR VPWR _6868_/X
+ sky130_fd_sc_hd__a221o_2
XFILLER_22_385 VGND VGND VPWR VPWR sky130_fd_sc_hd__decap_3
X_5819_ _5564_/Y _5566_/Y _5518_/Y _5522_/X VGND VGND VPWR VPWR _5820_/B sky130_fd_sc_hd__o211a_2
XFILLER_10_536 VGND VGND VPWR VPWR sky130_fd_sc_hd__fill_1
XFILLER_6_507 VGND VGND VPWR VPWR sky130_fd_sc_hd__fill_2
XFILLER_6_518 VGND VGND VPWR VPWR sky130_fd_sc_hd__decap_3
X_6799_ _6363_/A _6765_/B _6505_/X _6798_/Y VGND VGND VPWR VPWR _6803_/A sky130_fd_sc_hd__a31o_2
XFILLER_1_201 VGND VGND VPWR VPWR sky130_fd_sc_hd__decap_3
XTAP_TAPCELL_ROW_9_312 VGND VPWR sky130_fd_sc_hd__tapvpwrvgnd_1
XFILLER_1_234 VGND VGND VPWR VPWR sky130_fd_sc_hd__decap_3
XFILLER_89_363 VGND VGND VPWR VPWR sky130_fd_sc_hd__decap_3
XFILLER_2_29 VGND VGND VPWR VPWR sky130_fd_sc_hd__fill_2
XFILLER_66_10 VGND VGND VPWR VPWR sky130_fd_sc_hd__decap_3
XFILLER_49_249 VGND VGND VPWR VPWR sky130_fd_sc_hd__decap_3
XFILLER_57_271 VGND VGND VPWR VPWR sky130_fd_sc_hd__decap_3
XFILLER_66_76 VGND VGND VPWR VPWR sky130_fd_sc_hd__decap_3
XFILLER_72_230 VGND VGND VPWR VPWR sky130_fd_sc_hd__decap_3
XFILLER_85_591 VGND VGND VPWR VPWR sky130_fd_sc_hd__decap_3
XFILLER_72_241 VGND VGND VPWR VPWR sky130_fd_sc_hd__decap_3
XFILLER_60_436 VGND VGND VPWR VPWR sky130_fd_sc_hd__decap_3
XFILLER_72_274 VGND VGND VPWR VPWR sky130_fd_sc_hd__fill_2
XFILLER_72_285 VGND VGND VPWR VPWR sky130_fd_sc_hd__decap_3
XTAP_TAPCELL_ROW_71_965 VGND VPWR sky130_fd_sc_hd__tapvpwrvgnd_1
XTAP_TAPCELL_ROW_43_667 VGND VPWR sky130_fd_sc_hd__tapvpwrvgnd_1
XFILLER_40_171 VGND VGND VPWR VPWR sky130_fd_sc_hd__decap_3
XFILLER_9_323 VGND VGND VPWR VPWR sky130_fd_sc_hd__decap_3
XFILLER_13_396 VGND VGND VPWR VPWR sky130_fd_sc_hd__decap_3
XFILLER_9_356 VGND VGND VPWR VPWR sky130_fd_sc_hd__decap_3
XFILLER_9_389 VGND VGND VPWR VPWR sky130_fd_sc_hd__decap_3
XFILLER_31_90 VGND VGND VPWR VPWR sky130_fd_sc_hd__fill_1
XFILLER_56_6 VGND VGND VPWR VPWR sky130_fd_sc_hd__decap_3
XFILLER_68_514 VGND VGND VPWR VPWR sky130_fd_sc_hd__decap_3
X_4150_ _4150_/A _4262_/A VGND VGND VPWR VPWR _4152_/B sky130_fd_sc_hd__nand2_2
Xoutput90 _6995_/B VGND VGND VPWR VPWR result[27] sky130_fd_sc_hd__clkbuf_4
XFILLER_95_311 VGND VGND VPWR VPWR sky130_fd_sc_hd__fill_2
X_4081_ _4081_/A _4081_/B VGND VGND VPWR VPWR _4083_/B sky130_fd_sc_hd__xnor2_2
XFILLER_55_219 VGND VGND VPWR VPWR sky130_fd_sc_hd__decap_3
XFILLER_83_528 VGND VGND VPWR VPWR sky130_fd_sc_hd__decap_3
XFILLER_95_399 VGND VGND VPWR VPWR sky130_fd_sc_hd__decap_3
XFILLER_95_388 VGND VGND VPWR VPWR sky130_fd_sc_hd__decap_3
XFILLER_36_433 VGND VGND VPWR VPWR sky130_fd_sc_hd__decap_3
XFILLER_36_477 VGND VGND VPWR VPWR sky130_fd_sc_hd__fill_1
XFILLER_63_252 VGND VGND VPWR VPWR sky130_fd_sc_hd__decap_3
XFILLER_91_561 VGND VGND VPWR VPWR sky130_fd_sc_hd__fill_1
XFILLER_63_296 VGND VGND VPWR VPWR sky130_fd_sc_hd__decap_3
X_4983_ _4983_/A _4983_/B VGND VGND VPWR VPWR _4986_/B sky130_fd_sc_hd__xnor2_2
X_6722_ _6722_/A _6722_/B VGND VGND VPWR VPWR _6724_/A sky130_fd_sc_hd__nand2_2
X_3934_ _6024_/B _3933_/B _6019_/B _3933_/D VGND VGND VPWR VPWR _3935_/B sky130_fd_sc_hd__a22oi_2
X_6653_ _6652_/A _6655_/B _6853_/A VGND VGND VPWR VPWR _6653_/X sky130_fd_sc_hd__a21o_2
X_3865_ _3704_/A _3704_/B _3705_/Y VGND VGND VPWR VPWR _3866_/B sky130_fd_sc_hd__a21oi_2
XFILLER_31_182 VGND VGND VPWR VPWR sky130_fd_sc_hd__fill_1
X_5604_ _5604_/A _5618_/B VGND VGND VPWR VPWR _5606_/B sky130_fd_sc_hd__nor2_2
X_6584_ _6584_/A _6584_/B VGND VGND VPWR VPWR _6584_/Y sky130_fd_sc_hd__xnor2_2
X_3796_ _3796_/A _3796_/B VGND VGND VPWR VPWR _3799_/A sky130_fd_sc_hd__xnor2_2
XTAP_TAPCELL_ROW_98_1249 VGND VPWR sky130_fd_sc_hd__tapvpwrvgnd_1
X_5535_ _5537_/A _5537_/B VGND VGND VPWR VPWR _5535_/X sky130_fd_sc_hd__and2b_2
X_5466_ _5437_/B _5466_/B _5466_/C VGND VGND VPWR VPWR _5466_/Y sky130_fd_sc_hd__nand3b_4
X_4417_ _4302_/A _4302_/C _4302_/B VGND VGND VPWR VPWR _4418_/B sky130_fd_sc_hd__a21oi_2
Xfanout313 input51/X VGND VGND VPWR VPWR _6008_/A sky130_fd_sc_hd__clkdlybuf4s25_1
X_5397_ _5409_/A _5409_/B VGND VGND VPWR VPWR _5410_/B sky130_fd_sc_hd__nor2_2
XFILLER_59_514 VGND VGND VPWR VPWR sky130_fd_sc_hd__decap_3
XFILLER_59_547 VGND VGND VPWR VPWR sky130_fd_sc_hd__decap_3
Xfanout324 _6276_/A VGND VGND VPWR VPWR _3961_/D sky130_fd_sc_hd__clkbuf_2
Xfanout335 _5981_/C VGND VGND VPWR VPWR _4457_/C sky130_fd_sc_hd__clkdlybuf4s25_1
X_4348_ _4348_/A _4348_/B _4348_/C VGND VGND VPWR VPWR _4378_/A sky130_fd_sc_hd__and3_2
XFILLER_100_121 VGND VGND VPWR VPWR sky130_fd_sc_hd__fill_2
XFILLER_86_344 VGND VGND VPWR VPWR sky130_fd_sc_hd__decap_3
Xfanout368 _4628_/C VGND VGND VPWR VPWR _4593_/C sky130_fd_sc_hd__dlymetal6s4s_1
Xfanout379 _4646_/D VGND VGND VPWR VPWR _4592_/B sky130_fd_sc_hd__clkdlybuf4s25_1
X_4279_ _4279_/A _4279_/B _4279_/C VGND VGND VPWR VPWR _4285_/A sky130_fd_sc_hd__nand3_2
XFILLER_100_154 VGND VGND VPWR VPWR sky130_fd_sc_hd__decap_3
XFILLER_27_411 VGND VGND VPWR VPWR sky130_fd_sc_hd__decap_3
XFILLER_39_260 VGND VGND VPWR VPWR sky130_fd_sc_hd__decap_3
XFILLER_86_377 VGND VGND VPWR VPWR sky130_fd_sc_hd__decap_3
X_6018_ _6019_/A _6019_/B _6019_/C _6019_/D VGND VGND VPWR VPWR _6021_/C sky130_fd_sc_hd__a22oi_2
XFILLER_27_444 VGND VGND VPWR VPWR sky130_fd_sc_hd__decap_3
XFILLER_36_79 VGND VGND VPWR VPWR sky130_fd_sc_hd__decap_3
XFILLER_54_241 VGND VGND VPWR VPWR sky130_fd_sc_hd__decap_3
XFILLER_54_263 VGND VGND VPWR VPWR sky130_fd_sc_hd__fill_1
XFILLER_82_561 VGND VGND VPWR VPWR sky130_fd_sc_hd__fill_2
XFILLER_42_414 VGND VGND VPWR VPWR sky130_fd_sc_hd__decap_3
XFILLER_54_274 VGND VGND VPWR VPWR sky130_fd_sc_hd__fill_1
XFILLER_10_300 VGND VGND VPWR VPWR sky130_fd_sc_hd__decap_3
XFILLER_22_193 VGND VGND VPWR VPWR sky130_fd_sc_hd__decap_3
XFILLER_50_480 VGND VGND VPWR VPWR sky130_fd_sc_hd__decap_3
XTAP_TAPCELL_ROW_40_637 VGND VPWR sky130_fd_sc_hd__tapvpwrvgnd_1
XTAP_TAPCELL_ROW_12_339 VGND VPWR sky130_fd_sc_hd__tapvpwrvgnd_1
XFILLER_10_388 VGND VGND VPWR VPWR sky130_fd_sc_hd__decap_3
XFILLER_6_348 VGND VGND VPWR VPWR sky130_fd_sc_hd__decap_3
XTAP_TAPCELL_ROW_75_1002 VGND VPWR sky130_fd_sc_hd__tapvpwrvgnd_1
XFILLER_77_311 VGND VGND VPWR VPWR sky130_fd_sc_hd__decap_3
XTAP_TAPCELL_ROW_48_726 VGND VPWR sky130_fd_sc_hd__tapvpwrvgnd_1
XFILLER_18_444 VGND VGND VPWR VPWR sky130_fd_sc_hd__decap_3
XFILLER_92_347 VGND VGND VPWR VPWR sky130_fd_sc_hd__decap_3
XTAP_TAPCELL_ROW_86_1120 VGND VPWR sky130_fd_sc_hd__tapvpwrvgnd_1
XFILLER_18_477 VGND VGND VPWR VPWR sky130_fd_sc_hd__decap_3
XFILLER_73_561 VGND VGND VPWR VPWR sky130_fd_sc_hd__decap_3
XFILLER_33_425 VGND VGND VPWR VPWR sky130_fd_sc_hd__fill_2
XFILLER_73_594 VGND VGND VPWR VPWR sky130_fd_sc_hd__decap_3
XFILLER_93_96 VGND VGND VPWR VPWR sky130_fd_sc_hd__decap_3
XFILLER_93_85 VGND VGND VPWR VPWR sky130_fd_sc_hd__fill_1
XFILLER_33_458 VGND VGND VPWR VPWR sky130_fd_sc_hd__decap_3
XFILLER_13_193 VGND VGND VPWR VPWR sky130_fd_sc_hd__decap_3
X_3650_ _3651_/A _3650_/B _3650_/C VGND VGND VPWR VPWR _4132_/A sky130_fd_sc_hd__nand3_2
X_3581_ _3581_/A _3581_/B VGND VGND VPWR VPWR _3582_/C sky130_fd_sc_hd__xnor2_2
X_5320_ _5337_/A VGND VGND VPWR VPWR _5320_/Y sky130_fd_sc_hd__inv_2
X_5251_ _5250_/A _5250_/B _5831_/A VGND VGND VPWR VPWR _5251_/X sky130_fd_sc_hd__o21ba_2
X_4202_ _4203_/B _4203_/A VGND VGND VPWR VPWR _4202_/X sky130_fd_sc_hd__and2b_2
XFILLER_68_322 VGND VGND VPWR VPWR sky130_fd_sc_hd__decap_3
X_5182_ _5182_/A1 _5101_/X _5180_/A _5184_/A VGND VGND VPWR VPWR _5182_/Y sky130_fd_sc_hd__o211ai_2
X_4133_ _4132_/A _4132_/B _4132_/C VGND VGND VPWR VPWR _4135_/B sky130_fd_sc_hd__a21oi_2
XPHY_EDGE_ROW_79_Left_180 VGND VGND VPWR VPWR sky130_fd_sc_hd__decap_3
XFILLER_95_130 VGND VGND VPWR VPWR sky130_fd_sc_hd__fill_1
XFILLER_56_517 VGND VGND VPWR VPWR sky130_fd_sc_hd__fill_2
XFILLER_68_377 VGND VGND VPWR VPWR sky130_fd_sc_hd__decap_3
X_4064_ _4046_/A _4046_/C _4046_/B VGND VGND VPWR VPWR _4065_/B sky130_fd_sc_hd__a21oi_2
XFILLER_95_174 VGND VGND VPWR VPWR sky130_fd_sc_hd__fill_2
XFILLER_83_325 VGND VGND VPWR VPWR sky130_fd_sc_hd__decap_3
XFILLER_64_561 VGND VGND VPWR VPWR sky130_fd_sc_hd__fill_1
XFILLER_24_414 VGND VGND VPWR VPWR sky130_fd_sc_hd__decap_3
XFILLER_36_263 VGND VGND VPWR VPWR sky130_fd_sc_hd__decap_3
XFILLER_51_211 VGND VGND VPWR VPWR sky130_fd_sc_hd__decap_3
XFILLER_91_391 VGND VGND VPWR VPWR sky130_fd_sc_hd__fill_1
X_6705_ _5568_/Y _5820_/B _6705_/B1 VGND VGND VPWR VPWR _6705_/Y sky130_fd_sc_hd__o21ai_2
X_4966_ _4966_/A1 _5134_/B _5382_/D _5054_/A VGND VGND VPWR VPWR _4967_/C sky130_fd_sc_hd__a22oi_2
X_4897_ _4897_/A _4897_/B VGND VGND VPWR VPWR _4899_/A sky130_fd_sc_hd__nor2_2
X_3917_ _3798_/X _3807_/A _3915_/A _3916_/Y VGND VGND VPWR VPWR _4036_/A sky130_fd_sc_hd__o211a_2
X_6636_ _6213_/B _6140_/C _6635_/A VGND VGND VPWR VPWR _6636_/Y sky130_fd_sc_hd__o21ai_2
X_3848_ _6879_/B2 _5947_/A _3698_/B _3696_/X VGND VGND VPWR VPWR _3859_/A sky130_fd_sc_hd__a31o_2
X_6567_ _6589_/B _6567_/B VGND VGND VPWR VPWR _6567_/X sky130_fd_sc_hd__or2_2
X_3779_ _3779_/A _3779_/B VGND VGND VPWR VPWR _3781_/B sky130_fd_sc_hd__and2_2
X_5518_ _5372_/X _5374_/X _5516_/X _5517_/Y VGND VGND VPWR VPWR _5518_/Y sky130_fd_sc_hd__o211ai_2
XFILLER_3_329 VGND VGND VPWR VPWR sky130_fd_sc_hd__decap_3
X_6498_ _6498_/A _6498_/B _6498_/C VGND VGND VPWR VPWR _6498_/X sky130_fd_sc_hd__and3_2
X_5449_ _5451_/A _5451_/B _5451_/C VGND VGND VPWR VPWR _5458_/A sky130_fd_sc_hd__a21o_2
XFILLER_59_322 VGND VGND VPWR VPWR sky130_fd_sc_hd__decap_3
XFILLER_86_141 VGND VGND VPWR VPWR sky130_fd_sc_hd__fill_1
Xfanout143 _6550_/B VGND VGND VPWR VPWR _6331_/B sky130_fd_sc_hd__clkdlybuf4s25_1
Xfanout165 _6760_/S VGND VGND VPWR VPWR _6569_/B sky130_fd_sc_hd__clkbuf_4
XFILLER_47_517 VGND VGND VPWR VPWR sky130_fd_sc_hd__decap_3
XFILLER_59_388 VGND VGND VPWR VPWR sky130_fd_sc_hd__decap_3
XFILLER_55_561 VGND VGND VPWR VPWR sky130_fd_sc_hd__decap_3
XFILLER_15_403 VGND VGND VPWR VPWR sky130_fd_sc_hd__decap_3
XFILLER_15_425 VGND VGND VPWR VPWR sky130_fd_sc_hd__fill_2
XFILLER_82_380 VGND VGND VPWR VPWR sky130_fd_sc_hd__decap_3
XFILLER_42_233 VGND VGND VPWR VPWR sky130_fd_sc_hd__decap_3
XFILLER_70_553 VGND VGND VPWR VPWR sky130_fd_sc_hd__decap_3
XFILLER_42_277 VGND VGND VPWR VPWR sky130_fd_sc_hd__decap_3
XFILLER_70_586 VGND VGND VPWR VPWR sky130_fd_sc_hd__fill_2
XTAP_TAPCELL_ROW_53_773 VGND VPWR sky130_fd_sc_hd__tapvpwrvgnd_1
XTAP_TAPCELL_ROW_25_475 VGND VPWR sky130_fd_sc_hd__tapvpwrvgnd_1
XFILLER_30_439 VGND VGND VPWR VPWR sky130_fd_sc_hd__decap_3
XFILLER_8_17 VGND VGND VPWR VPWR sky130_fd_sc_hd__decap_3
XTAP_TAPCELL_ROW_81_1072 VGND VPWR sky130_fd_sc_hd__tapvpwrvgnd_1
XFILLER_10_141 VGND VGND VPWR VPWR sky130_fd_sc_hd__decap_3
XFILLER_6_189 VGND VGND VPWR VPWR sky130_fd_sc_hd__decap_3
Xload_slew505 _3578_/A VGND VGND VPWR VPWR _4483_/A sky130_fd_sc_hd__buf_4
XFILLER_69_119 VGND VGND VPWR VPWR sky130_fd_sc_hd__decap_3
XFILLER_88_85 VGND VGND VPWR VPWR sky130_fd_sc_hd__decap_3
Xload_slew516 _3647_/A VGND VGND VPWR VPWR _4662_/B sky130_fd_sc_hd__clkbuf_4
XFILLER_97_428 VGND VGND VPWR VPWR sky130_fd_sc_hd__fill_1
XFILLER_77_130 VGND VGND VPWR VPWR sky130_fd_sc_hd__decap_3
XFILLER_65_303 VGND VGND VPWR VPWR sky130_fd_sc_hd__decap_3
XFILLER_38_539 VGND VGND VPWR VPWR sky130_fd_sc_hd__decap_3
XFILLER_92_133 VGND VGND VPWR VPWR sky130_fd_sc_hd__decap_3
XFILLER_65_358 VGND VGND VPWR VPWR sky130_fd_sc_hd__fill_1
XFILLER_92_144 VGND VGND VPWR VPWR sky130_fd_sc_hd__decap_3
XFILLER_18_285 VGND VGND VPWR VPWR sky130_fd_sc_hd__decap_3
XFILLER_33_211 VGND VGND VPWR VPWR sky130_fd_sc_hd__decap_3
XFILLER_80_339 VGND VGND VPWR VPWR sky130_fd_sc_hd__decap_3
XFILLER_92_188 VGND VGND VPWR VPWR sky130_fd_sc_hd__decap_3
XFILLER_73_391 VGND VGND VPWR VPWR sky130_fd_sc_hd__fill_1
X_4820_ _4775_/X _4777_/Y _4818_/X _4819_/Y VGND VGND VPWR VPWR _4828_/A sky130_fd_sc_hd__o211ai_2
XFILLER_33_255 VGND VGND VPWR VPWR sky130_fd_sc_hd__decap_3
XFILLER_33_266 VGND VGND VPWR VPWR sky130_fd_sc_hd__decap_3
XFILLER_61_564 VGND VGND VPWR VPWR sky130_fd_sc_hd__decap_3
X_4751_ _4748_/X _4751_/B VGND VGND VPWR VPWR _4953_/B sky130_fd_sc_hd__and2b_2
X_4682_ _4870_/A _4681_/A _4604_/Y VGND VGND VPWR VPWR _4714_/C sky130_fd_sc_hd__o21bai_2
X_3702_ _3703_/A _3703_/B VGND VGND VPWR VPWR _3702_/Y sky130_fd_sc_hd__nand2b_2
X_6421_ _6420_/Y _6421_/B VGND VGND VPWR VPWR _6770_/B sky130_fd_sc_hd__and2b_2
X_3633_ _4054_/A _3633_/B _3633_/C VGND VGND VPWR VPWR _4054_/B sky130_fd_sc_hd__nor3_2
XTAP_TAPCELL_ROW_95_1219 VGND VPWR sky130_fd_sc_hd__tapvpwrvgnd_1
X_6352_ _6283_/Y _6348_/Y _6350_/X _6351_/X VGND VGND VPWR VPWR _6353_/D sky130_fd_sc_hd__o22a_2
X_3564_ _3565_/A _3565_/B _3565_/C VGND VGND VPWR VPWR _4048_/B sky130_fd_sc_hd__and3_2
X_6283_ _6284_/B VGND VGND VPWR VPWR _6283_/Y sky130_fd_sc_hd__inv_2
X_5303_ _5303_/A _5303_/B VGND VGND VPWR VPWR _5304_/C sky130_fd_sc_hd__xnor2_2
X_3495_ _4822_/A VGND VGND VPWR VPWR _3495_/Y sky130_fd_sc_hd__inv_2
XFILLER_88_439 VGND VGND VPWR VPWR sky130_fd_sc_hd__decap_3
X_5234_ _5234_/A _5234_/B VGND VGND VPWR VPWR _5236_/B sky130_fd_sc_hd__xor2_2
XFILLER_68_130 VGND VGND VPWR VPWR sky130_fd_sc_hd__decap_3
X_5165_ _5165_/A1 _5081_/B _5081_/C VGND VGND VPWR VPWR _5166_/C sky130_fd_sc_hd__a21oi_2
XFILLER_29_528 VGND VGND VPWR VPWR sky130_fd_sc_hd__decap_3
XFILLER_68_141 VGND VGND VPWR VPWR sky130_fd_sc_hd__decap_3
X_4116_ _4482_/A _4617_/A _4593_/C _4593_/D VGND VGND VPWR VPWR _4116_/X sky130_fd_sc_hd__and4_2
XFILLER_96_472 VGND VGND VPWR VPWR sky130_fd_sc_hd__decap_3
XFILLER_68_185 VGND VGND VPWR VPWR sky130_fd_sc_hd__decap_3
X_5096_ _5002_/Y _5094_/X _5093_/Y _5091_/Y VGND VGND VPWR VPWR _5096_/X sky130_fd_sc_hd__o211a_2
XFILLER_17_37 VGND VGND VPWR VPWR sky130_fd_sc_hd__decap_3
XFILLER_37_561 VGND VGND VPWR VPWR sky130_fd_sc_hd__decap_3
XFILLER_44_509 VGND VGND VPWR VPWR sky130_fd_sc_hd__decap_3
XFILLER_83_155 VGND VGND VPWR VPWR sky130_fd_sc_hd__decap_3
X_4047_ _4049_/A _4065_/A VGND VGND VPWR VPWR _4055_/B sky130_fd_sc_hd__nand2_2
XFILLER_37_594 VGND VGND VPWR VPWR sky130_fd_sc_hd__decap_3
XFILLER_71_317 VGND VGND VPWR VPWR sky130_fd_sc_hd__decap_3
XFILLER_52_542 VGND VGND VPWR VPWR sky130_fd_sc_hd__decap_3
XFILLER_24_277 VGND VGND VPWR VPWR sky130_fd_sc_hd__decap_3
XFILLER_52_564 VGND VGND VPWR VPWR sky130_fd_sc_hd__fill_2
X_5998_ _5998_/A _5998_/B VGND VGND VPWR VPWR _6000_/A sky130_fd_sc_hd__xnor2_2
XFILLER_12_439 VGND VGND VPWR VPWR sky130_fd_sc_hd__decap_3
XFILLER_24_299 VGND VGND VPWR VPWR sky130_fd_sc_hd__decap_3
X_4949_ _4949_/A1 _4719_/C _4719_/B VGND VGND VPWR VPWR _4950_/C sky130_fd_sc_hd__o21ai_2
XTAP_TAPCELL_ROW_50_743 VGND VPWR sky130_fd_sc_hd__tapvpwrvgnd_1
XFILLER_20_450 VGND VGND VPWR VPWR sky130_fd_sc_hd__decap_3
XTAP_TAPCELL_ROW_22_445 VGND VPWR sky130_fd_sc_hd__tapvpwrvgnd_1
X_6619_ _6138_/Y _6383_/D _6618_/Y VGND VGND VPWR VPWR _6632_/C sky130_fd_sc_hd__a21oi_2
XFILLER_3_104 VGND VGND VPWR VPWR sky130_fd_sc_hd__decap_3
XFILLER_79_417 VGND VGND VPWR VPWR sky130_fd_sc_hd__decap_3
XFILLER_59_130 VGND VGND VPWR VPWR sky130_fd_sc_hd__fill_2
XFILLER_58_66 VGND VGND VPWR VPWR sky130_fd_sc_hd__decap_3
XFILLER_58_88 VGND VGND VPWR VPWR sky130_fd_sc_hd__decap_3
XFILLER_87_472 VGND VGND VPWR VPWR sky130_fd_sc_hd__decap_3
XFILLER_74_111 VGND VGND VPWR VPWR sky130_fd_sc_hd__decap_3
XFILLER_87_483 VGND VGND VPWR VPWR sky130_fd_sc_hd__fill_2
XTAP_TAPCELL_ROW_58_821 VGND VPWR sky130_fd_sc_hd__tapvpwrvgnd_1
XFILLER_74_144 VGND VGND VPWR VPWR sky130_fd_sc_hd__decap_3
XFILLER_15_200 VGND VGND VPWR VPWR sky130_fd_sc_hd__decap_3
XFILLER_62_339 VGND VGND VPWR VPWR sky130_fd_sc_hd__decap_3
XFILLER_74_177 VGND VGND VPWR VPWR sky130_fd_sc_hd__decap_3
XFILLER_30_203 VGND VGND VPWR VPWR sky130_fd_sc_hd__fill_2
XFILLER_43_564 VGND VGND VPWR VPWR sky130_fd_sc_hd__decap_3
XFILLER_90_20 VGND VGND VPWR VPWR sky130_fd_sc_hd__fill_2
XFILLER_15_288 VGND VGND VPWR VPWR sky130_fd_sc_hd__decap_3
XFILLER_70_394 VGND VGND VPWR VPWR sky130_fd_sc_hd__decap_3
XFILLER_23_91 VGND VGND VPWR VPWR sky130_fd_sc_hd__fill_1
XFILLER_7_410 VGND VGND VPWR VPWR sky130_fd_sc_hd__decap_3
XFILLER_11_494 VGND VGND VPWR VPWR sky130_fd_sc_hd__decap_3
Xmax_cap107 _5098_/B VGND VGND VPWR VPWR _5182_/A1 sky130_fd_sc_hd__clkbuf_1
XFILLER_7_498 VGND VGND VPWR VPWR sky130_fd_sc_hd__decap_3
Xload_slew302 _6315_/A VGND VGND VPWR VPWR _4785_/B sky130_fd_sc_hd__buf_4
Xload_slew346 _5536_/B VGND VGND VPWR VPWR _6434_/S sky130_fd_sc_hd__clkbuf_2
XFILLER_17_3 VGND VGND VPWR VPWR sky130_fd_sc_hd__decap_3
XFILLER_65_122 VGND VGND VPWR VPWR sky130_fd_sc_hd__decap_3
XFILLER_93_420 VGND VGND VPWR VPWR sky130_fd_sc_hd__decap_3
XFILLER_26_509 VGND VGND VPWR VPWR sky130_fd_sc_hd__decap_3
XFILLER_65_155 VGND VGND VPWR VPWR sky130_fd_sc_hd__decap_3
X_6970_ _6970_/A _6970_/B VGND VGND VPWR VPWR _6971_/C sky130_fd_sc_hd__nand2_2
XFILLER_93_464 VGND VGND VPWR VPWR sky130_fd_sc_hd__decap_3
XFILLER_19_572 VGND VGND VPWR VPWR sky130_fd_sc_hd__decap_3
X_5921_ _5889_/X _5892_/X _5920_/X _4561_/Y VGND VGND VPWR VPWR _5921_/Y sky130_fd_sc_hd__o211ai_2
XFILLER_0_73 VGND VGND VPWR VPWR sky130_fd_sc_hd__decap_3
XFILLER_34_542 VGND VGND VPWR VPWR sky130_fd_sc_hd__decap_3
XFILLER_80_125 VGND VGND VPWR VPWR sky130_fd_sc_hd__decap_3
X_5852_ _5233_/Y _5235_/Y _5850_/X _5851_/Y VGND VGND VPWR VPWR _5852_/Y sky130_fd_sc_hd__a211oi_4
XFILLER_21_214 VGND VGND VPWR VPWR sky130_fd_sc_hd__decap_3
XFILLER_21_225 VGND VGND VPWR VPWR sky130_fd_sc_hd__decap_3
X_5783_ _5783_/A _5783_/B VGND VGND VPWR VPWR _5784_/B sky130_fd_sc_hd__xor2_2
X_4803_ _4803_/A _4803_/B VGND VGND VPWR VPWR _4805_/B sky130_fd_sc_hd__xor2_2
X_4734_ _5502_/A _4734_/A2 _4755_/D _5151_/B VGND VGND VPWR VPWR _4735_/C sky130_fd_sc_hd__a22oi_2
X_4665_ _4665_/A _4665_/B VGND VGND VPWR VPWR _4675_/A sky130_fd_sc_hd__xnor2_2
X_6404_ _6266_/B _4989_/B _4827_/A VGND VGND VPWR VPWR _6404_/Y sky130_fd_sc_hd__o21ai_2
X_4596_ _4596_/A _4596_/B VGND VGND VPWR VPWR _4683_/B sky130_fd_sc_hd__xnor2_2
X_3616_ _6019_/B _3941_/B _3834_/D _3657_/C VGND VGND VPWR VPWR _3617_/B sky130_fd_sc_hd__a22oi_2
X_6335_ _6336_/A _6353_/C _6384_/A VGND VGND VPWR VPWR _6367_/A sky130_fd_sc_hd__nor3_2
X_3547_ _3797_/A _3547_/B _5995_/B _5976_/A VGND VGND VPWR VPWR _3797_/B sky130_fd_sc_hd__and4b_2
XFILLER_88_203 VGND VGND VPWR VPWR sky130_fd_sc_hd__decap_3
X_6266_ _6266_/A _6266_/B _6266_/C VGND VGND VPWR VPWR _6266_/X sky130_fd_sc_hd__or3_2
XFILLER_76_409 VGND VGND VPWR VPWR sky130_fd_sc_hd__decap_3
X_6197_ _6071_/Y _6197_/B VGND VGND VPWR VPWR _6957_/A sky130_fd_sc_hd__nand2b_2
X_5217_ _5126_/X _5217_/A2 _5200_/A _5142_/A VGND VGND VPWR VPWR _5217_/X sky130_fd_sc_hd__o211a_4
XFILLER_29_314 VGND VGND VPWR VPWR sky130_fd_sc_hd__decap_3
X_5148_ _5061_/X _5145_/Y _5220_/A1 _5148_/C1 VGND VGND VPWR VPWR _5164_/A sky130_fd_sc_hd__a211o_4
XFILLER_96_291 VGND VGND VPWR VPWR sky130_fd_sc_hd__decap_3
XFILLER_56_144 VGND VGND VPWR VPWR sky130_fd_sc_hd__decap_3
X_5079_ _5080_/A _5080_/B VGND VGND VPWR VPWR _5079_/Y sky130_fd_sc_hd__nand2b_2
XFILLER_44_306 VGND VGND VPWR VPWR sky130_fd_sc_hd__fill_2
XFILLER_56_177 VGND VGND VPWR VPWR sky130_fd_sc_hd__decap_3
XFILLER_84_475 VGND VGND VPWR VPWR sky130_fd_sc_hd__fill_1
XFILLER_84_486 VGND VGND VPWR VPWR sky130_fd_sc_hd__decap_3
XTAP_TAPCELL_ROW_27_504 VGND VPWR sky130_fd_sc_hd__tapvpwrvgnd_1
XFILLER_25_520 VGND VGND VPWR VPWR sky130_fd_sc_hd__decap_3
XFILLER_37_380 VGND VGND VPWR VPWR sky130_fd_sc_hd__decap_3
XFILLER_71_136 VGND VGND VPWR VPWR sky130_fd_sc_hd__decap_3
XFILLER_71_169 VGND VGND VPWR VPWR sky130_fd_sc_hd__decap_3
XFILLER_25_597 VGND VGND VPWR VPWR sky130_fd_sc_hd__fill_1
XFILLER_40_512 VGND VGND VPWR VPWR sky130_fd_sc_hd__fill_2
XFILLER_52_383 VGND VGND VPWR VPWR sky130_fd_sc_hd__fill_2
XTAP_TAPCELL_ROW_35_581 VGND VPWR sky130_fd_sc_hd__tapvpwrvgnd_1
XFILLER_100_85 VGND VGND VPWR VPWR sky130_fd_sc_hd__decap_3
XFILLER_40_589 VGND VGND VPWR VPWR sky130_fd_sc_hd__decap_3
XFILLER_20_291 VGND VGND VPWR VPWR sky130_fd_sc_hd__fill_1
XFILLER_69_21 VGND VGND VPWR VPWR sky130_fd_sc_hd__fill_1
XFILLER_79_225 VGND VGND VPWR VPWR sky130_fd_sc_hd__fill_2
XFILLER_79_258 VGND VGND VPWR VPWR sky130_fd_sc_hd__decap_3
XFILLER_47_111 VGND VGND VPWR VPWR sky130_fd_sc_hd__fill_1
XTAP_TAPCELL_ROW_7_295 VGND VPWR sky130_fd_sc_hd__tapvpwrvgnd_1
XFILLER_94_228 VGND VGND VPWR VPWR sky130_fd_sc_hd__decap_3
XFILLER_85_75 VGND VGND VPWR VPWR sky130_fd_sc_hd__decap_3
XFILLER_47_166 VGND VGND VPWR VPWR sky130_fd_sc_hd__fill_2
XFILLER_62_114 VGND VGND VPWR VPWR sky130_fd_sc_hd__decap_3
XFILLER_16_520 VGND VGND VPWR VPWR sky130_fd_sc_hd__decap_3
XFILLER_90_456 VGND VGND VPWR VPWR sky130_fd_sc_hd__decap_3
XFILLER_31_501 VGND VGND VPWR VPWR sky130_fd_sc_hd__decap_3
XFILLER_50_309 VGND VGND VPWR VPWR sky130_fd_sc_hd__decap_3
XFILLER_31_523 VGND VGND VPWR VPWR sky130_fd_sc_hd__decap_3
XFILLER_43_372 VGND VGND VPWR VPWR sky130_fd_sc_hd__decap_3
XFILLER_43_383 VGND VGND VPWR VPWR sky130_fd_sc_hd__decap_3
XFILLER_70_180 VGND VGND VPWR VPWR sky130_fd_sc_hd__decap_3
XFILLER_31_567 VGND VGND VPWR VPWR sky130_fd_sc_hd__decap_3
X_4450_ _4321_/B _4325_/X _4446_/X _4449_/Y VGND VGND VPWR VPWR _5939_/A sky130_fd_sc_hd__o211a_2
X_4381_ _4351_/Y _4375_/X _4380_/Y _4308_/X VGND VGND VPWR VPWR _4382_/A sky130_fd_sc_hd__a211oi_2
X_6120_ _6120_/A _6120_/B VGND VGND VPWR VPWR _6381_/C sky130_fd_sc_hd__or2_2
XFILLER_100_517 VGND VGND VPWR VPWR sky130_fd_sc_hd__decap_3
XFILLER_58_409 VGND VGND VPWR VPWR sky130_fd_sc_hd__decap_3
XFILLER_85_217 VGND VGND VPWR VPWR sky130_fd_sc_hd__decap_3
Xload_slew154 _6291_/A VGND VGND VPWR VPWR _6900_/A3 sky130_fd_sc_hd__clkbuf_2
X_6051_ _4060_/A _4060_/B _4058_/X VGND VGND VPWR VPWR _6053_/A sky130_fd_sc_hd__a21oi_2
XFILLER_98_589 VGND VGND VPWR VPWR sky130_fd_sc_hd__decap_3
XFILLER_100_539 VGND VGND VPWR VPWR sky130_fd_sc_hd__decap_3
XFILLER_85_228 VGND VGND VPWR VPWR sky130_fd_sc_hd__decap_3
Xload_slew198 _5452_/A VGND VGND VPWR VPWR _4979_/A sky130_fd_sc_hd__buf_4
X_5002_ _4994_/Y _4998_/C _5000_/Y _5001_/X VGND VGND VPWR VPWR _5002_/Y sky130_fd_sc_hd__a211oi_4
XTAP_TAPCELL_ROW_69_938 VGND VPWR sky130_fd_sc_hd__tapvpwrvgnd_1
XFILLER_66_431 VGND VGND VPWR VPWR sky130_fd_sc_hd__decap_3
XFILLER_66_464 VGND VGND VPWR VPWR sky130_fd_sc_hd__decap_3
XFILLER_78_291 VGND VGND VPWR VPWR sky130_fd_sc_hd__decap_3
XFILLER_38_177 VGND VGND VPWR VPWR sky130_fd_sc_hd__fill_2
XFILLER_66_486 VGND VGND VPWR VPWR sky130_fd_sc_hd__decap_3
XFILLER_81_401 VGND VGND VPWR VPWR sky130_fd_sc_hd__decap_3
XFILLER_93_272 VGND VGND VPWR VPWR sky130_fd_sc_hd__decap_3
X_6953_ _6074_/A _6936_/A _6957_/A VGND VGND VPWR VPWR _6955_/A sky130_fd_sc_hd__a21oi_2
XFILLER_34_350 VGND VGND VPWR VPWR sky130_fd_sc_hd__decap_3
XFILLER_53_158 VGND VGND VPWR VPWR sky130_fd_sc_hd__fill_1
XFILLER_81_489 VGND VGND VPWR VPWR sky130_fd_sc_hd__decap_3
X_6884_ _6273_/B _6932_/B _6874_/X _6875_/Y _6883_/X VGND VGND VPWR VPWR _6884_/X
+ sky130_fd_sc_hd__o311a_2
X_5904_ _4913_/X _4915_/Y _5898_/X _5903_/Y VGND VGND VPWR VPWR _5907_/A sky130_fd_sc_hd__o211a_2
XFILLER_22_512 VGND VGND VPWR VPWR sky130_fd_sc_hd__fill_1
XFILLER_34_383 VGND VGND VPWR VPWR sky130_fd_sc_hd__fill_1
X_5835_ _5249_/Y _5251_/X _5835_/B1 _5248_/B VGND VGND VPWR VPWR _5835_/Y sky130_fd_sc_hd__o211ai_2
XFILLER_14_49 VGND VGND VPWR VPWR sky130_fd_sc_hd__fill_2
XFILLER_22_567 VGND VGND VPWR VPWR sky130_fd_sc_hd__fill_1
XFILLER_22_589 VGND VGND VPWR VPWR sky130_fd_sc_hd__decap_3
X_5766_ _5766_/A _5775_/A VGND VGND VPWR VPWR _5767_/B sky130_fd_sc_hd__or2_2
XTAP_TAPCELL_ROW_32_551 VGND VPWR sky130_fd_sc_hd__tapvpwrvgnd_1
X_5697_ _5778_/B _6945_/B1 _5725_/C _5695_/A VGND VGND VPWR VPWR _5698_/C sky130_fd_sc_hd__a22oi_2
X_4717_ _5046_/B _5115_/B VGND VGND VPWR VPWR _4719_/B sky130_fd_sc_hd__nand2_2
XFILLER_30_26 VGND VGND VPWR VPWR sky130_fd_sc_hd__fill_2
X_4648_ _4648_/A _4648_/B VGND VGND VPWR VPWR _4655_/B sky130_fd_sc_hd__nor2_2
XPHY_EDGE_ROW_15_Left_116 VGND VGND VPWR VPWR sky130_fd_sc_hd__decap_3
X_4579_ _4793_/A _5162_/A _4978_/C _4978_/D VGND VGND VPWR VPWR _4579_/X sky130_fd_sc_hd__and4_2
XFILLER_89_534 VGND VGND VPWR VPWR sky130_fd_sc_hd__fill_2
X_6318_ _6897_/S _6698_/A VGND VGND VPWR VPWR _6767_/B sky130_fd_sc_hd__nand2_2
XFILLER_39_57 VGND VGND VPWR VPWR sky130_fd_sc_hd__decap_3
X_6249_ _6100_/A _6249_/B VGND VGND VPWR VPWR _6250_/B sky130_fd_sc_hd__and2b_2
XFILLER_76_239 VGND VGND VPWR VPWR sky130_fd_sc_hd__decap_3
XTAP_TAPCELL_ROW_4_254 VGND VPWR sky130_fd_sc_hd__tapvpwrvgnd_1
XPHY_EDGE_ROW_24_Left_125 VGND VGND VPWR VPWR sky130_fd_sc_hd__decap_3
XFILLER_44_147 VGND VGND VPWR VPWR sky130_fd_sc_hd__decap_3
XFILLER_72_434 VGND VGND VPWR VPWR sky130_fd_sc_hd__decap_3
XFILLER_25_361 VGND VGND VPWR VPWR sky130_fd_sc_hd__decap_3
XFILLER_55_89 VGND VGND VPWR VPWR sky130_fd_sc_hd__decap_3
XFILLER_71_11 VGND VGND VPWR VPWR sky130_fd_sc_hd__fill_1
XFILLER_13_556 VGND VGND VPWR VPWR sky130_fd_sc_hd__decap_3
XPHY_EDGE_ROW_33_Left_134 VGND VGND VPWR VPWR sky130_fd_sc_hd__decap_3
XTAP_TAPCELL_ROW_78_1033 VGND VPWR sky130_fd_sc_hd__tapvpwrvgnd_1
XFILLER_99_309 VGND VGND VPWR VPWR sky130_fd_sc_hd__decap_3
XFILLER_4_243 VGND VGND VPWR VPWR sky130_fd_sc_hd__decap_3
XFILLER_4_287 VGND VGND VPWR VPWR sky130_fd_sc_hd__decap_3
XFILLER_0_482 VGND VGND VPWR VPWR sky130_fd_sc_hd__decap_3
XFILLER_67_228 VGND VGND VPWR VPWR sky130_fd_sc_hd__decap_3
XPHY_EDGE_ROW_42_Left_143 VGND VGND VPWR VPWR sky130_fd_sc_hd__decap_3
XFILLER_48_442 VGND VGND VPWR VPWR sky130_fd_sc_hd__decap_3
XTAP_TAPCELL_ROW_66_908 VGND VPWR sky130_fd_sc_hd__tapvpwrvgnd_1
XTAP_TAPCELL_ROW_89_1151 VGND VPWR sky130_fd_sc_hd__tapvpwrvgnd_1
XFILLER_16_350 VGND VGND VPWR VPWR sky130_fd_sc_hd__decap_3
XFILLER_35_169 VGND VGND VPWR VPWR sky130_fd_sc_hd__decap_3
XFILLER_50_106 VGND VGND VPWR VPWR sky130_fd_sc_hd__decap_3
XFILLER_63_467 VGND VGND VPWR VPWR sky130_fd_sc_hd__decap_3
XFILLER_90_253 VGND VGND VPWR VPWR sky130_fd_sc_hd__decap_3
X_3950_ _3950_/A _6039_/B _3950_/C VGND VGND VPWR VPWR _3951_/B sky130_fd_sc_hd__nor3_2
XTAP_TAPCELL_ROW_74_996 VGND VPWR sky130_fd_sc_hd__tapvpwrvgnd_1
XTAP_TAPCELL_ROW_46_698 VGND VPWR sky130_fd_sc_hd__tapvpwrvgnd_1
X_3881_ _3881_/A _3881_/B VGND VGND VPWR VPWR _3882_/B sky130_fd_sc_hd__nor2_2
XPHY_EDGE_ROW_51_Left_152 VGND VGND VPWR VPWR sky130_fd_sc_hd__decap_3
XFILLER_31_375 VGND VGND VPWR VPWR sky130_fd_sc_hd__decap_3
XFILLER_84_3 VGND VGND VPWR VPWR sky130_fd_sc_hd__decap_3
X_5620_ _5620_/A _5620_/B VGND VGND VPWR VPWR _5655_/A sky130_fd_sc_hd__or2_2
X_5551_ _5599_/A _5600_/A VGND VGND VPWR VPWR _5555_/B sky130_fd_sc_hd__nand2_2
XFILLER_8_571 VGND VGND VPWR VPWR sky130_fd_sc_hd__fill_2
X_4502_ _4497_/B _4473_/Y _4500_/Y _4435_/X VGND VGND VPWR VPWR _4502_/Y sky130_fd_sc_hd__a211oi_4
XFILLER_6_61 VGND VGND VPWR VPWR sky130_fd_sc_hd__decap_3
X_5482_ _5550_/A _5550_/B VGND VGND VPWR VPWR _5552_/A sky130_fd_sc_hd__nand2_2
X_4433_ _4432_/A _4900_/B _4432_/C VGND VGND VPWR VPWR _4434_/B sky130_fd_sc_hd__a21oi_2
Xfanout506 _4607_/A VGND VGND VPWR VPWR wire507/A sky130_fd_sc_hd__clkdlybuf4s25_1
X_4364_ _4364_/A _4364_/B _4364_/C VGND VGND VPWR VPWR _4481_/A sky130_fd_sc_hd__or3_4
XFILLER_58_206 VGND VGND VPWR VPWR sky130_fd_sc_hd__decap_3
Xfanout517 _5976_/B VGND VGND VPWR VPWR _3585_/A sky130_fd_sc_hd__clkdlybuf4s25_1
Xfanout539 fanout541/X VGND VGND VPWR VPWR _3550_/B sky130_fd_sc_hd__dlymetal6s2s_1
X_6103_ _6104_/A _6104_/B VGND VGND VPWR VPWR _6383_/A sky130_fd_sc_hd__nor2_2
X_4295_ _4295_/A1 _4420_/C _4538_/D _4822_/A VGND VGND VPWR VPWR _4295_/Y sky130_fd_sc_hd__a22oi_2
XPHY_EDGE_ROW_60_Left_161 VGND VGND VPWR VPWR sky130_fd_sc_hd__decap_3
XFILLER_58_239 VGND VGND VPWR VPWR sky130_fd_sc_hd__decap_3
X_6034_ _6019_/D _4264_/B _3937_/A _3935_/A VGND VGND VPWR VPWR _6035_/B sky130_fd_sc_hd__a31o_2
XFILLER_73_209 VGND VGND VPWR VPWR sky130_fd_sc_hd__decap_3
XTAP_TAPCELL_ROW_1_224 VGND VPWR sky130_fd_sc_hd__tapvpwrvgnd_1
XFILLER_54_445 VGND VGND VPWR VPWR sky130_fd_sc_hd__decap_3
XFILLER_66_294 VGND VGND VPWR VPWR sky130_fd_sc_hd__decap_3
XFILLER_81_220 VGND VGND VPWR VPWR sky130_fd_sc_hd__decap_3
XFILLER_81_231 VGND VGND VPWR VPWR sky130_fd_sc_hd__decap_3
XTAP_TAPCELL_ROW_37_610 VGND VPWR sky130_fd_sc_hd__tapvpwrvgnd_1
XFILLER_14_309 VGND VGND VPWR VPWR sky130_fd_sc_hd__decap_3
X_6936_ _6936_/A _6971_/B VGND VGND VPWR VPWR _6936_/Y sky130_fd_sc_hd__nand2_2
XFILLER_25_48 VGND VGND VPWR VPWR sky130_fd_sc_hd__decap_3
XFILLER_41_117 VGND VGND VPWR VPWR sky130_fd_sc_hd__decap_3
XFILLER_34_180 VGND VGND VPWR VPWR sky130_fd_sc_hd__decap_3
X_6867_ _6867_/A _6867_/B VGND VGND VPWR VPWR _6867_/Y sky130_fd_sc_hd__nand2_2
XFILLER_10_526 VGND VGND VPWR VPWR sky130_fd_sc_hd__decap_3
X_6798_ _6795_/B _6810_/B1 _6965_/A _6797_/X VGND VGND VPWR VPWR _6798_/Y sky130_fd_sc_hd__o211ai_2
X_5818_ _5688_/Y _6687_/A _5815_/X _5817_/Y _5651_/X VGND VGND VPWR VPWR _5818_/Y
+ sky130_fd_sc_hd__a41oi_4
X_5749_ _5757_/A _5739_/D _5709_/X VGND VGND VPWR VPWR _5750_/B sky130_fd_sc_hd__a21oi_2
XTAP_TAPCELL_ROW_9_313 VGND VPWR sky130_fd_sc_hd__tapvpwrvgnd_1
XFILLER_1_246 VGND VGND VPWR VPWR sky130_fd_sc_hd__fill_1
XFILLER_49_228 VGND VGND VPWR VPWR sky130_fd_sc_hd__decap_3
XFILLER_57_250 VGND VGND VPWR VPWR sky130_fd_sc_hd__decap_3
XFILLER_64_209 VGND VGND VPWR VPWR sky130_fd_sc_hd__decap_3
XFILLER_66_88 VGND VGND VPWR VPWR sky130_fd_sc_hd__decap_3
XFILLER_72_253 VGND VGND VPWR VPWR sky130_fd_sc_hd__decap_3
XFILLER_82_32 VGND VGND VPWR VPWR sky130_fd_sc_hd__decap_3
XFILLER_32_128 VGND VGND VPWR VPWR sky130_fd_sc_hd__decap_3
XFILLER_72_297 VGND VGND VPWR VPWR sky130_fd_sc_hd__decap_3
XFILLER_13_320 VGND VGND VPWR VPWR sky130_fd_sc_hd__fill_2
XFILLER_25_191 VGND VGND VPWR VPWR sky130_fd_sc_hd__fill_2
XFILLER_82_76 VGND VGND VPWR VPWR sky130_fd_sc_hd__decap_3
XTAP_TAPCELL_ROW_71_966 VGND VPWR sky130_fd_sc_hd__tapvpwrvgnd_1
XTAP_TAPCELL_ROW_43_668 VGND VPWR sky130_fd_sc_hd__tapvpwrvgnd_1
XFILLER_9_302 VGND VGND VPWR VPWR sky130_fd_sc_hd__decap_3
XFILLER_40_183 VGND VGND VPWR VPWR sky130_fd_sc_hd__fill_1
XFILLER_40_194 VGND VGND VPWR VPWR sky130_fd_sc_hd__fill_2
XFILLER_9_368 VGND VGND VPWR VPWR sky130_fd_sc_hd__fill_2
XFILLER_5_541 VGND VGND VPWR VPWR sky130_fd_sc_hd__fill_1
Xrebuffer690 wire672/X VGND VGND VPWR VPWR fanout662/A sky130_fd_sc_hd__buf_2
XFILLER_49_6 VGND VGND VPWR VPWR sky130_fd_sc_hd__fill_1
XFILLER_99_128 VGND VGND VPWR VPWR sky130_fd_sc_hd__fill_2
XFILLER_68_548 VGND VGND VPWR VPWR sky130_fd_sc_hd__decap_3
Xoutput91 _6994_/B VGND VGND VPWR VPWR result[28] sky130_fd_sc_hd__buf_8
Xoutput80 _6984_/B VGND VGND VPWR VPWR result[18] sky130_fd_sc_hd__dlymetal6s4s_1
X_4080_ _4080_/A _4080_/B VGND VGND VPWR VPWR _4081_/B sky130_fd_sc_hd__nand2_2
XFILLER_76_570 VGND VGND VPWR VPWR sky130_fd_sc_hd__decap_3
XFILLER_48_272 VGND VGND VPWR VPWR sky130_fd_sc_hd__decap_3
XFILLER_76_592 VGND VGND VPWR VPWR sky130_fd_sc_hd__decap_3
XFILLER_63_231 VGND VGND VPWR VPWR sky130_fd_sc_hd__decap_3
XFILLER_63_264 VGND VGND VPWR VPWR sky130_fd_sc_hd__decap_3
X_4982_ _4979_/A _6315_/A _4981_/B _4978_/X VGND VGND VPWR VPWR _4986_/A sky130_fd_sc_hd__a31oi_2
X_6721_ _6757_/C _6707_/Y _6720_/Y _6706_/X VGND VGND VPWR VPWR _6989_/B sky130_fd_sc_hd__a211o_2
X_3933_ _6024_/B _3933_/B _6019_/B _3933_/D VGND VGND VPWR VPWR _3935_/A sky130_fd_sc_hd__and4_2
X_6652_ _6652_/A _6655_/B VGND VGND VPWR VPWR _6652_/Y sky130_fd_sc_hd__nor2_2
X_3864_ _5965_/B _3864_/B VGND VGND VPWR VPWR _3866_/A sky130_fd_sc_hd__or2_2
X_5603_ _5603_/A _5603_/B VGND VGND VPWR VPWR _5618_/B sky130_fd_sc_hd__xor2_2
X_6583_ _6583_/A _6583_/B VGND VGND VPWR VPWR _6583_/Y sky130_fd_sc_hd__xnor2_2
X_3795_ _3795_/A _3795_/B VGND VGND VPWR VPWR _3796_/B sky130_fd_sc_hd__nor2_2
XFILLER_11_39 VGND VGND VPWR VPWR sky130_fd_sc_hd__decap_3
X_5534_ _5534_/A _5534_/B VGND VGND VPWR VPWR _5537_/B sky130_fd_sc_hd__xnor2_2
X_5465_ _5846_/A _5464_/C _5464_/B VGND VGND VPWR VPWR _5466_/C sky130_fd_sc_hd__o21ai_2
X_4416_ _4416_/A1 _4384_/X _4398_/Y _4414_/X VGND VGND VPWR VPWR _4436_/B sky130_fd_sc_hd__o211ai_2
Xfanout303 _5953_/A2 VGND VGND VPWR VPWR _4539_/B sky130_fd_sc_hd__buf_6
Xfanout314 _6187_/A VGND VGND VPWR VPWR _3961_/C sky130_fd_sc_hd__buf_2
X_5396_ _5370_/A _5370_/C _5370_/B VGND VGND VPWR VPWR _5409_/B sky130_fd_sc_hd__a21oi_2
XFILLER_100_100 VGND VGND VPWR VPWR sky130_fd_sc_hd__decap_3
XFILLER_86_323 VGND VGND VPWR VPWR sky130_fd_sc_hd__decap_3
Xfanout325 _4088_/C VGND VGND VPWR VPWR _6276_/A sky130_fd_sc_hd__clkbuf_2
Xfanout336 _5981_/C VGND VGND VPWR VPWR _3551_/B1 sky130_fd_sc_hd__clkdlybuf4s25_1
Xfanout347 _6499_/S VGND VGND VPWR VPWR _5282_/B sky130_fd_sc_hd__clkdlybuf4s25_1
X_4347_ _4466_/A _4466_/B VGND VGND VPWR VPWR _4348_/C sky130_fd_sc_hd__and2_2
XFILLER_98_172 VGND VGND VPWR VPWR sky130_fd_sc_hd__decap_3
XFILLER_100_111 VGND VGND VPWR VPWR sky130_fd_sc_hd__fill_1
XFILLER_59_559 VGND VGND VPWR VPWR sky130_fd_sc_hd__fill_1
Xfanout358 _6938_/S1 VGND VGND VPWR VPWR _6125_/B sky130_fd_sc_hd__clkdlybuf4s25_1
Xfanout369 input43/X VGND VGND VPWR VPWR _4628_/C sky130_fd_sc_hd__clkbuf_2
X_4278_ _4167_/A _4167_/C _4167_/B VGND VGND VPWR VPWR _4279_/C sky130_fd_sc_hd__o21ai_2
XFILLER_39_250 VGND VGND VPWR VPWR sky130_fd_sc_hd__fill_2
XFILLER_86_389 VGND VGND VPWR VPWR sky130_fd_sc_hd__decap_3
X_6017_ _6017_/A _6017_/B VGND VGND VPWR VPWR _6023_/A sky130_fd_sc_hd__nor2_2
XFILLER_27_423 VGND VGND VPWR VPWR sky130_fd_sc_hd__decap_3
XFILLER_39_272 VGND VGND VPWR VPWR sky130_fd_sc_hd__decap_3
XFILLER_27_467 VGND VGND VPWR VPWR sky130_fd_sc_hd__decap_3
XFILLER_36_47 VGND VGND VPWR VPWR sky130_fd_sc_hd__decap_3
XFILLER_54_253 VGND VGND VPWR VPWR sky130_fd_sc_hd__decap_3
XFILLER_82_595 VGND VGND VPWR VPWR sky130_fd_sc_hd__decap_3
X_6919_ _6931_/A _6919_/B _6919_/C VGND VGND VPWR VPWR _6919_/X sky130_fd_sc_hd__and3_2
XFILLER_22_150 VGND VGND VPWR VPWR sky130_fd_sc_hd__decap_3
XFILLER_52_46 VGND VGND VPWR VPWR sky130_fd_sc_hd__decap_3
XFILLER_10_312 VGND VGND VPWR VPWR sky130_fd_sc_hd__decap_3
XFILLER_50_492 VGND VGND VPWR VPWR sky130_fd_sc_hd__decap_3
XTAP_TAPCELL_ROW_40_638 VGND VPWR sky130_fd_sc_hd__tapvpwrvgnd_1
XTAP_TAPCELL_ROW_75_1003 VGND VPWR sky130_fd_sc_hd__tapvpwrvgnd_1
XFILLER_2_533 VGND VGND VPWR VPWR sky130_fd_sc_hd__decap_3
XFILLER_77_323 VGND VGND VPWR VPWR sky130_fd_sc_hd__decap_3
XFILLER_89_161 VGND VGND VPWR VPWR sky130_fd_sc_hd__decap_3
XFILLER_77_76 VGND VGND VPWR VPWR sky130_fd_sc_hd__decap_3
XFILLER_18_401 VGND VGND VPWR VPWR sky130_fd_sc_hd__decap_3
XFILLER_37_209 VGND VGND VPWR VPWR sky130_fd_sc_hd__decap_3
XFILLER_65_518 VGND VGND VPWR VPWR sky130_fd_sc_hd__fill_1
XFILLER_77_378 VGND VGND VPWR VPWR sky130_fd_sc_hd__decap_3
XFILLER_92_315 VGND VGND VPWR VPWR sky130_fd_sc_hd__fill_1
XTAP_TAPCELL_ROW_48_716 VGND VPWR sky130_fd_sc_hd__tapvpwrvgnd_1
XFILLER_92_326 VGND VGND VPWR VPWR sky130_fd_sc_hd__decap_3
XTAP_TAPCELL_ROW_86_1121 VGND VPWR sky130_fd_sc_hd__tapvpwrvgnd_1
XFILLER_18_456 VGND VGND VPWR VPWR sky130_fd_sc_hd__decap_3
XFILLER_45_231 VGND VGND VPWR VPWR sky130_fd_sc_hd__decap_3
XFILLER_92_359 VGND VGND VPWR VPWR sky130_fd_sc_hd__decap_3
XFILLER_18_489 VGND VGND VPWR VPWR sky130_fd_sc_hd__decap_3
XFILLER_33_437 VGND VGND VPWR VPWR sky130_fd_sc_hd__decap_3
XFILLER_60_234 VGND VGND VPWR VPWR sky130_fd_sc_hd__decap_3
XFILLER_41_481 VGND VGND VPWR VPWR sky130_fd_sc_hd__fill_1
XFILLER_41_492 VGND VGND VPWR VPWR sky130_fd_sc_hd__fill_1
X_3580_ _3578_/X _3580_/B VGND VGND VPWR VPWR _3581_/B sky130_fd_sc_hd__and2b_2
XFILLER_5_382 VGND VGND VPWR VPWR sky130_fd_sc_hd__decap_3
X_5250_ _5250_/A _5250_/B _5831_/A VGND VGND VPWR VPWR _5250_/X sky130_fd_sc_hd__or3b_2
XFILLER_47_3 VGND VGND VPWR VPWR sky130_fd_sc_hd__decap_3
X_4201_ _4201_/A _4201_/B VGND VGND VPWR VPWR _4203_/B sky130_fd_sc_hd__nor2_2
X_5181_ _5258_/B1 _5101_/X _5180_/A _5184_/A VGND VGND VPWR VPWR _5263_/A sky130_fd_sc_hd__o211a_2
X_4132_ _4132_/A _4132_/B _4132_/C VGND VGND VPWR VPWR _4132_/Y sky130_fd_sc_hd__nand3_2
X_4063_ _4072_/A _4072_/B VGND VGND VPWR VPWR _4074_/A sky130_fd_sc_hd__nand2_2
XFILLER_64_595 VGND VGND VPWR VPWR sky130_fd_sc_hd__decap_3
XFILLER_91_370 VGND VGND VPWR VPWR sky130_fd_sc_hd__decap_3
XFILLER_24_448 VGND VGND VPWR VPWR sky130_fd_sc_hd__decap_3
XFILLER_24_459 VGND VGND VPWR VPWR sky130_fd_sc_hd__decap_3
XFILLER_51_223 VGND VGND VPWR VPWR sky130_fd_sc_hd__fill_1
X_4965_ _4965_/A _5313_/B VGND VGND VPWR VPWR _4967_/A sky130_fd_sc_hd__nand2_2
X_6704_ _6777_/A _6687_/Y _6703_/X VGND VGND VPWR VPWR _6989_/A sky130_fd_sc_hd__o21ai_2
X_3916_ _3916_/A _3916_/B _3916_/C VGND VGND VPWR VPWR _3916_/Y sky130_fd_sc_hd__nand3_2
X_4896_ _4547_/A _4547_/C _4547_/B VGND VGND VPWR VPWR _4897_/B sky130_fd_sc_hd__a21oi_2
X_6635_ _6635_/A _6635_/B VGND VGND VPWR VPWR _6635_/Y sky130_fd_sc_hd__xnor2_2
X_3847_ _3845_/A _3952_/B _3844_/B _4056_/A VGND VGND VPWR VPWR _3886_/A sky130_fd_sc_hd__a31o_2
X_6566_ _6566_/A _6853_/A _6566_/C VGND VGND VPWR VPWR _6566_/X sky130_fd_sc_hd__or3_2
X_3778_ _3778_/A _3778_/B _4178_/A VGND VGND VPWR VPWR _3779_/B sky130_fd_sc_hd__or3_2
X_5517_ _5517_/A1 _5515_/X _5514_/Y _5517_/C1 VGND VGND VPWR VPWR _5517_/Y sky130_fd_sc_hd__o211ai_2
X_6497_ _6625_/A _6496_/X _6491_/X VGND VGND VPWR VPWR _6498_/C sky130_fd_sc_hd__a21o_2
XFILLER_0_9 VGND VGND VPWR VPWR sky130_fd_sc_hd__decap_3
X_5448_ _5448_/A _5448_/B VGND VGND VPWR VPWR _5451_/C sky130_fd_sc_hd__nand2_2
XFILLER_59_301 VGND VGND VPWR VPWR sky130_fd_sc_hd__decap_3
Xfanout122 _6369_/Y VGND VGND VPWR VPWR _6586_/A sky130_fd_sc_hd__clkdlybuf4s25_1
X_5379_ _5543_/A _5777_/A _6109_/B _5680_/B VGND VGND VPWR VPWR _5620_/A sky130_fd_sc_hd__and4_2
XFILLER_99_470 VGND VGND VPWR VPWR sky130_fd_sc_hd__decap_3
XFILLER_59_334 VGND VGND VPWR VPWR sky130_fd_sc_hd__fill_2
Xfanout133 _6333_/X VGND VGND VPWR VPWR _6781_/A2 sky130_fd_sc_hd__clkdlybuf4s25_1
XFILLER_47_24 VGND VGND VPWR VPWR sky130_fd_sc_hd__decap_3
XFILLER_47_35 VGND VGND VPWR VPWR sky130_fd_sc_hd__decap_3
XFILLER_74_315 VGND VGND VPWR VPWR sky130_fd_sc_hd__decap_3
Xfanout166 _3501_/Y VGND VGND VPWR VPWR _6493_/A sky130_fd_sc_hd__buf_2
Xfanout177 _3500_/Y VGND VGND VPWR VPWR _6608_/S sky130_fd_sc_hd__clkdlybuf4s25_1
Xfanout188 input8/X VGND VGND VPWR VPWR _4526_/A sky130_fd_sc_hd__clkdlybuf4s25_1
Xfanout199 _3748_/A VGND VGND VPWR VPWR _4525_/B2 sky130_fd_sc_hd__clkdlybuf4s25_1
XFILLER_47_57 VGND VGND VPWR VPWR sky130_fd_sc_hd__fill_2
XFILLER_86_186 VGND VGND VPWR VPWR sky130_fd_sc_hd__decap_3
XFILLER_86_197 VGND VGND VPWR VPWR sky130_fd_sc_hd__decap_3
XPHY_EDGE_ROW_29_Right_29 VGND VGND VPWR VPWR sky130_fd_sc_hd__decap_3
XFILLER_27_231 VGND VGND VPWR VPWR sky130_fd_sc_hd__fill_1
XFILLER_55_551 VGND VGND VPWR VPWR sky130_fd_sc_hd__decap_3
XFILLER_15_415 VGND VGND VPWR VPWR sky130_fd_sc_hd__fill_1
XFILLER_27_275 VGND VGND VPWR VPWR sky130_fd_sc_hd__decap_3
XFILLER_55_595 VGND VGND VPWR VPWR sky130_fd_sc_hd__decap_3
XFILLER_70_521 VGND VGND VPWR VPWR sky130_fd_sc_hd__decap_3
XFILLER_42_245 VGND VGND VPWR VPWR sky130_fd_sc_hd__decap_3
XFILLER_63_34 VGND VGND VPWR VPWR sky130_fd_sc_hd__fill_2
XFILLER_63_45 VGND VGND VPWR VPWR sky130_fd_sc_hd__decap_3
XFILLER_30_418 VGND VGND VPWR VPWR sky130_fd_sc_hd__fill_2
XFILLER_63_78 VGND VGND VPWR VPWR sky130_fd_sc_hd__decap_3
XFILLER_70_565 VGND VGND VPWR VPWR sky130_fd_sc_hd__fill_2
XTAP_TAPCELL_ROW_53_774 VGND VPWR sky130_fd_sc_hd__tapvpwrvgnd_1
XTAP_TAPCELL_ROW_25_476 VGND VPWR sky130_fd_sc_hd__tapvpwrvgnd_1
XFILLER_8_29 VGND VGND VPWR VPWR sky130_fd_sc_hd__decap_3
XPHY_EDGE_ROW_7_Left_108 VGND VGND VPWR VPWR sky130_fd_sc_hd__decap_3
XPHY_EDGE_ROW_38_Right_38 VGND VGND VPWR VPWR sky130_fd_sc_hd__decap_3
XFILLER_6_102 VGND VGND VPWR VPWR sky130_fd_sc_hd__decap_3
XFILLER_10_197 VGND VGND VPWR VPWR sky130_fd_sc_hd__fill_2
XFILLER_6_146 VGND VGND VPWR VPWR sky130_fd_sc_hd__decap_3
XFILLER_69_109 VGND VGND VPWR VPWR sky130_fd_sc_hd__decap_3
Xload_slew528 _3640_/A1 VGND VGND VPWR VPWR _4617_/A sky130_fd_sc_hd__clkbuf_4
XTAP_TAPCELL_ROW_92_1180 VGND VPWR sky130_fd_sc_hd__tapvpwrvgnd_1
XFILLER_97_418 VGND VGND VPWR VPWR sky130_fd_sc_hd__fill_1
XFILLER_38_507 VGND VGND VPWR VPWR sky130_fd_sc_hd__decap_3
XFILLER_77_142 VGND VGND VPWR VPWR sky130_fd_sc_hd__decap_3
XFILLER_77_164 VGND VGND VPWR VPWR sky130_fd_sc_hd__decap_3
XPHY_EDGE_ROW_47_Right_47 VGND VGND VPWR VPWR sky130_fd_sc_hd__decap_3
XFILLER_65_315 VGND VGND VPWR VPWR sky130_fd_sc_hd__decap_3
XFILLER_65_337 VGND VGND VPWR VPWR sky130_fd_sc_hd__decap_3
XFILLER_92_101 VGND VGND VPWR VPWR sky130_fd_sc_hd__decap_3
XFILLER_92_112 VGND VGND VPWR VPWR sky130_fd_sc_hd__decap_3
XFILLER_18_253 VGND VGND VPWR VPWR sky130_fd_sc_hd__decap_3
XFILLER_73_370 VGND VGND VPWR VPWR sky130_fd_sc_hd__decap_3
XFILLER_80_318 VGND VGND VPWR VPWR sky130_fd_sc_hd__fill_2
XFILLER_33_234 VGND VGND VPWR VPWR sky130_fd_sc_hd__decap_3
XFILLER_61_554 VGND VGND VPWR VPWR sky130_fd_sc_hd__decap_3
XFILLER_33_278 VGND VGND VPWR VPWR sky130_fd_sc_hd__fill_2
X_4750_ _4748_/A _5321_/C _5321_/D _4748_/B VGND VGND VPWR VPWR _4751_/B sky130_fd_sc_hd__a22o_2
XPHY_EDGE_ROW_56_Right_56 VGND VGND VPWR VPWR sky130_fd_sc_hd__decap_3
X_4681_ _4681_/A _4870_/A _4604_/Y VGND VGND VPWR VPWR _4855_/A sky130_fd_sc_hd__or3b_4
X_3701_ _3701_/A _3701_/B VGND VGND VPWR VPWR _3703_/B sky130_fd_sc_hd__xnor2_2
X_6420_ _6417_/X _6420_/B _6432_/S VGND VGND VPWR VPWR _6420_/Y sky130_fd_sc_hd__nand3b_2
X_3632_ _3632_/A _3632_/B VGND VGND VPWR VPWR _3633_/C sky130_fd_sc_hd__xnor2_2
X_6351_ _6730_/A _6350_/B _6069_/X _6206_/X _6286_/X VGND VGND VPWR VPWR _6351_/X
+ sky130_fd_sc_hd__o221a_2
X_5302_ _5300_/X _5302_/B VGND VGND VPWR VPWR _5303_/B sky130_fd_sc_hd__and2b_2
X_3563_ _3599_/B _3563_/B VGND VGND VPWR VPWR _3565_/C sky130_fd_sc_hd__nor2_2
X_6282_ _3485_/Y _6175_/B _6932_/A VGND VGND VPWR VPWR _6284_/B sky130_fd_sc_hd__a21o_2
X_3494_ _6085_/B VGND VGND VPWR VPWR _6266_/B sky130_fd_sc_hd__inv_2
X_5233_ _5234_/A _5234_/B VGND VGND VPWR VPWR _5233_/Y sky130_fd_sc_hd__nand2_2
XPHY_EDGE_ROW_65_Right_65 VGND VGND VPWR VPWR sky130_fd_sc_hd__decap_3
X_5164_ _5164_/A _5164_/B _5164_/C VGND VGND VPWR VPWR _5244_/B sky130_fd_sc_hd__and3_4
XFILLER_68_164 VGND VGND VPWR VPWR sky130_fd_sc_hd__decap_3
X_4115_ _3651_/A _3650_/C _3650_/B VGND VGND VPWR VPWR _4132_/B sky130_fd_sc_hd__a21o_2
XFILLER_96_451 VGND VGND VPWR VPWR sky130_fd_sc_hd__decap_3
XFILLER_56_315 VGND VGND VPWR VPWR sky130_fd_sc_hd__decap_3
XFILLER_68_197 VGND VGND VPWR VPWR sky130_fd_sc_hd__decap_3
X_5095_ _5091_/Y _5093_/Y _5094_/X _5002_/Y VGND VGND VPWR VPWR _5098_/A sky130_fd_sc_hd__a211oi_4
XFILLER_37_551 VGND VGND VPWR VPWR sky130_fd_sc_hd__decap_3
XFILLER_83_134 VGND VGND VPWR VPWR sky130_fd_sc_hd__decap_3
X_4046_ _4046_/A _4046_/B _4046_/C VGND VGND VPWR VPWR _4065_/A sky130_fd_sc_hd__and3_2
XFILLER_52_510 VGND VGND VPWR VPWR sky130_fd_sc_hd__decap_3
XFILLER_71_329 VGND VGND VPWR VPWR sky130_fd_sc_hd__decap_3
XFILLER_83_167 VGND VGND VPWR VPWR sky130_fd_sc_hd__fill_1
XFILLER_83_189 VGND VGND VPWR VPWR sky130_fd_sc_hd__decap_3
XFILLER_24_245 VGND VGND VPWR VPWR sky130_fd_sc_hd__decap_3
XFILLER_64_392 VGND VGND VPWR VPWR sky130_fd_sc_hd__decap_3
XFILLER_12_418 VGND VGND VPWR VPWR sky130_fd_sc_hd__fill_2
XFILLER_24_256 VGND VGND VPWR VPWR sky130_fd_sc_hd__fill_1
X_5997_ _5997_/A _5997_/B VGND VGND VPWR VPWR _5998_/B sky130_fd_sc_hd__xnor2_2
XPHY_EDGE_ROW_74_Right_74 VGND VGND VPWR VPWR sky130_fd_sc_hd__decap_3
XFILLER_24_289 VGND VGND VPWR VPWR sky130_fd_sc_hd__fill_2
X_4948_ _4947_/B _4947_/C _4947_/A VGND VGND VPWR VPWR _4950_/B sky130_fd_sc_hd__o21bai_2
X_4879_ _4876_/Y _4877_/X _4879_/B1 _4834_/Y VGND VGND VPWR VPWR _4879_/X sky130_fd_sc_hd__a211o_2
XTAP_TAPCELL_ROW_50_744 VGND VPWR sky130_fd_sc_hd__tapvpwrvgnd_1
XTAP_TAPCELL_ROW_22_446 VGND VPWR sky130_fd_sc_hd__tapvpwrvgnd_1
X_6618_ _6138_/Y _6383_/D _6819_/A2 VGND VGND VPWR VPWR _6618_/Y sky130_fd_sc_hd__o21ai_2
X_6549_ _6698_/A _6700_/B _6546_/X VGND VGND VPWR VPWR _6829_/B sky130_fd_sc_hd__a21oi_2
XPHY_EDGE_ROW_83_Right_83 VGND VGND VPWR VPWR sky130_fd_sc_hd__decap_3
XFILLER_58_12 VGND VGND VPWR VPWR sky130_fd_sc_hd__decap_3
XFILLER_79_429 VGND VGND VPWR VPWR sky130_fd_sc_hd__decap_3
XFILLER_59_175 VGND VGND VPWR VPWR sky130_fd_sc_hd__decap_3
XFILLER_74_123 VGND VGND VPWR VPWR sky130_fd_sc_hd__decap_3
XTAP_TAPCELL_ROW_58_822 VGND VPWR sky130_fd_sc_hd__tapvpwrvgnd_1
XFILLER_47_348 VGND VGND VPWR VPWR sky130_fd_sc_hd__decap_3
XFILLER_74_156 VGND VGND VPWR VPWR sky130_fd_sc_hd__decap_3
XFILLER_62_318 VGND VGND VPWR VPWR sky130_fd_sc_hd__decap_3
XFILLER_74_189 VGND VGND VPWR VPWR sky130_fd_sc_hd__decap_3
XFILLER_74_66 VGND VGND VPWR VPWR sky130_fd_sc_hd__decap_3
XPHY_EDGE_ROW_98_Left_199 VGND VGND VPWR VPWR sky130_fd_sc_hd__decap_3
XFILLER_15_212 VGND VGND VPWR VPWR sky130_fd_sc_hd__decap_3
XFILLER_43_543 VGND VGND VPWR VPWR sky130_fd_sc_hd__decap_3
XFILLER_55_381 VGND VGND VPWR VPWR sky130_fd_sc_hd__decap_3
XFILLER_74_99 VGND VGND VPWR VPWR sky130_fd_sc_hd__decap_3
XPHY_EDGE_ROW_92_Right_92 VGND VGND VPWR VPWR sky130_fd_sc_hd__decap_3
XFILLER_30_237 VGND VGND VPWR VPWR sky130_fd_sc_hd__decap_3
XFILLER_70_373 VGND VGND VPWR VPWR sky130_fd_sc_hd__decap_3
XFILLER_90_43 VGND VGND VPWR VPWR sky130_fd_sc_hd__fill_2
XFILLER_11_440 VGND VGND VPWR VPWR sky130_fd_sc_hd__decap_3
XFILLER_7_455 VGND VGND VPWR VPWR sky130_fd_sc_hd__fill_1
Xmax_cap108 wire109/X VGND VGND VPWR VPWR _6824_/A2 sky130_fd_sc_hd__clkbuf_1
XFILLER_7_477 VGND VGND VPWR VPWR sky130_fd_sc_hd__decap_3
Xmax_cap119 _4287_/Y VGND VGND VPWR VPWR _4416_/A1 sky130_fd_sc_hd__clkbuf_2
XFILLER_99_85 VGND VGND VPWR VPWR sky130_fd_sc_hd__decap_3
XFILLER_31_6 VGND VGND VPWR VPWR sky130_fd_sc_hd__decap_3
XFILLER_78_451 VGND VGND VPWR VPWR sky130_fd_sc_hd__decap_3
XFILLER_38_315 VGND VGND VPWR VPWR sky130_fd_sc_hd__decap_3
XFILLER_38_326 VGND VGND VPWR VPWR sky130_fd_sc_hd__fill_1
XFILLER_65_134 VGND VGND VPWR VPWR sky130_fd_sc_hd__decap_3
XFILLER_93_443 VGND VGND VPWR VPWR sky130_fd_sc_hd__decap_3
XFILLER_53_307 VGND VGND VPWR VPWR sky130_fd_sc_hd__decap_3
XFILLER_65_167 VGND VGND VPWR VPWR sky130_fd_sc_hd__fill_1
XFILLER_65_178 VGND VGND VPWR VPWR sky130_fd_sc_hd__decap_3
X_5920_ _4559_/X _4560_/Y _5920_/B1 _4558_/B VGND VGND VPWR VPWR _5920_/X sky130_fd_sc_hd__a211o_2
XFILLER_93_476 VGND VGND VPWR VPWR sky130_fd_sc_hd__decap_3
XFILLER_0_85 VGND VGND VPWR VPWR sky130_fd_sc_hd__decap_3
XFILLER_0_96 VGND VGND VPWR VPWR sky130_fd_sc_hd__decap_3
XFILLER_19_595 VGND VGND VPWR VPWR sky130_fd_sc_hd__decap_3
XFILLER_46_381 VGND VGND VPWR VPWR sky130_fd_sc_hd__decap_3
XFILLER_80_137 VGND VGND VPWR VPWR sky130_fd_sc_hd__decap_3
XFILLER_34_576 VGND VGND VPWR VPWR sky130_fd_sc_hd__decap_3
XFILLER_61_340 VGND VGND VPWR VPWR sky130_fd_sc_hd__fill_1
X_5851_ _5834_/X _5849_/Y _5851_/B1 _5848_/Y VGND VGND VPWR VPWR _5851_/Y sky130_fd_sc_hd__a211oi_4
XFILLER_21_237 VGND VGND VPWR VPWR sky130_fd_sc_hd__decap_3
XFILLER_61_384 VGND VGND VPWR VPWR sky130_fd_sc_hd__decap_3
X_5782_ _5780_/A _5790_/A _5793_/A VGND VGND VPWR VPWR _5787_/B sky130_fd_sc_hd__a21oi_2
X_4802_ _4803_/A _4803_/B VGND VGND VPWR VPWR _4802_/Y sky130_fd_sc_hd__nand2_2
XPHY_EDGE_ROW_100_Right_100 VGND VGND VPWR VPWR sky130_fd_sc_hd__decap_3
XFILLER_21_248 VGND VGND VPWR VPWR sky130_fd_sc_hd__decap_3
X_4733_ _5152_/A _4757_/B VGND VGND VPWR VPWR _4735_/A sky130_fd_sc_hd__nand2_2
X_6403_ _6401_/X _6402_/X _6478_/S VGND VGND VPWR VPWR _6403_/X sky130_fd_sc_hd__mux2_1
X_4664_ _4662_/X _4664_/B VGND VGND VPWR VPWR _4665_/B sky130_fd_sc_hd__and2b_2
X_4595_ _4593_/X _4595_/B VGND VGND VPWR VPWR _4596_/B sky130_fd_sc_hd__and2b_2
X_3615_ _6019_/B _6089_/B _3941_/B _3834_/D VGND VGND VPWR VPWR _3617_/A sky130_fd_sc_hd__and4_2
X_6334_ _6999_/A _6891_/B1 _6605_/A2 _6337_/A _6331_/Y VGND VGND VPWR VPWR _6334_/X
+ sky130_fd_sc_hd__o221a_2
X_3546_ _3544_/A _3969_/B _3969_/D _3960_/A VGND VGND VPWR VPWR _3547_/B sky130_fd_sc_hd__a22o_2
XFILLER_0_108 VGND VGND VPWR VPWR sky130_fd_sc_hd__decap_3
XFILLER_88_215 VGND VGND VPWR VPWR sky130_fd_sc_hd__decap_3
X_6265_ _6265_/A _6265_/B VGND VGND VPWR VPWR _6265_/Y sky130_fd_sc_hd__nand2_2
XFILLER_88_248 VGND VGND VPWR VPWR sky130_fd_sc_hd__decap_3
X_5216_ _5207_/X _5214_/X _5215_/X _5200_/Y VGND VGND VPWR VPWR _5448_/A sky130_fd_sc_hd__o211ai_4
XFILLER_88_259 VGND VGND VPWR VPWR sky130_fd_sc_hd__fill_1
X_6196_ _6196_/A _6196_/B VGND VGND VPWR VPWR _6197_/B sky130_fd_sc_hd__nand2_2
XFILLER_29_337 VGND VGND VPWR VPWR sky130_fd_sc_hd__decap_3
XFILLER_56_112 VGND VGND VPWR VPWR sky130_fd_sc_hd__decap_3
XFILLER_84_421 VGND VGND VPWR VPWR sky130_fd_sc_hd__decap_3
X_5147_ _5220_/A1 _5148_/C1 _5145_/Y _5147_/C1 VGND VGND VPWR VPWR _5164_/B sky130_fd_sc_hd__o211ai_2
XFILLER_56_156 VGND VGND VPWR VPWR sky130_fd_sc_hd__decap_3
XFILLER_84_454 VGND VGND VPWR VPWR sky130_fd_sc_hd__decap_3
X_5078_ _5078_/A _5078_/B VGND VGND VPWR VPWR _5080_/B sky130_fd_sc_hd__xor2_2
XFILLER_56_189 VGND VGND VPWR VPWR sky130_fd_sc_hd__decap_3
X_4029_ _4029_/A _4029_/B VGND VGND VPWR VPWR _4039_/A sky130_fd_sc_hd__xnor2_2
XTAP_TAPCELL_ROW_27_505 VGND VPWR sky130_fd_sc_hd__tapvpwrvgnd_1
XFILLER_25_532 VGND VGND VPWR VPWR sky130_fd_sc_hd__decap_3
XFILLER_25_543 VGND VGND VPWR VPWR sky130_fd_sc_hd__decap_3
XFILLER_44_58 VGND VGND VPWR VPWR sky130_fd_sc_hd__decap_3
XFILLER_52_362 VGND VGND VPWR VPWR sky130_fd_sc_hd__fill_2
XFILLER_100_20 VGND VGND VPWR VPWR sky130_fd_sc_hd__fill_2
XTAP_TAPCELL_ROW_63_880 VGND VPWR sky130_fd_sc_hd__tapvpwrvgnd_1
XTAP_TAPCELL_ROW_35_582 VGND VPWR sky130_fd_sc_hd__tapvpwrvgnd_1
XFILLER_100_64 VGND VGND VPWR VPWR sky130_fd_sc_hd__fill_2
XFILLER_60_13 VGND VGND VPWR VPWR sky130_fd_sc_hd__fill_2
XFILLER_100_97 VGND VGND VPWR VPWR sky130_fd_sc_hd__decap_3
XFILLER_60_46 VGND VGND VPWR VPWR sky130_fd_sc_hd__decap_3
XFILLER_20_270 VGND VGND VPWR VPWR sky130_fd_sc_hd__fill_2
XFILLER_4_469 VGND VGND VPWR VPWR sky130_fd_sc_hd__decap_3
XFILLER_79_215 VGND VGND VPWR VPWR sky130_fd_sc_hd__decap_3
XFILLER_85_21 VGND VGND VPWR VPWR sky130_fd_sc_hd__fill_2
XFILLER_87_281 VGND VGND VPWR VPWR sky130_fd_sc_hd__fill_2
XFILLER_87_292 VGND VGND VPWR VPWR sky130_fd_sc_hd__decap_3
XFILLER_35_329 VGND VGND VPWR VPWR sky130_fd_sc_hd__decap_3
XFILLER_47_178 VGND VGND VPWR VPWR sky130_fd_sc_hd__decap_3
XFILLER_75_465 VGND VGND VPWR VPWR sky130_fd_sc_hd__fill_2
XFILLER_85_87 VGND VGND VPWR VPWR sky130_fd_sc_hd__decap_3
XFILLER_18_81 VGND VGND VPWR VPWR sky130_fd_sc_hd__decap_3
XFILLER_62_126 VGND VGND VPWR VPWR sky130_fd_sc_hd__decap_3
XFILLER_90_435 VGND VGND VPWR VPWR sky130_fd_sc_hd__decap_3
XFILLER_43_340 VGND VGND VPWR VPWR sky130_fd_sc_hd__fill_1
XFILLER_43_351 VGND VGND VPWR VPWR sky130_fd_sc_hd__fill_2
XFILLER_90_468 VGND VGND VPWR VPWR sky130_fd_sc_hd__decap_3
XFILLER_31_535 VGND VGND VPWR VPWR sky130_fd_sc_hd__decap_3
XFILLER_34_80 VGND VGND VPWR VPWR sky130_fd_sc_hd__decap_3
XFILLER_34_91 VGND VGND VPWR VPWR sky130_fd_sc_hd__decap_3
XFILLER_70_192 VGND VGND VPWR VPWR sky130_fd_sc_hd__decap_3
XFILLER_11_281 VGND VGND VPWR VPWR sky130_fd_sc_hd__fill_2
XFILLER_7_230 VGND VGND VPWR VPWR sky130_fd_sc_hd__decap_3
XFILLER_7_252 VGND VGND VPWR VPWR sky130_fd_sc_hd__decap_3
XFILLER_7_274 VGND VGND VPWR VPWR sky130_fd_sc_hd__decap_3
Xwire161 wire161/A VGND VGND VPWR VPWR _6971_/B sky130_fd_sc_hd__buf_4
Xwire183 wire183/A VGND VGND VPWR VPWR _4280_/B sky130_fd_sc_hd__clkbuf_4
X_4380_ _4309_/A _4309_/B _4309_/C VGND VGND VPWR VPWR _4380_/Y sky130_fd_sc_hd__a21oi_2
XFILLER_98_557 VGND VGND VPWR VPWR sky130_fd_sc_hd__fill_1
Xload_slew155 _6542_/B2 VGND VGND VPWR VPWR _6291_/A sky130_fd_sc_hd__buf_4
X_6050_ _6050_/A _6050_/B VGND VGND VPWR VPWR _6054_/A sky130_fd_sc_hd__xnor2_2
XFILLER_100_529 VGND VGND VPWR VPWR sky130_fd_sc_hd__decap_3
XFILLER_66_410 VGND VGND VPWR VPWR sky130_fd_sc_hd__decap_3
XFILLER_66_421 VGND VGND VPWR VPWR sky130_fd_sc_hd__decap_3
XFILLER_78_270 VGND VGND VPWR VPWR sky130_fd_sc_hd__decap_3
X_5001_ _5001_/A1 _4999_/X _4998_/Y _4998_/A VGND VGND VPWR VPWR _5001_/X sky130_fd_sc_hd__o211a_2
XTAP_TAPCELL_ROW_69_939 VGND VPWR sky130_fd_sc_hd__tapvpwrvgnd_1
XFILLER_38_134 VGND VGND VPWR VPWR sky130_fd_sc_hd__decap_3
XFILLER_66_443 VGND VGND VPWR VPWR sky130_fd_sc_hd__decap_3
XFILLER_26_307 VGND VGND VPWR VPWR sky130_fd_sc_hd__fill_1
XFILLER_81_413 VGND VGND VPWR VPWR sky130_fd_sc_hd__fill_1
XFILLER_93_251 VGND VGND VPWR VPWR sky130_fd_sc_hd__decap_3
XFILLER_38_189 VGND VGND VPWR VPWR sky130_fd_sc_hd__decap_3
XFILLER_53_137 VGND VGND VPWR VPWR sky130_fd_sc_hd__decap_3
XFILLER_93_284 VGND VGND VPWR VPWR sky130_fd_sc_hd__decap_3
X_6952_ _6952_/A _6952_/B VGND VGND VPWR VPWR _6952_/Y sky130_fd_sc_hd__nor2_4
X_6883_ _6392_/A _6393_/B _6602_/Y _6882_/Y VGND VGND VPWR VPWR _6883_/X sky130_fd_sc_hd__o31a_2
X_5903_ _5896_/A _5897_/X _4907_/X _4911_/C VGND VGND VPWR VPWR _5903_/Y sky130_fd_sc_hd__o211ai_2
XFILLER_34_362 VGND VGND VPWR VPWR sky130_fd_sc_hd__fill_2
X_5834_ _5849_/B1 _5830_/C _5831_/Y _5832_/X VGND VGND VPWR VPWR _5834_/X sky130_fd_sc_hd__a211o_4
XFILLER_22_546 VGND VGND VPWR VPWR sky130_fd_sc_hd__fill_2
XTAP_TAPCELL_ROW_60_850 VGND VPWR sky130_fd_sc_hd__tapvpwrvgnd_1
X_5765_ _5765_/A _5791_/B VGND VGND VPWR VPWR _5783_/A sky130_fd_sc_hd__nand2_2
XTAP_TAPCELL_ROW_32_552 VGND VPWR sky130_fd_sc_hd__tapvpwrvgnd_1
X_5696_ _6123_/A _5778_/C VGND VGND VPWR VPWR _6124_/A sky130_fd_sc_hd__nand2_2
X_4716_ _5340_/A _5290_/C _5188_/C _5311_/A VGND VGND VPWR VPWR _4719_/A sky130_fd_sc_hd__and4_2
X_4647_ _4636_/C _5018_/B _4637_/A _4635_/Y VGND VGND VPWR VPWR _4648_/B sky130_fd_sc_hd__o2bb2a_2
XFILLER_1_406 VGND VGND VPWR VPWR sky130_fd_sc_hd__decap_3
X_6317_ _6310_/X _6316_/X _6317_/S VGND VGND VPWR VPWR _6317_/X sky130_fd_sc_hd__mux2_1
X_4578_ _4578_/A _4578_/B VGND VGND VPWR VPWR _4586_/A sky130_fd_sc_hd__xnor2_2
XFILLER_89_557 VGND VGND VPWR VPWR sky130_fd_sc_hd__decap_3
X_3529_ _3531_/B _3767_/A _3531_/A VGND VGND VPWR VPWR _3532_/A sky130_fd_sc_hd__o21a_2
XFILLER_76_207 VGND VGND VPWR VPWR sky130_fd_sc_hd__decap_3
XFILLER_89_579 VGND VGND VPWR VPWR sky130_fd_sc_hd__decap_3
X_6248_ _4646_/C _6248_/B VGND VGND VPWR VPWR _6793_/B sky130_fd_sc_hd__and2b_2
XFILLER_29_101 VGND VGND VPWR VPWR sky130_fd_sc_hd__decap_3
XFILLER_39_69 VGND VGND VPWR VPWR sky130_fd_sc_hd__decap_3
XFILLER_57_410 VGND VGND VPWR VPWR sky130_fd_sc_hd__decap_3
XFILLER_57_421 VGND VGND VPWR VPWR sky130_fd_sc_hd__fill_1
XFILLER_69_270 VGND VGND VPWR VPWR sky130_fd_sc_hd__decap_3
X_6179_ _6180_/A _6919_/B VGND VGND VPWR VPWR _6278_/A sky130_fd_sc_hd__and2_2
XFILLER_69_281 VGND VGND VPWR VPWR sky130_fd_sc_hd__decap_3
XTAP_TAPCELL_ROW_4_255 VGND VPWR sky130_fd_sc_hd__tapvpwrvgnd_1
XFILLER_55_35 VGND VGND VPWR VPWR sky130_fd_sc_hd__decap_3
XFILLER_57_465 VGND VGND VPWR VPWR sky130_fd_sc_hd__fill_1
XFILLER_57_476 VGND VGND VPWR VPWR sky130_fd_sc_hd__decap_3
XFILLER_72_413 VGND VGND VPWR VPWR sky130_fd_sc_hd__decap_3
XFILLER_84_251 VGND VGND VPWR VPWR sky130_fd_sc_hd__fill_1
XFILLER_84_262 VGND VGND VPWR VPWR sky130_fd_sc_hd__decap_3
XFILLER_29_189 VGND VGND VPWR VPWR sky130_fd_sc_hd__decap_3
XFILLER_44_126 VGND VGND VPWR VPWR sky130_fd_sc_hd__decap_3
XFILLER_55_57 VGND VGND VPWR VPWR sky130_fd_sc_hd__decap_3
XFILLER_72_424 VGND VGND VPWR VPWR sky130_fd_sc_hd__decap_3
XFILLER_72_446 VGND VGND VPWR VPWR sky130_fd_sc_hd__decap_3
XFILLER_25_340 VGND VGND VPWR VPWR sky130_fd_sc_hd__decap_3
XFILLER_25_373 VGND VGND VPWR VPWR sky130_fd_sc_hd__decap_3
XFILLER_40_321 VGND VGND VPWR VPWR sky130_fd_sc_hd__decap_3
XFILLER_40_354 VGND VGND VPWR VPWR sky130_fd_sc_hd__decap_3
XFILLER_9_528 VGND VGND VPWR VPWR sky130_fd_sc_hd__decap_3
XFILLER_4_200 VGND VGND VPWR VPWR sky130_fd_sc_hd__fill_1
Xrebuffer850 _6993_/B VGND VGND VPWR VPWR output89/A sky130_fd_sc_hd__buf_2
XTAP_TAPCELL_ROW_78_1034 VGND VPWR sky130_fd_sc_hd__tapvpwrvgnd_1
XFILLER_4_266 VGND VGND VPWR VPWR sky130_fd_sc_hd__decap_3
XFILLER_95_505 VGND VGND VPWR VPWR sky130_fd_sc_hd__decap_3
XFILLER_0_461 VGND VGND VPWR VPWR sky130_fd_sc_hd__decap_3
XFILLER_0_494 VGND VGND VPWR VPWR sky130_fd_sc_hd__decap_3
XFILLER_29_80 VGND VGND VPWR VPWR sky130_fd_sc_hd__decap_3
XFILLER_48_421 VGND VGND VPWR VPWR sky130_fd_sc_hd__decap_3
XFILLER_48_454 VGND VGND VPWR VPWR sky130_fd_sc_hd__decap_3
XTAP_TAPCELL_ROW_66_909 VGND VPWR sky130_fd_sc_hd__tapvpwrvgnd_1
XFILLER_75_273 VGND VGND VPWR VPWR sky130_fd_sc_hd__decap_3
XTAP_TAPCELL_ROW_89_1152 VGND VPWR sky130_fd_sc_hd__tapvpwrvgnd_1
XFILLER_63_424 VGND VGND VPWR VPWR sky130_fd_sc_hd__decap_3
XFILLER_75_284 VGND VGND VPWR VPWR sky130_fd_sc_hd__decap_3
XFILLER_90_221 VGND VGND VPWR VPWR sky130_fd_sc_hd__decap_3
XFILLER_63_479 VGND VGND VPWR VPWR sky130_fd_sc_hd__decap_3
XFILLER_90_265 VGND VGND VPWR VPWR sky130_fd_sc_hd__decap_3
XFILLER_16_362 VGND VGND VPWR VPWR sky130_fd_sc_hd__fill_2
XFILLER_90_287 VGND VGND VPWR VPWR sky130_fd_sc_hd__decap_3
XFILLER_90_298 VGND VGND VPWR VPWR sky130_fd_sc_hd__decap_3
XTAP_TAPCELL_ROW_74_997 VGND VPWR sky130_fd_sc_hd__tapvpwrvgnd_1
XTAP_TAPCELL_ROW_46_699 VGND VPWR sky130_fd_sc_hd__tapvpwrvgnd_1
X_3880_ _3880_/A _3880_/B _3880_/C VGND VGND VPWR VPWR _3881_/B sky130_fd_sc_hd__nor3_2
X_5550_ _5550_/A _5550_/B VGND VGND VPWR VPWR _5600_/A sky130_fd_sc_hd__xor2_2
X_5481_ _5481_/A _5481_/B VGND VGND VPWR VPWR _5550_/B sky130_fd_sc_hd__xnor2_2
X_4501_ _4435_/X _4500_/Y _4497_/B _4473_/Y VGND VGND VPWR VPWR _4501_/X sky130_fd_sc_hd__o211a_2
X_4432_ _4432_/A _4900_/B _4432_/C VGND VGND VPWR VPWR _4434_/A sky130_fd_sc_hd__and3_4
XFILLER_6_73 VGND VGND VPWR VPWR sky130_fd_sc_hd__decap_3
X_4363_ _4617_/A _4361_/C _4361_/D _4483_/A VGND VGND VPWR VPWR _4364_/C sky130_fd_sc_hd__a22oi_2
Xfanout529 wire532/A VGND VGND VPWR VPWR _4010_/B sky130_fd_sc_hd__clkdlybuf4s25_1
X_6102_ _6102_/A _6102_/B VGND VGND VPWR VPWR _6104_/B sky130_fd_sc_hd__nor2_2
X_4294_ _6085_/B _4822_/A _4420_/C _4538_/D VGND VGND VPWR VPWR _4294_/X sky130_fd_sc_hd__and4_2
XFILLER_98_365 VGND VGND VPWR VPWR sky130_fd_sc_hd__fill_1
XFILLER_98_343 VGND VGND VPWR VPWR sky130_fd_sc_hd__fill_2
XFILLER_100_315 VGND VGND VPWR VPWR sky130_fd_sc_hd__decap_3
XFILLER_58_218 VGND VGND VPWR VPWR sky130_fd_sc_hd__decap_3
XFILLER_86_549 VGND VGND VPWR VPWR sky130_fd_sc_hd__decap_3
X_6033_ _3930_/A _3930_/B _3929_/A VGND VGND VPWR VPWR _6035_/A sky130_fd_sc_hd__a21o_2
XFILLER_100_348 VGND VGND VPWR VPWR sky130_fd_sc_hd__decap_3
XFILLER_66_251 VGND VGND VPWR VPWR sky130_fd_sc_hd__fill_1
XTAP_TAPCELL_ROW_1_225 VGND VPWR sky130_fd_sc_hd__tapvpwrvgnd_1
XFILLER_94_560 VGND VGND VPWR VPWR sky130_fd_sc_hd__fill_2
XFILLER_54_424 VGND VGND VPWR VPWR sky130_fd_sc_hd__decap_3
XFILLER_94_582 VGND VGND VPWR VPWR sky130_fd_sc_hd__decap_3
X_6935_ _6935_/A _6935_/B VGND VGND VPWR VPWR _6935_/X sky130_fd_sc_hd__xor2_4
XFILLER_41_107 VGND VGND VPWR VPWR sky130_fd_sc_hd__decap_3
XFILLER_81_287 VGND VGND VPWR VPWR sky130_fd_sc_hd__decap_3
XFILLER_22_343 VGND VGND VPWR VPWR sky130_fd_sc_hd__decap_3
X_6866_ _6325_/X _6372_/B _6944_/B1 _6302_/X _6865_/X VGND VGND VPWR VPWR _6866_/X
+ sky130_fd_sc_hd__a221o_2
X_6797_ _6207_/A _6797_/A2 _6928_/A2 _6089_/B _6796_/Y VGND VGND VPWR VPWR _6797_/X
+ sky130_fd_sc_hd__o221a_2
X_5817_ _5817_/A _5817_/B VGND VGND VPWR VPWR _5817_/Y sky130_fd_sc_hd__nor2_4
XFILLER_41_37 VGND VGND VPWR VPWR sky130_fd_sc_hd__fill_1
X_5748_ _5748_/A _5748_/B VGND VGND VPWR VPWR _5755_/A sky130_fd_sc_hd__nand2_2
X_5679_ _5678_/B _5711_/B _5678_/D _5678_/A VGND VGND VPWR VPWR _5680_/D sky130_fd_sc_hd__a22o_2
XTAP_TAPCELL_ROW_9_314 VGND VPWR sky130_fd_sc_hd__tapvpwrvgnd_1
XFILLER_9_6 VGND VGND VPWR VPWR sky130_fd_sc_hd__decap_3
XFILLER_1_269 VGND VGND VPWR VPWR sky130_fd_sc_hd__decap_3
XFILLER_89_376 VGND VGND VPWR VPWR sky130_fd_sc_hd__decap_3
XFILLER_66_45 VGND VGND VPWR VPWR sky130_fd_sc_hd__decap_3
XFILLER_57_240 VGND VGND VPWR VPWR sky130_fd_sc_hd__decap_3
XFILLER_57_262 VGND VGND VPWR VPWR sky130_fd_sc_hd__decap_3
XFILLER_57_295 VGND VGND VPWR VPWR sky130_fd_sc_hd__decap_3
XFILLER_72_221 VGND VGND VPWR VPWR sky130_fd_sc_hd__decap_3
XFILLER_60_416 VGND VGND VPWR VPWR sky130_fd_sc_hd__decap_3
XFILLER_72_265 VGND VGND VPWR VPWR sky130_fd_sc_hd__decap_3
XFILLER_82_88 VGND VGND VPWR VPWR sky130_fd_sc_hd__decap_3
XTAP_TAPCELL_ROW_71_967 VGND VPWR sky130_fd_sc_hd__tapvpwrvgnd_1
XFILLER_15_60 VGND VGND VPWR VPWR sky130_fd_sc_hd__fill_1
XFILLER_15_82 VGND VGND VPWR VPWR sky130_fd_sc_hd__decap_3
XTAP_TAPCELL_ROW_43_669 VGND VPWR sky130_fd_sc_hd__tapvpwrvgnd_1
XFILLER_9_314 VGND VGND VPWR VPWR sky130_fd_sc_hd__decap_3
Xrebuffer691 fanout600/X VGND VGND VPWR VPWR _4725_/A sky130_fd_sc_hd__buf_2
Xrebuffer680 _5126_/X VGND VGND VPWR VPWR _5148_/C1 sky130_fd_sc_hd__buf_2
XFILLER_5_597 VGND VGND VPWR VPWR sky130_fd_sc_hd__fill_1
Xoutput70 _6998_/X VGND VGND VPWR VPWR overflow sky130_fd_sc_hd__buf_8
Xoutput92 output92/A VGND VGND VPWR VPWR result[29] sky130_fd_sc_hd__buf_8
Xoutput81 _6983_/A VGND VGND VPWR VPWR result[19] sky130_fd_sc_hd__clkbuf_2
XFILLER_95_302 VGND VGND VPWR VPWR sky130_fd_sc_hd__decap_3
XFILLER_95_335 VGND VGND VPWR VPWR sky130_fd_sc_hd__fill_1
XFILLER_48_251 VGND VGND VPWR VPWR sky130_fd_sc_hd__fill_1
XFILLER_83_519 VGND VGND VPWR VPWR sky130_fd_sc_hd__decap_3
XFILLER_48_295 VGND VGND VPWR VPWR sky130_fd_sc_hd__fill_2
XFILLER_63_221 VGND VGND VPWR VPWR sky130_fd_sc_hd__decap_3
XFILLER_63_243 VGND VGND VPWR VPWR sky130_fd_sc_hd__decap_3
XFILLER_91_541 VGND VGND VPWR VPWR sky130_fd_sc_hd__decap_3
XFILLER_23_129 VGND VGND VPWR VPWR sky130_fd_sc_hd__fill_1
XFILLER_63_276 VGND VGND VPWR VPWR sky130_fd_sc_hd__decap_3
XFILLER_63_287 VGND VGND VPWR VPWR sky130_fd_sc_hd__decap_3
X_4981_ _4978_/X _4981_/B VGND VGND VPWR VPWR _5072_/B sky130_fd_sc_hd__and2b_2
XFILLER_16_170 VGND VGND VPWR VPWR sky130_fd_sc_hd__decap_3
X_6720_ _6778_/B1 _6709_/Y _6719_/X VGND VGND VPWR VPWR _6720_/Y sky130_fd_sc_hd__o21ai_2
X_3932_ _3932_/A _3932_/B _3932_/C VGND VGND VPWR VPWR _3947_/B sky130_fd_sc_hd__and3_2
X_6651_ _6650_/A _6650_/B _6650_/C VGND VGND VPWR VPWR _6651_/Y sky130_fd_sc_hd__o21ai_2
X_3863_ _5965_/A _3861_/Y _3700_/Y _3702_/Y VGND VGND VPWR VPWR _3864_/B sky130_fd_sc_hd__o211a_2
X_6582_ _5810_/A _5810_/B _6982_/A2 VGND VGND VPWR VPWR _6582_/X sky130_fd_sc_hd__o21a_2
X_5602_ _5603_/A _5603_/B VGND VGND VPWR VPWR _5602_/X sky130_fd_sc_hd__and2b_2
XTAP_TAPCELL_ROW_14_360 VGND VPWR sky130_fd_sc_hd__tapvpwrvgnd_1
X_5533_ _5533_/A _5591_/A VGND VGND VPWR VPWR _5537_/A sky130_fd_sc_hd__and2_2
X_3794_ _3960_/A _3969_/B _3969_/D _5995_/B VGND VGND VPWR VPWR _3795_/B sky130_fd_sc_hd__a22oi_2
X_5464_ _5846_/A _5464_/B _5464_/C VGND VGND VPWR VPWR _5464_/X sky130_fd_sc_hd__or3_4
X_5395_ _5395_/A _5582_/B VGND VGND VPWR VPWR _5412_/B sky130_fd_sc_hd__nand2_2
X_4415_ _4398_/Y _4414_/X _4415_/B1 _4384_/X VGND VGND VPWR VPWR _4436_/A sky130_fd_sc_hd__a211o_4
Xfanout304 _5953_/A2 VGND VGND VPWR VPWR _3872_/B sky130_fd_sc_hd__clkdlybuf4s25_1
X_4346_ _4346_/A _4346_/B VGND VGND VPWR VPWR _4466_/B sky130_fd_sc_hd__nor2_2
XFILLER_59_505 VGND VGND VPWR VPWR sky130_fd_sc_hd__decap_3
XFILLER_59_538 VGND VGND VPWR VPWR sky130_fd_sc_hd__fill_2
Xfanout326 input48/X VGND VGND VPWR VPWR _6077_/A sky130_fd_sc_hd__clkdlybuf4s25_1
XFILLER_100_134 VGND VGND VPWR VPWR sky130_fd_sc_hd__decap_3
XFILLER_86_335 VGND VGND VPWR VPWR sky130_fd_sc_hd__decap_3
XFILLER_86_357 VGND VGND VPWR VPWR sky130_fd_sc_hd__decap_3
X_4277_ _4524_/B _4518_/B _4276_/B _4273_/X VGND VGND VPWR VPWR _4279_/B sky130_fd_sc_hd__a31o_2
XFILLER_27_402 VGND VGND VPWR VPWR sky130_fd_sc_hd__decap_3
XFILLER_39_240 VGND VGND VPWR VPWR sky130_fd_sc_hd__decap_3
XFILLER_86_368 VGND VGND VPWR VPWR sky130_fd_sc_hd__decap_3
X_6016_ _6016_/A _6016_/B _6016_/C _6016_/D VGND VGND VPWR VPWR _6017_/B sky130_fd_sc_hd__and4_2
XFILLER_39_284 VGND VGND VPWR VPWR sky130_fd_sc_hd__decap_3
XFILLER_67_593 VGND VGND VPWR VPWR sky130_fd_sc_hd__decap_3
XFILLER_36_59 VGND VGND VPWR VPWR sky130_fd_sc_hd__fill_2
XFILLER_94_390 VGND VGND VPWR VPWR sky130_fd_sc_hd__decap_3
XFILLER_42_427 VGND VGND VPWR VPWR sky130_fd_sc_hd__fill_2
XFILLER_54_298 VGND VGND VPWR VPWR sky130_fd_sc_hd__decap_3
X_6918_ _6971_/B _6903_/Y _6919_/C _6917_/Y VGND VGND VPWR VPWR _6993_/B sky130_fd_sc_hd__a31o_4
X_6849_ _6712_/X _6944_/B1 _6848_/X _6372_/B _6846_/X VGND VGND VPWR VPWR _6854_/A
+ sky130_fd_sc_hd__a221o_2
XFILLER_10_324 VGND VGND VPWR VPWR sky130_fd_sc_hd__fill_1
XFILLER_10_335 VGND VGND VPWR VPWR sky130_fd_sc_hd__decap_3
XFILLER_22_162 VGND VGND VPWR VPWR sky130_fd_sc_hd__fill_1
XFILLER_22_184 VGND VGND VPWR VPWR sky130_fd_sc_hd__decap_3
XTAP_TAPCELL_ROW_40_639 VGND VPWR sky130_fd_sc_hd__tapvpwrvgnd_1
XFILLER_10_368 VGND VGND VPWR VPWR sky130_fd_sc_hd__fill_2
XFILLER_6_306 VGND VGND VPWR VPWR sky130_fd_sc_hd__fill_2
XTAP_TAPCELL_ROW_75_1004 VGND VPWR sky130_fd_sc_hd__tapvpwrvgnd_1
XFILLER_2_512 VGND VGND VPWR VPWR sky130_fd_sc_hd__fill_1
XFILLER_7_3 VGND VGND VPWR VPWR sky130_fd_sc_hd__decap_3
XFILLER_2_589 VGND VGND VPWR VPWR sky130_fd_sc_hd__decap_3
XFILLER_77_302 VGND VGND VPWR VPWR sky130_fd_sc_hd__decap_3
XFILLER_77_335 VGND VGND VPWR VPWR sky130_fd_sc_hd__fill_1
XFILLER_92_305 VGND VGND VPWR VPWR sky130_fd_sc_hd__decap_3
XTAP_TAPCELL_ROW_48_717 VGND VPWR sky130_fd_sc_hd__tapvpwrvgnd_1
XFILLER_18_424 VGND VGND VPWR VPWR sky130_fd_sc_hd__fill_2
XFILLER_18_435 VGND VGND VPWR VPWR sky130_fd_sc_hd__decap_3
XFILLER_92_338 VGND VGND VPWR VPWR sky130_fd_sc_hd__decap_3
XFILLER_73_552 VGND VGND VPWR VPWR sky130_fd_sc_hd__decap_3
XFILLER_85_390 VGND VGND VPWR VPWR sky130_fd_sc_hd__fill_2
XTAP_TAPCELL_ROW_86_1122 VGND VPWR sky130_fd_sc_hd__tapvpwrvgnd_1
XFILLER_33_405 VGND VGND VPWR VPWR sky130_fd_sc_hd__fill_1
XFILLER_33_449 VGND VGND VPWR VPWR sky130_fd_sc_hd__decap_3
XFILLER_60_246 VGND VGND VPWR VPWR sky130_fd_sc_hd__decap_3
XFILLER_13_162 VGND VGND VPWR VPWR sky130_fd_sc_hd__fill_2
XFILLER_9_122 VGND VGND VPWR VPWR sky130_fd_sc_hd__decap_3
XTAP_TAPCELL_ROW_11_330 VGND VPWR sky130_fd_sc_hd__tapvpwrvgnd_1
XTAP_TAPCELL_ROW_97_1240 VGND VPWR sky130_fd_sc_hd__tapvpwrvgnd_1
XFILLER_61_6 VGND VGND VPWR VPWR sky130_fd_sc_hd__decap_3
XFILLER_5_350 VGND VGND VPWR VPWR sky130_fd_sc_hd__decap_3
X_4200_ _4143_/Y _4195_/A _4201_/A _4199_/Y VGND VGND VPWR VPWR _4201_/B sky130_fd_sc_hd__a211oi_2
XFILLER_3_30 VGND VGND VPWR VPWR sky130_fd_sc_hd__fill_1
XFILLER_68_302 VGND VGND VPWR VPWR sky130_fd_sc_hd__decap_3
X_5180_ _5180_/A _5180_/B _5180_/C VGND VGND VPWR VPWR _5184_/A sky130_fd_sc_hd__nand3_2
X_4131_ _4132_/A _4132_/B _4132_/C VGND VGND VPWR VPWR _4135_/A sky130_fd_sc_hd__and3_2
XFILLER_95_121 VGND VGND VPWR VPWR sky130_fd_sc_hd__fill_2
XFILLER_56_508 VGND VGND VPWR VPWR sky130_fd_sc_hd__decap_3
XFILLER_68_357 VGND VGND VPWR VPWR sky130_fd_sc_hd__fill_1
XFILLER_83_305 VGND VGND VPWR VPWR sky130_fd_sc_hd__decap_3
X_4062_ _4051_/A _4051_/B _4051_/C VGND VGND VPWR VPWR _4072_/B sky130_fd_sc_hd__o21ai_2
XFILLER_49_571 VGND VGND VPWR VPWR sky130_fd_sc_hd__fill_1
XFILLER_49_582 VGND VGND VPWR VPWR sky130_fd_sc_hd__decap_3
XFILLER_95_187 VGND VGND VPWR VPWR sky130_fd_sc_hd__fill_1
XFILLER_51_202 VGND VGND VPWR VPWR sky130_fd_sc_hd__decap_3
XFILLER_91_382 VGND VGND VPWR VPWR sky130_fd_sc_hd__decap_3
X_4964_ _5275_/B _5311_/C _5054_/A _5382_/D VGND VGND VPWR VPWR _4967_/B sky130_fd_sc_hd__and4_2
X_6703_ _6242_/Y _6688_/X _6690_/X _6702_/X VGND VGND VPWR VPWR _6703_/X sky130_fd_sc_hd__o211a_2
X_3915_ _3915_/A VGND VGND VPWR VPWR _3918_/A sky130_fd_sc_hd__inv_2
X_4895_ _4531_/Y _4893_/X _4863_/X _4860_/Y VGND VGND VPWR VPWR _4903_/B sky130_fd_sc_hd__o211ai_2
X_6634_ _5720_/Y _5813_/X _6633_/Y VGND VGND VPWR VPWR _6634_/X sky130_fd_sc_hd__o21a_2
X_3846_ _4054_/A _4054_/B _4054_/C VGND VGND VPWR VPWR _4056_/A sky130_fd_sc_hd__o21a_2
X_6565_ _6231_/B _6231_/C _6381_/B VGND VGND VPWR VPWR _6566_/C sky130_fd_sc_hd__a21oi_2
X_3777_ _3778_/B _4178_/A _3778_/A VGND VGND VPWR VPWR _3779_/A sky130_fd_sc_hd__o21ai_2
X_6496_ _6589_/B _6731_/A _6354_/C _6493_/X VGND VGND VPWR VPWR _6496_/X sky130_fd_sc_hd__a31o_2
X_5516_ _5517_/C1 _5514_/Y _5515_/X _5517_/A1 VGND VGND VPWR VPWR _5516_/X sky130_fd_sc_hd__a211o_2
X_5447_ _5200_/Y _5215_/X _5214_/X _5207_/X VGND VGND VPWR VPWR _5448_/B sky130_fd_sc_hd__a211o_2
XFILLER_59_313 VGND VGND VPWR VPWR sky130_fd_sc_hd__decap_3
X_5378_ _5377_/A _5377_/B _5377_/C VGND VGND VPWR VPWR _5378_/Y sky130_fd_sc_hd__a21oi_2
XFILLER_86_121 VGND VGND VPWR VPWR sky130_fd_sc_hd__decap_3
Xfanout134 _6333_/X VGND VGND VPWR VPWR _6928_/A2 sky130_fd_sc_hd__clkdlybuf4s25_1
X_4329_ _4253_/B _4253_/C _4253_/D _4253_/A VGND VGND VPWR VPWR _4329_/X sky130_fd_sc_hd__a22o_2
XFILLER_47_508 VGND VGND VPWR VPWR sky130_fd_sc_hd__decap_3
XFILLER_59_379 VGND VGND VPWR VPWR sky130_fd_sc_hd__decap_3
Xfanout178 _3500_/Y VGND VGND VPWR VPWR _6589_/A sky130_fd_sc_hd__clkdlybuf4s25_1
XFILLER_47_69 VGND VGND VPWR VPWR sky130_fd_sc_hd__fill_2
XFILLER_82_371 VGND VGND VPWR VPWR sky130_fd_sc_hd__decap_3
XFILLER_15_449 VGND VGND VPWR VPWR sky130_fd_sc_hd__decap_3
XFILLER_63_57 VGND VGND VPWR VPWR sky130_fd_sc_hd__decap_3
XFILLER_70_533 VGND VGND VPWR VPWR sky130_fd_sc_hd__fill_1
XFILLER_70_544 VGND VGND VPWR VPWR sky130_fd_sc_hd__decap_3
XTAP_TAPCELL_ROW_53_775 VGND VPWR sky130_fd_sc_hd__tapvpwrvgnd_1
XFILLER_23_460 VGND VGND VPWR VPWR sky130_fd_sc_hd__decap_3
XTAP_TAPCELL_ROW_81_1063 VGND VPWR sky130_fd_sc_hd__tapvpwrvgnd_1
XTAP_TAPCELL_ROW_25_477 VGND VPWR sky130_fd_sc_hd__tapvpwrvgnd_1
XFILLER_6_114 VGND VGND VPWR VPWR sky130_fd_sc_hd__decap_3
Xwire557 wire557/A VGND VGND VPWR VPWR _5993_/B sky130_fd_sc_hd__buf_4
XFILLER_10_187 VGND VGND VPWR VPWR sky130_fd_sc_hd__fill_1
XFILLER_6_158 VGND VGND VPWR VPWR sky130_fd_sc_hd__decap_3
XFILLER_88_65 VGND VGND VPWR VPWR sky130_fd_sc_hd__decap_3
Xload_slew518 _3585_/A VGND VGND VPWR VPWR _3977_/A sky130_fd_sc_hd__buf_2
XTAP_TAPCELL_ROW_92_1181 VGND VPWR sky130_fd_sc_hd__tapvpwrvgnd_1
XFILLER_65_327 VGND VGND VPWR VPWR sky130_fd_sc_hd__decap_3
XFILLER_65_349 VGND VGND VPWR VPWR sky130_fd_sc_hd__decap_3
XFILLER_33_202 VGND VGND VPWR VPWR sky130_fd_sc_hd__decap_3
XFILLER_37_80 VGND VGND VPWR VPWR sky130_fd_sc_hd__decap_3
XFILLER_61_533 VGND VGND VPWR VPWR sky130_fd_sc_hd__decap_3
XFILLER_73_382 VGND VGND VPWR VPWR sky130_fd_sc_hd__decap_3
XFILLER_33_246 VGND VGND VPWR VPWR sky130_fd_sc_hd__decap_3
X_3700_ _3701_/A _3701_/B VGND VGND VPWR VPWR _3700_/Y sky130_fd_sc_hd__nand2b_2
X_4680_ _4680_/A1 _4644_/Y _4678_/A _4677_/Y VGND VGND VPWR VPWR _4681_/A sky130_fd_sc_hd__a211oi_2
X_3631_ _3631_/A _3631_/B VGND VGND VPWR VPWR _3632_/B sky130_fd_sc_hd__xnor2_2
X_6350_ _6730_/A _6350_/B VGND VGND VPWR VPWR _6350_/X sky130_fd_sc_hd__and2_2
X_3562_ _3562_/A _3562_/B VGND VGND VPWR VPWR _3563_/B sky130_fd_sc_hd__and2_2
X_5301_ _5300_/B _5321_/C _5321_/D _5341_/A VGND VGND VPWR VPWR _5302_/B sky130_fd_sc_hd__a22o_2
X_6281_ _6931_/A _6904_/A _6890_/A _6273_/B _6279_/X VGND VGND VPWR VPWR _6932_/A
+ sky130_fd_sc_hd__a41o_2
X_3493_ _6102_/B VGND VGND VPWR VPWR _3493_/Y sky130_fd_sc_hd__inv_2
X_5232_ _5286_/A _5284_/B _5453_/B _5229_/X VGND VGND VPWR VPWR _5234_/B sky130_fd_sc_hd__a31o_2
XFILLER_68_121 VGND VGND VPWR VPWR sky130_fd_sc_hd__decap_3
X_5163_ _5163_/A _5163_/B VGND VGND VPWR VPWR _5164_/C sky130_fd_sc_hd__xnor2_2
XFILLER_96_430 VGND VGND VPWR VPWR sky130_fd_sc_hd__fill_2
XFILLER_29_519 VGND VGND VPWR VPWR sky130_fd_sc_hd__decap_3
XFILLER_56_305 VGND VGND VPWR VPWR sky130_fd_sc_hd__decap_3
X_4114_ _4106_/B _4109_/B _4112_/X _3675_/A VGND VGND VPWR VPWR _4114_/Y sky130_fd_sc_hd__a211oi_2
XFILLER_96_463 VGND VGND VPWR VPWR sky130_fd_sc_hd__decap_3
XFILLER_68_176 VGND VGND VPWR VPWR sky130_fd_sc_hd__decap_3
X_5094_ _5000_/Y _5001_/X _4994_/Y _4998_/C VGND VGND VPWR VPWR _5094_/X sky130_fd_sc_hd__o211a_2
XFILLER_83_146 VGND VGND VPWR VPWR sky130_fd_sc_hd__decap_3
X_4045_ _3996_/B _5993_/A _6178_/A _3955_/A VGND VGND VPWR VPWR _4046_/C sky130_fd_sc_hd__a22o_2
XFILLER_64_360 VGND VGND VPWR VPWR sky130_fd_sc_hd__decap_3
XFILLER_71_308 VGND VGND VPWR VPWR sky130_fd_sc_hd__decap_3
XFILLER_24_224 VGND VGND VPWR VPWR sky130_fd_sc_hd__decap_3
XFILLER_52_533 VGND VGND VPWR VPWR sky130_fd_sc_hd__decap_3
XFILLER_91_190 VGND VGND VPWR VPWR sky130_fd_sc_hd__decap_3
X_5996_ _5996_/A _5996_/B VGND VGND VPWR VPWR _5997_/B sky130_fd_sc_hd__xor2_2
X_4947_ _4947_/A _4947_/B _4947_/C VGND VGND VPWR VPWR _5038_/A sky130_fd_sc_hd__or3_4
XFILLER_20_441 VGND VGND VPWR VPWR sky130_fd_sc_hd__decap_3
X_4878_ _4879_/B1 _4834_/Y _4876_/Y _4877_/X VGND VGND VPWR VPWR _4878_/Y sky130_fd_sc_hd__o211ai_2
XTAP_TAPCELL_ROW_50_745 VGND VPWR sky130_fd_sc_hd__tapvpwrvgnd_1
XTAP_TAPCELL_ROW_22_447 VGND VPWR sky130_fd_sc_hd__tapvpwrvgnd_1
X_6617_ _6383_/D _6235_/Y _6616_/Y VGND VGND VPWR VPWR _6632_/B sky130_fd_sc_hd__o21a_2
X_3829_ _6019_/B _6014_/A _3830_/A VGND VGND VPWR VPWR _3938_/B sky130_fd_sc_hd__and3_2
X_6548_ _6402_/S _6420_/B _6698_/B VGND VGND VPWR VPWR _6700_/B sky130_fd_sc_hd__a21oi_2
X_6479_ _6621_/A3 _6621_/A2 _6621_/A1 _6236_/B _6439_/B _6478_/S VGND VGND VPWR VPWR
+ _6479_/X sky130_fd_sc_hd__mux4_2
XFILLER_79_408 VGND VGND VPWR VPWR sky130_fd_sc_hd__decap_3
XFILLER_59_110 VGND VGND VPWR VPWR sky130_fd_sc_hd__fill_2
XFILLER_58_57 VGND VGND VPWR VPWR sky130_fd_sc_hd__decap_3
XFILLER_87_463 VGND VGND VPWR VPWR sky130_fd_sc_hd__decap_3
XFILLER_74_102 VGND VGND VPWR VPWR sky130_fd_sc_hd__fill_1
XTAP_TAPCELL_ROW_58_823 VGND VPWR sky130_fd_sc_hd__tapvpwrvgnd_1
XFILLER_74_23 VGND VGND VPWR VPWR sky130_fd_sc_hd__decap_3
XFILLER_74_168 VGND VGND VPWR VPWR sky130_fd_sc_hd__decap_3
XFILLER_74_56 VGND VGND VPWR VPWR sky130_fd_sc_hd__decap_3
XFILLER_55_393 VGND VGND VPWR VPWR sky130_fd_sc_hd__decap_3
XFILLER_43_555 VGND VGND VPWR VPWR sky130_fd_sc_hd__decap_3
XFILLER_15_279 VGND VGND VPWR VPWR sky130_fd_sc_hd__fill_1
XFILLER_30_227 VGND VGND VPWR VPWR sky130_fd_sc_hd__decap_3
XFILLER_70_385 VGND VGND VPWR VPWR sky130_fd_sc_hd__decap_3
XFILLER_23_290 VGND VGND VPWR VPWR sky130_fd_sc_hd__decap_3
XFILLER_30_249 VGND VGND VPWR VPWR sky130_fd_sc_hd__decap_3
XFILLER_90_88 VGND VGND VPWR VPWR sky130_fd_sc_hd__fill_1
XFILLER_11_463 VGND VGND VPWR VPWR sky130_fd_sc_hd__fill_2
XFILLER_23_60 VGND VGND VPWR VPWR sky130_fd_sc_hd__decap_3
XFILLER_7_401 VGND VGND VPWR VPWR sky130_fd_sc_hd__decap_3
XFILLER_90_99 VGND VGND VPWR VPWR sky130_fd_sc_hd__decap_3
XFILLER_11_485 VGND VGND VPWR VPWR sky130_fd_sc_hd__fill_2
XFILLER_7_445 VGND VGND VPWR VPWR sky130_fd_sc_hd__decap_3
XFILLER_99_97 VGND VGND VPWR VPWR sky130_fd_sc_hd__decap_3
XFILLER_2_172 VGND VGND VPWR VPWR sky130_fd_sc_hd__decap_3
Xload_slew337 _3551_/B1 VGND VGND VPWR VPWR _3969_/D sky130_fd_sc_hd__clkbuf_4
XFILLER_97_249 VGND VGND VPWR VPWR sky130_fd_sc_hd__decap_3
XFILLER_97_238 VGND VGND VPWR VPWR sky130_fd_sc_hd__fill_1
XFILLER_24_6 VGND VGND VPWR VPWR sky130_fd_sc_hd__fill_2
Xload_slew359 _6125_/B VGND VGND VPWR VPWR _5727_/B sky130_fd_sc_hd__buf_2
Xload_slew348 _5282_/B VGND VGND VPWR VPWR _5284_/B sky130_fd_sc_hd__clkbuf_4
XFILLER_38_305 VGND VGND VPWR VPWR sky130_fd_sc_hd__decap_3
XFILLER_65_102 VGND VGND VPWR VPWR sky130_fd_sc_hd__decap_3
XFILLER_78_496 VGND VGND VPWR VPWR sky130_fd_sc_hd__decap_3
XFILLER_93_411 VGND VGND VPWR VPWR sky130_fd_sc_hd__decap_3
XFILLER_93_455 VGND VGND VPWR VPWR sky130_fd_sc_hd__decap_3
XFILLER_93_488 VGND VGND VPWR VPWR sky130_fd_sc_hd__decap_3
XFILLER_0_64 VGND VGND VPWR VPWR sky130_fd_sc_hd__decap_3
XFILLER_34_511 VGND VGND VPWR VPWR sky130_fd_sc_hd__fill_1
XFILLER_34_533 VGND VGND VPWR VPWR sky130_fd_sc_hd__decap_3
XFILLER_80_116 VGND VGND VPWR VPWR sky130_fd_sc_hd__decap_3
X_5850_ _5848_/A _5848_/Y _5849_/Y _5834_/X VGND VGND VPWR VPWR _5850_/X sky130_fd_sc_hd__o211a_4
XFILLER_61_396 VGND VGND VPWR VPWR sky130_fd_sc_hd__fill_1
X_5781_ _5792_/A _5792_/B VGND VGND VPWR VPWR _5793_/A sky130_fd_sc_hd__nor2_2
X_4801_ _6248_/B _4782_/B _4977_/B _4798_/X VGND VGND VPWR VPWR _4803_/B sky130_fd_sc_hd__a31o_2
X_4732_ _5502_/A _5151_/B _4755_/C _4755_/D VGND VGND VPWR VPWR _4735_/B sky130_fd_sc_hd__and4_2
X_4663_ _4662_/A _4662_/C _4662_/D _4662_/B VGND VGND VPWR VPWR _4664_/B sky130_fd_sc_hd__a22o_2
X_6402_ _6093_/B _6089_/B _6402_/S VGND VGND VPWR VPWR _6402_/X sky130_fd_sc_hd__mux2_1
X_3614_ _3614_/A _6014_/C VGND VGND VPWR VPWR _3618_/A sky130_fd_sc_hd__nand2_2
X_4594_ _4593_/B _4593_/C _4593_/D wire590/X VGND VGND VPWR VPWR _4595_/B sky130_fd_sc_hd__a22o_2
X_6333_ _6342_/A _6336_/A _6338_/B VGND VGND VPWR VPWR _6333_/X sky130_fd_sc_hd__or3b_2
X_3545_ _3797_/A VGND VGND VPWR VPWR _3545_/Y sky130_fd_sc_hd__inv_2
X_6264_ _6264_/A _6264_/B VGND VGND VPWR VPWR _6860_/B sky130_fd_sc_hd__nor2_2
XFILLER_88_227 VGND VGND VPWR VPWR sky130_fd_sc_hd__decap_3
X_5215_ _5200_/A _5200_/C _5200_/B VGND VGND VPWR VPWR _5215_/X sky130_fd_sc_hd__a21o_4
X_6195_ _6191_/X _6194_/X _6348_/C VGND VGND VPWR VPWR _6936_/A sky130_fd_sc_hd__a21o_2
XFILLER_28_38 VGND VGND VPWR VPWR sky130_fd_sc_hd__decap_3
XFILLER_84_411 VGND VGND VPWR VPWR sky130_fd_sc_hd__decap_3
X_5146_ _5148_/C1 _5220_/A1 _5145_/Y _5147_/C1 VGND VGND VPWR VPWR _5146_/X sky130_fd_sc_hd__o211a_2
XFILLER_56_124 VGND VGND VPWR VPWR sky130_fd_sc_hd__fill_2
XFILLER_84_433 VGND VGND VPWR VPWR sky130_fd_sc_hd__decap_3
X_5077_ _5078_/A _5078_/B VGND VGND VPWR VPWR _5077_/Y sky130_fd_sc_hd__nand2_2
XFILLER_84_466 VGND VGND VPWR VPWR sky130_fd_sc_hd__decap_3
XFILLER_84_477 VGND VGND VPWR VPWR sky130_fd_sc_hd__decap_3
X_4028_ _4028_/A _4028_/B VGND VGND VPWR VPWR _4029_/B sky130_fd_sc_hd__nor2_2
XFILLER_37_393 VGND VGND VPWR VPWR sky130_fd_sc_hd__fill_2
XFILLER_25_555 VGND VGND VPWR VPWR sky130_fd_sc_hd__decap_3
XFILLER_25_577 VGND VGND VPWR VPWR sky130_fd_sc_hd__fill_1
XFILLER_52_341 VGND VGND VPWR VPWR sky130_fd_sc_hd__decap_3
XFILLER_40_503 VGND VGND VPWR VPWR sky130_fd_sc_hd__decap_3
XFILLER_52_374 VGND VGND VPWR VPWR sky130_fd_sc_hd__decap_3
X_5979_ _5979_/A _5979_/B VGND VGND VPWR VPWR _5987_/A sky130_fd_sc_hd__xnor2_2
XTAP_TAPCELL_ROW_63_881 VGND VPWR sky130_fd_sc_hd__tapvpwrvgnd_1
XTAP_TAPCELL_ROW_35_583 VGND VPWR sky130_fd_sc_hd__tapvpwrvgnd_1
XFILLER_100_54 VGND VGND VPWR VPWR sky130_fd_sc_hd__fill_2
XFILLER_40_547 VGND VGND VPWR VPWR sky130_fd_sc_hd__decap_3
XFILLER_60_58 VGND VGND VPWR VPWR sky130_fd_sc_hd__fill_1
XFILLER_47_102 VGND VGND VPWR VPWR sky130_fd_sc_hd__decap_3
XFILLER_75_422 VGND VGND VPWR VPWR sky130_fd_sc_hd__fill_1
XTAP_TAPCELL_ROW_7_286 VGND VPWR sky130_fd_sc_hd__tapvpwrvgnd_1
XFILLER_94_219 VGND VGND VPWR VPWR sky130_fd_sc_hd__decap_3
XFILLER_47_146 VGND VGND VPWR VPWR sky130_fd_sc_hd__fill_1
XFILLER_75_444 VGND VGND VPWR VPWR sky130_fd_sc_hd__decap_3
XFILLER_85_55 VGND VGND VPWR VPWR sky130_fd_sc_hd__fill_1
XFILLER_85_66 VGND VGND VPWR VPWR sky130_fd_sc_hd__decap_3
XFILLER_75_488 VGND VGND VPWR VPWR sky130_fd_sc_hd__decap_3
XFILLER_85_99 VGND VGND VPWR VPWR sky130_fd_sc_hd__decap_3
XFILLER_16_533 VGND VGND VPWR VPWR sky130_fd_sc_hd__decap_3
XFILLER_28_382 VGND VGND VPWR VPWR sky130_fd_sc_hd__decap_3
XFILLER_90_447 VGND VGND VPWR VPWR sky130_fd_sc_hd__decap_3
XFILLER_31_514 VGND VGND VPWR VPWR sky130_fd_sc_hd__fill_1
XFILLER_70_171 VGND VGND VPWR VPWR sky130_fd_sc_hd__decap_3
XFILLER_43_396 VGND VGND VPWR VPWR sky130_fd_sc_hd__fill_1
XFILLER_93_9 VGND VGND VPWR VPWR sky130_fd_sc_hd__fill_2
Xwire162 _6202_/Y VGND VGND VPWR VPWR wire162/X sky130_fd_sc_hd__clkdlybuf4s25_1
XFILLER_100_508 VGND VGND VPWR VPWR sky130_fd_sc_hd__decap_3
X_5000_ _4998_/A _4998_/Y _4999_/X _5001_/A1 VGND VGND VPWR VPWR _5000_/Y sky130_fd_sc_hd__a211oi_4
XFILLER_22_3 VGND VGND VPWR VPWR sky130_fd_sc_hd__decap_3
XFILLER_85_208 VGND VGND VPWR VPWR sky130_fd_sc_hd__fill_1
Xload_slew189 _4526_/A VGND VGND VPWR VPWR _4406_/B sky130_fd_sc_hd__clkbuf_4
Xload_slew167 _6493_/A VGND VGND VPWR VPWR _6761_/S sky130_fd_sc_hd__buf_2
XFILLER_66_455 VGND VGND VPWR VPWR sky130_fd_sc_hd__decap_3
XFILLER_78_282 VGND VGND VPWR VPWR sky130_fd_sc_hd__decap_3
XFILLER_66_477 VGND VGND VPWR VPWR sky130_fd_sc_hd__decap_3
XFILLER_93_263 VGND VGND VPWR VPWR sky130_fd_sc_hd__decap_3
XFILLER_19_360 VGND VGND VPWR VPWR sky130_fd_sc_hd__decap_3
XFILLER_19_393 VGND VGND VPWR VPWR sky130_fd_sc_hd__fill_2
XFILLER_81_447 VGND VGND VPWR VPWR sky130_fd_sc_hd__fill_1
XFILLER_93_296 VGND VGND VPWR VPWR sky130_fd_sc_hd__decap_3
X_6951_ _6951_/A _6951_/B _6951_/C VGND VGND VPWR VPWR _6952_/A sky130_fd_sc_hd__and3_4
XFILLER_53_149 VGND VGND VPWR VPWR sky130_fd_sc_hd__decap_3
XFILLER_81_458 VGND VGND VPWR VPWR sky130_fd_sc_hd__fill_1
X_6882_ _6746_/B _6767_/Y _6881_/X VGND VGND VPWR VPWR _6882_/Y sky130_fd_sc_hd__a21oi_2
X_5902_ _5931_/A _5900_/Y _4550_/A _4551_/X VGND VGND VPWR VPWR _5902_/X sky130_fd_sc_hd__a211o_2
XFILLER_22_525 VGND VGND VPWR VPWR sky130_fd_sc_hd__decap_3
XFILLER_34_374 VGND VGND VPWR VPWR sky130_fd_sc_hd__decap_3
X_5833_ _5849_/B1 _5830_/C _5831_/Y _5832_/X VGND VGND VPWR VPWR _5833_/Y sky130_fd_sc_hd__a211oi_2
XFILLER_22_558 VGND VGND VPWR VPWR sky130_fd_sc_hd__decap_3
XFILLER_34_396 VGND VGND VPWR VPWR sky130_fd_sc_hd__decap_3
X_5764_ _5766_/A _5775_/A VGND VGND VPWR VPWR _5767_/A sky130_fd_sc_hd__nand2_2
XTAP_TAPCELL_ROW_60_851 VGND VPWR sky130_fd_sc_hd__tapvpwrvgnd_1
XTAP_TAPCELL_ROW_32_553 VGND VPWR sky130_fd_sc_hd__tapvpwrvgnd_1
X_5695_ _5695_/A _5778_/B _5695_/C _5725_/C VGND VGND VPWR VPWR _5698_/A sky130_fd_sc_hd__and4_2
X_4715_ _4715_/A1 _4714_/C _4942_/A VGND VGND VPWR VPWR _4834_/B sky130_fd_sc_hd__a21boi_2
X_4646_ _4925_/A _4925_/B _4646_/C _4646_/D VGND VGND VPWR VPWR _5014_/A sky130_fd_sc_hd__and4_2
X_4577_ _4577_/A _4577_/B VGND VGND VPWR VPWR _4590_/A sky130_fd_sc_hd__xnor2_2
X_6316_ _6731_/A _3867_/A _3868_/A _3872_/A _6319_/S _3868_/B VGND VGND VPWR VPWR
+ _6316_/X sky130_fd_sc_hd__mux4_2
XFILLER_89_525 VGND VGND VPWR VPWR sky130_fd_sc_hd__decap_3
X_3528_ _4176_/A _6893_/S _3528_/C VGND VGND VPWR VPWR _3767_/A sky130_fd_sc_hd__and3_2
X_6247_ _6247_/A _6247_/B VGND VGND VPWR VPWR _6255_/C sky130_fd_sc_hd__and2_2
X_6178_ _6178_/A _6275_/B VGND VGND VPWR VPWR _6919_/B sky130_fd_sc_hd__nand2_2
XFILLER_29_113 VGND VGND VPWR VPWR sky130_fd_sc_hd__decap_3
XFILLER_69_293 VGND VGND VPWR VPWR sky130_fd_sc_hd__decap_3
X_5129_ _5340_/A _5341_/C _5341_/D _5311_/A VGND VGND VPWR VPWR _5130_/B sky130_fd_sc_hd__a22o_2
XTAP_TAPCELL_ROW_4_256 VGND VPWR sky130_fd_sc_hd__tapvpwrvgnd_1
XFILLER_17_319 VGND VGND VPWR VPWR sky130_fd_sc_hd__fill_2
XFILLER_29_157 VGND VGND VPWR VPWR sky130_fd_sc_hd__decap_3
XFILLER_57_488 VGND VGND VPWR VPWR sky130_fd_sc_hd__decap_3
XFILLER_44_138 VGND VGND VPWR VPWR sky130_fd_sc_hd__fill_2
XFILLER_55_69 VGND VGND VPWR VPWR sky130_fd_sc_hd__decap_3
XFILLER_84_274 VGND VGND VPWR VPWR sky130_fd_sc_hd__decap_3
XFILLER_25_352 VGND VGND VPWR VPWR sky130_fd_sc_hd__decap_3
XFILLER_80_480 VGND VGND VPWR VPWR sky130_fd_sc_hd__decap_3
XFILLER_13_547 VGND VGND VPWR VPWR sky130_fd_sc_hd__decap_3
XFILLER_25_396 VGND VGND VPWR VPWR sky130_fd_sc_hd__fill_2
XFILLER_71_57 VGND VGND VPWR VPWR sky130_fd_sc_hd__decap_3
XTAP_TAPCELL_ROW_78_1035 VGND VPWR sky130_fd_sc_hd__tapvpwrvgnd_1
XFILLER_4_212 VGND VGND VPWR VPWR sky130_fd_sc_hd__decap_3
XFILLER_4_234 VGND VGND VPWR VPWR sky130_fd_sc_hd__decap_3
XFILLER_4_278 VGND VGND VPWR VPWR sky130_fd_sc_hd__decap_3
XFILLER_0_473 VGND VGND VPWR VPWR sky130_fd_sc_hd__decap_3
XFILLER_95_517 VGND VGND VPWR VPWR sky130_fd_sc_hd__fill_1
XFILLER_48_433 VGND VGND VPWR VPWR sky130_fd_sc_hd__fill_1
XFILLER_29_92 VGND VGND VPWR VPWR sky130_fd_sc_hd__decap_3
XTAP_TAPCELL_ROW_89_1153 VGND VPWR sky130_fd_sc_hd__tapvpwrvgnd_1
XFILLER_75_296 VGND VGND VPWR VPWR sky130_fd_sc_hd__decap_3
XFILLER_90_200 VGND VGND VPWR VPWR sky130_fd_sc_hd__fill_1
XFILLER_16_341 VGND VGND VPWR VPWR sky130_fd_sc_hd__decap_3
XTAP_TAPCELL_ROW_74_998 VGND VPWR sky130_fd_sc_hd__tapvpwrvgnd_1
XFILLER_16_396 VGND VGND VPWR VPWR sky130_fd_sc_hd__decap_3
XFILLER_31_333 VGND VGND VPWR VPWR sky130_fd_sc_hd__decap_3
XFILLER_31_388 VGND VGND VPWR VPWR sky130_fd_sc_hd__decap_3
XFILLER_8_562 VGND VGND VPWR VPWR sky130_fd_sc_hd__decap_3
X_5480_ _5477_/A _5576_/D _5479_/B _5476_/X VGND VGND VPWR VPWR _5550_/A sky130_fd_sc_hd__a31o_2
X_4500_ _4436_/A _4436_/B _4436_/C VGND VGND VPWR VPWR _4500_/Y sky130_fd_sc_hd__a21oi_2
XANTENNA_1 input12/X VGND VGND VPWR VPWR sky130_fd_sc_hd__diode_2
X_4431_ _4431_/A _4431_/B VGND VGND VPWR VPWR _4432_/C sky130_fd_sc_hd__xnor2_2
X_4362_ _4362_/A _4362_/B VGND VGND VPWR VPWR _4364_/B sky130_fd_sc_hd__nand2_2
XFILLER_98_300 VGND VGND VPWR VPWR sky130_fd_sc_hd__fill_1
Xfanout508 input30/X VGND VGND VPWR VPWR _4607_/A sky130_fd_sc_hd__buf_4
Xfanout519 input3/X VGND VGND VPWR VPWR _5976_/B sky130_fd_sc_hd__dlymetal6s2s_1
X_6101_ _6758_/A _6748_/A VGND VGND VPWR VPWR _6255_/A sky130_fd_sc_hd__nand2_2
X_4293_ _6263_/B _4539_/B _4184_/A _4182_/Y VGND VGND VPWR VPWR _4299_/B sky130_fd_sc_hd__o2bb2a_2
XFILLER_100_305 VGND VGND VPWR VPWR sky130_fd_sc_hd__decap_3
X_6032_ _6032_/A _6032_/B VGND VGND VPWR VPWR _6036_/A sky130_fd_sc_hd__xnor2_2
XFILLER_100_327 VGND VGND VPWR VPWR sky130_fd_sc_hd__decap_3
XFILLER_39_444 VGND VGND VPWR VPWR sky130_fd_sc_hd__decap_3
XFILLER_79_591 VGND VGND VPWR VPWR sky130_fd_sc_hd__decap_3
XFILLER_39_455 VGND VGND VPWR VPWR sky130_fd_sc_hd__decap_3
XFILLER_54_403 VGND VGND VPWR VPWR sky130_fd_sc_hd__decap_3
XFILLER_66_230 VGND VGND VPWR VPWR sky130_fd_sc_hd__decap_3
XFILLER_26_116 VGND VGND VPWR VPWR sky130_fd_sc_hd__fill_2
XFILLER_39_499 VGND VGND VPWR VPWR sky130_fd_sc_hd__decap_3
XFILLER_54_436 VGND VGND VPWR VPWR sky130_fd_sc_hd__decap_3
XFILLER_81_211 VGND VGND VPWR VPWR sky130_fd_sc_hd__decap_3
XTAP_TAPCELL_ROW_37_601 VGND VPWR sky130_fd_sc_hd__tapvpwrvgnd_1
XTAP_TAPCELL_ROW_1_226 VGND VPWR sky130_fd_sc_hd__tapvpwrvgnd_1
XFILLER_94_594 VGND VGND VPWR VPWR sky130_fd_sc_hd__decap_3
XFILLER_19_190 VGND VGND VPWR VPWR sky130_fd_sc_hd__decap_3
XFILLER_26_138 VGND VGND VPWR VPWR sky130_fd_sc_hd__fill_2
X_6934_ _6934_/A _6934_/B _6933_/X VGND VGND VPWR VPWR _6995_/B sky130_fd_sc_hd__or3b_4
XFILLER_81_299 VGND VGND VPWR VPWR sky130_fd_sc_hd__decap_3
XFILLER_34_171 VGND VGND VPWR VPWR sky130_fd_sc_hd__decap_3
X_6865_ _6929_/A _6960_/A _6307_/X _6930_/A _6864_/Y VGND VGND VPWR VPWR _6865_/X
+ sky130_fd_sc_hd__a311o_2
XFILLER_22_355 VGND VGND VPWR VPWR sky130_fd_sc_hd__decap_3
X_6796_ _6796_/A _6809_/B VGND VGND VPWR VPWR _6796_/Y sky130_fd_sc_hd__nand2_2
X_5816_ _5614_/Y _5617_/X _5647_/Y _5649_/Y VGND VGND VPWR VPWR _5817_/A sky130_fd_sc_hd__a211oi_2
XTAP_TAPCELL_ROW_17_391 VGND VPWR sky130_fd_sc_hd__tapvpwrvgnd_1
XFILLER_22_388 VGND VGND VPWR VPWR sky130_fd_sc_hd__decap_3
X_5747_ _5743_/A _5743_/C _5743_/B VGND VGND VPWR VPWR _5752_/B sky130_fd_sc_hd__o21ai_2
X_5678_ _5678_/A _5678_/B _5711_/B _5678_/D VGND VGND VPWR VPWR _5680_/C sky130_fd_sc_hd__nand4_2
X_4629_ _4457_/B _4628_/C _4646_/C _4925_/A VGND VGND VPWR VPWR _4629_/Y sky130_fd_sc_hd__a22oi_2
XTAP_TAPCELL_ROW_9_315 VGND VPWR sky130_fd_sc_hd__tapvpwrvgnd_1
XFILLER_1_204 VGND VGND VPWR VPWR sky130_fd_sc_hd__decap_3
XFILLER_89_311 VGND VGND VPWR VPWR sky130_fd_sc_hd__fill_1
XFILLER_1_237 VGND VGND VPWR VPWR sky130_fd_sc_hd__decap_3
XFILLER_89_366 VGND VGND VPWR VPWR sky130_fd_sc_hd__fill_1
XFILLER_66_13 VGND VGND VPWR VPWR sky130_fd_sc_hd__fill_1
XFILLER_66_24 VGND VGND VPWR VPWR sky130_fd_sc_hd__decap_3
XFILLER_66_79 VGND VGND VPWR VPWR sky130_fd_sc_hd__decap_3
XFILLER_85_561 VGND VGND VPWR VPWR sky130_fd_sc_hd__decap_3
XFILLER_17_116 VGND VGND VPWR VPWR sky130_fd_sc_hd__decap_3
XFILLER_45_414 VGND VGND VPWR VPWR sky130_fd_sc_hd__fill_1
XFILLER_57_274 VGND VGND VPWR VPWR sky130_fd_sc_hd__decap_3
XFILLER_72_200 VGND VGND VPWR VPWR sky130_fd_sc_hd__fill_1
XFILLER_85_594 VGND VGND VPWR VPWR sky130_fd_sc_hd__decap_3
XFILLER_45_458 VGND VGND VPWR VPWR sky130_fd_sc_hd__decap_3
XFILLER_72_244 VGND VGND VPWR VPWR sky130_fd_sc_hd__decap_3
XFILLER_82_23 VGND VGND VPWR VPWR sky130_fd_sc_hd__decap_3
XFILLER_72_288 VGND VGND VPWR VPWR sky130_fd_sc_hd__decap_3
XFILLER_82_56 VGND VGND VPWR VPWR sky130_fd_sc_hd__fill_1
XFILLER_60_439 VGND VGND VPWR VPWR sky130_fd_sc_hd__fill_2
XTAP_TAPCELL_ROW_84_1094 VGND VPWR sky130_fd_sc_hd__tapvpwrvgnd_1
XFILLER_13_344 VGND VGND VPWR VPWR sky130_fd_sc_hd__decap_3
XFILLER_13_399 VGND VGND VPWR VPWR sky130_fd_sc_hd__decap_3
XFILLER_40_174 VGND VGND VPWR VPWR sky130_fd_sc_hd__decap_3
XFILLER_9_359 VGND VGND VPWR VPWR sky130_fd_sc_hd__decap_3
XFILLER_9_337 VGND VGND VPWR VPWR sky130_fd_sc_hd__decap_3
Xrebuffer692 _5746_/X VGND VGND VPWR VPWR _6615_/A1 sky130_fd_sc_hd__buf_2
Xrebuffer681 _6705_/B1 VGND VGND VPWR VPWR _6706_/A2 sky130_fd_sc_hd__buf_2
XFILLER_99_108 VGND VGND VPWR VPWR sky130_fd_sc_hd__decap_3
XFILLER_68_517 VGND VGND VPWR VPWR sky130_fd_sc_hd__decap_3
XFILLER_68_539 VGND VGND VPWR VPWR sky130_fd_sc_hd__decap_3
Xoutput93 _6985_/B VGND VGND VPWR VPWR result[2] sky130_fd_sc_hd__clkdlybuf4s25_1
Xoutput82 _6985_/A VGND VGND VPWR VPWR result[1] sky130_fd_sc_hd__clkdlybuf4s25_1
Xoutput71 _6990_/A VGND VGND VPWR VPWR result[0] sky130_fd_sc_hd__dlymetal6s4s_1
XFILLER_0_281 VGND VGND VPWR VPWR sky130_fd_sc_hd__decap_3
XFILLER_76_561 VGND VGND VPWR VPWR sky130_fd_sc_hd__decap_3
XFILLER_36_436 VGND VGND VPWR VPWR sky130_fd_sc_hd__decap_3
XFILLER_48_263 VGND VGND VPWR VPWR sky130_fd_sc_hd__decap_3
XFILLER_63_200 VGND VGND VPWR VPWR sky130_fd_sc_hd__decap_3
XFILLER_63_255 VGND VGND VPWR VPWR sky130_fd_sc_hd__decap_3
XFILLER_23_119 VGND VGND VPWR VPWR sky130_fd_sc_hd__decap_3
X_4980_ _5152_/A _5151_/C _4978_/D _5068_/A VGND VGND VPWR VPWR _4981_/B sky130_fd_sc_hd__a22o_2
XFILLER_63_299 VGND VGND VPWR VPWR sky130_fd_sc_hd__decap_3
X_3931_ _3932_/A _3932_/B _3932_/C VGND VGND VPWR VPWR _6039_/A sky130_fd_sc_hd__a21oi_2
XFILLER_31_130 VGND VGND VPWR VPWR sky130_fd_sc_hd__decap_3
X_6650_ _6650_/A _6650_/B _6650_/C VGND VGND VPWR VPWR _6650_/X sky130_fd_sc_hd__or3_2
X_3862_ _3700_/Y _3702_/Y _5965_/A _3861_/Y VGND VGND VPWR VPWR _5965_/B sky130_fd_sc_hd__a211oi_2
X_6581_ _5807_/Y _6982_/A2 _6562_/X _6580_/X VGND VGND VPWR VPWR _6986_/B sky130_fd_sc_hd__a31o_2
X_5601_ _5600_/A _5599_/B _5639_/A _5639_/B VGND VGND VPWR VPWR _5603_/B sky130_fd_sc_hd__a22o_2
XTAP_TAPCELL_ROW_14_361 VGND VPWR sky130_fd_sc_hd__tapvpwrvgnd_1
X_5532_ _5630_/A _6123_/B _5533_/A _5532_/D VGND VGND VPWR VPWR _5591_/A sky130_fd_sc_hd__nand4_2
X_3793_ _3960_/A _5995_/B _3969_/B _3969_/D VGND VGND VPWR VPWR _3795_/A sky130_fd_sc_hd__and4_2
XFILLER_11_19 VGND VGND VPWR VPWR sky130_fd_sc_hd__decap_3
X_5463_ _5848_/B _5462_/C _5462_/A VGND VGND VPWR VPWR _5464_/C sky130_fd_sc_hd__a21oi_2
X_5394_ _5393_/B _5393_/C _5393_/A VGND VGND VPWR VPWR _5414_/B sky130_fd_sc_hd__o21ai_2
X_4414_ _4412_/A _4516_/A _4413_/Y _4398_/A VGND VGND VPWR VPWR _4414_/X sky130_fd_sc_hd__a211o_4
X_4345_ _4088_/B _4088_/C _6077_/A _4593_/B VGND VGND VPWR VPWR _4346_/B sky130_fd_sc_hd__a22oi_2
Xfanout316 _5374_/A VGND VGND VPWR VPWR _4767_/A sky130_fd_sc_hd__clkbuf_2
Xfanout327 input48/X VGND VGND VPWR VPWR _5992_/A sky130_fd_sc_hd__clkdlybuf4s25_1
XFILLER_98_141 VGND VGND VPWR VPWR sky130_fd_sc_hd__decap_3
XFILLER_100_113 VGND VGND VPWR VPWR sky130_fd_sc_hd__decap_3
XFILLER_86_347 VGND VGND VPWR VPWR sky130_fd_sc_hd__fill_1
Xfanout349 _6499_/S VGND VGND VPWR VPWR _4985_/B sky130_fd_sc_hd__clkdlybuf4s25_1
X_4276_ _4273_/X _4276_/B VGND VGND VPWR VPWR _4393_/B sky130_fd_sc_hd__and2b_2
XFILLER_100_157 VGND VGND VPWR VPWR sky130_fd_sc_hd__decap_3
XFILLER_67_561 VGND VGND VPWR VPWR sky130_fd_sc_hd__decap_3
X_6015_ _3941_/B _6016_/B _3834_/D _6016_/D VGND VGND VPWR VPWR _6017_/A sky130_fd_sc_hd__a22oi_2
XFILLER_27_414 VGND VGND VPWR VPWR sky130_fd_sc_hd__decap_3
XFILLER_36_16 VGND VGND VPWR VPWR sky130_fd_sc_hd__decap_3
XFILLER_39_263 VGND VGND VPWR VPWR sky130_fd_sc_hd__decap_3
XFILLER_54_200 VGND VGND VPWR VPWR sky130_fd_sc_hd__decap_3
XFILLER_67_572 VGND VGND VPWR VPWR sky130_fd_sc_hd__fill_2
XFILLER_27_447 VGND VGND VPWR VPWR sky130_fd_sc_hd__fill_1
XFILLER_27_458 VGND VGND VPWR VPWR sky130_fd_sc_hd__decap_3
XFILLER_36_38 VGND VGND VPWR VPWR sky130_fd_sc_hd__decap_3
XFILLER_54_244 VGND VGND VPWR VPWR sky130_fd_sc_hd__fill_2
XFILLER_82_531 VGND VGND VPWR VPWR sky130_fd_sc_hd__fill_1
XFILLER_42_417 VGND VGND VPWR VPWR sky130_fd_sc_hd__decap_3
XFILLER_82_586 VGND VGND VPWR VPWR sky130_fd_sc_hd__fill_2
X_6917_ _6931_/C _6908_/X _6916_/X _6907_/X VGND VGND VPWR VPWR _6917_/Y sky130_fd_sc_hd__o211ai_2
XFILLER_22_141 VGND VGND VPWR VPWR sky130_fd_sc_hd__fill_2
X_6848_ _6782_/X _6847_/X _6848_/S VGND VGND VPWR VPWR _6848_/X sky130_fd_sc_hd__mux2_1
XFILLER_10_303 VGND VGND VPWR VPWR sky130_fd_sc_hd__decap_3
XFILLER_50_483 VGND VGND VPWR VPWR sky130_fd_sc_hd__decap_3
X_6779_ _6779_/A _6779_/B VGND VGND VPWR VPWR _6779_/X sky130_fd_sc_hd__or2_2
XTAP_TAPCELL_ROW_75_1005 VGND VPWR sky130_fd_sc_hd__tapvpwrvgnd_1
XFILLER_77_12 VGND VGND VPWR VPWR sky130_fd_sc_hd__fill_2
XFILLER_77_314 VGND VGND VPWR VPWR sky130_fd_sc_hd__decap_3
XFILLER_89_152 VGND VGND VPWR VPWR sky130_fd_sc_hd__decap_3
XTAP_TAPCELL_ROW_48_718 VGND VPWR sky130_fd_sc_hd__tapvpwrvgnd_1
XFILLER_45_200 VGND VGND VPWR VPWR sky130_fd_sc_hd__fill_1
XFILLER_18_447 VGND VGND VPWR VPWR sky130_fd_sc_hd__decap_3
XTAP_TAPCELL_ROW_86_1123 VGND VPWR sky130_fd_sc_hd__tapvpwrvgnd_1
XFILLER_93_44 VGND VGND VPWR VPWR sky130_fd_sc_hd__decap_3
XFILLER_73_564 VGND VGND VPWR VPWR sky130_fd_sc_hd__fill_1
XFILLER_93_99 VGND VGND VPWR VPWR sky130_fd_sc_hd__decap_3
XFILLER_45_299 VGND VGND VPWR VPWR sky130_fd_sc_hd__decap_3
XFILLER_73_597 VGND VGND VPWR VPWR sky130_fd_sc_hd__fill_1
XFILLER_41_461 VGND VGND VPWR VPWR sky130_fd_sc_hd__fill_1
XFILLER_13_196 VGND VGND VPWR VPWR sky130_fd_sc_hd__decap_3
XTAP_TAPCELL_ROW_11_331 VGND VPWR sky130_fd_sc_hd__tapvpwrvgnd_1
XFILLER_9_178 VGND VGND VPWR VPWR sky130_fd_sc_hd__decap_3
XFILLER_5_373 VGND VGND VPWR VPWR sky130_fd_sc_hd__decap_3
XPHY_EDGE_ROW_39_Left_140 VGND VGND VPWR VPWR sky130_fd_sc_hd__decap_3
X_4130_ _4129_/B _4129_/C _4129_/A VGND VGND VPWR VPWR _4132_/C sky130_fd_sc_hd__a21bo_2
XFILLER_68_325 VGND VGND VPWR VPWR sky130_fd_sc_hd__decap_3
XFILLER_1_590 VGND VGND VPWR VPWR sky130_fd_sc_hd__decap_3
X_4061_ _4056_/A _4056_/C _4055_/Y _4057_/A VGND VGND VPWR VPWR _4061_/X sky130_fd_sc_hd__a2bb2o_2
XFILLER_36_211 VGND VGND VPWR VPWR sky130_fd_sc_hd__decap_3
XFILLER_83_328 VGND VGND VPWR VPWR sky130_fd_sc_hd__decap_3
XFILLER_64_531 VGND VGND VPWR VPWR sky130_fd_sc_hd__fill_1
XFILLER_76_391 VGND VGND VPWR VPWR sky130_fd_sc_hd__decap_3
XTAP_TAPCELL_ROW_19_420 VGND VPWR sky130_fd_sc_hd__tapvpwrvgnd_1
XFILLER_24_417 VGND VGND VPWR VPWR sky130_fd_sc_hd__decap_3
XFILLER_36_266 VGND VGND VPWR VPWR sky130_fd_sc_hd__fill_2
XFILLER_91_361 VGND VGND VPWR VPWR sky130_fd_sc_hd__decap_3
XFILLER_17_491 VGND VGND VPWR VPWR sky130_fd_sc_hd__decap_3
XFILLER_36_299 VGND VGND VPWR VPWR sky130_fd_sc_hd__decap_3
XFILLER_51_214 VGND VGND VPWR VPWR sky130_fd_sc_hd__decap_3
XFILLER_51_225 VGND VGND VPWR VPWR sky130_fd_sc_hd__decap_3
X_4963_ _4963_/A _4963_/B _4963_/C VGND VGND VPWR VPWR _4970_/A sky130_fd_sc_hd__nand3_4
XFILLER_32_450 VGND VGND VPWR VPWR sky130_fd_sc_hd__fill_1
XFILLER_51_269 VGND VGND VPWR VPWR sky130_fd_sc_hd__fill_2
X_6702_ _5151_/C _6695_/Y _6697_/X _6701_/X VGND VGND VPWR VPWR _6702_/X sky130_fd_sc_hd__o211a_2
X_3914_ _3916_/A _3916_/B _3916_/C VGND VGND VPWR VPWR _3915_/A sky130_fd_sc_hd__a21o_2
X_6633_ _5720_/Y _5813_/X _6841_/A VGND VGND VPWR VPWR _6633_/Y sky130_fd_sc_hd__a21oi_2
X_4894_ _4860_/Y _4863_/X _4893_/X _4531_/Y VGND VGND VPWR VPWR _4903_/A sky130_fd_sc_hd__a211o_2
X_3845_ _3845_/A _3845_/B VGND VGND VPWR VPWR _4054_/C sky130_fd_sc_hd__xnor2_2
X_6564_ _6381_/B _6134_/X _6563_/Y VGND VGND VPWR VPWR _6564_/X sky130_fd_sc_hd__a21o_2
X_3776_ _4290_/A _6893_/S _3776_/C VGND VGND VPWR VPWR _4178_/A sky130_fd_sc_hd__and3_2
X_6495_ _6625_/A _6494_/X _6491_/X VGND VGND VPWR VPWR _6495_/X sky130_fd_sc_hd__a21o_2
X_5515_ _5441_/A _5441_/C _5441_/B VGND VGND VPWR VPWR _5515_/X sky130_fd_sc_hd__o21a_2
X_5446_ _5826_/A _5446_/B VGND VGND VPWR VPWR _5462_/A sky130_fd_sc_hd__and2_2
X_5377_ _5377_/A _5377_/B _5377_/C VGND VGND VPWR VPWR _5377_/Y sky130_fd_sc_hd__nand3_2
XFILLER_99_461 VGND VGND VPWR VPWR sky130_fd_sc_hd__decap_3
XFILLER_59_325 VGND VGND VPWR VPWR sky130_fd_sc_hd__decap_3
XFILLER_86_100 VGND VGND VPWR VPWR sky130_fd_sc_hd__decap_3
Xfanout124 _6371_/Y VGND VGND VPWR VPWR _6372_/B sky130_fd_sc_hd__clkdlybuf4s25_1
Xfanout135 _6333_/X VGND VGND VPWR VPWR _6605_/A2 sky130_fd_sc_hd__clkdlybuf4s25_1
Xfanout146 _6841_/A VGND VGND VPWR VPWR _6777_/A sky130_fd_sc_hd__clkdlybuf4s25_1
X_4328_ _4313_/B _4313_/C _4313_/D _4313_/A VGND VGND VPWR VPWR _4328_/X sky130_fd_sc_hd__a22o_2
Xfanout157 _6203_/X VGND VGND VPWR VPWR _6778_/B1 sky130_fd_sc_hd__clkdlybuf4s25_1
Xfanout168 _3501_/Y VGND VGND VPWR VPWR _6317_/S sky130_fd_sc_hd__dlygate4sd1_1
Xfanout179 _3499_/Y VGND VGND VPWR VPWR _6897_/S sky130_fd_sc_hd__clkdlybuf4s25_1
X_4259_ _4229_/Y _4253_/C _4256_/Y _4192_/X VGND VGND VPWR VPWR _4259_/X sky130_fd_sc_hd__a211o_2
XFILLER_55_520 VGND VGND VPWR VPWR sky130_fd_sc_hd__decap_3
XFILLER_55_542 VGND VGND VPWR VPWR sky130_fd_sc_hd__decap_3
XFILLER_15_406 VGND VGND VPWR VPWR sky130_fd_sc_hd__decap_3
XFILLER_55_564 VGND VGND VPWR VPWR sky130_fd_sc_hd__decap_3
XFILLER_70_512 VGND VGND VPWR VPWR sky130_fd_sc_hd__decap_3
XFILLER_42_236 VGND VGND VPWR VPWR sky130_fd_sc_hd__decap_3
XFILLER_82_383 VGND VGND VPWR VPWR sky130_fd_sc_hd__fill_2
XFILLER_42_258 VGND VGND VPWR VPWR sky130_fd_sc_hd__decap_3
XFILLER_70_556 VGND VGND VPWR VPWR sky130_fd_sc_hd__decap_3
XTAP_TAPCELL_ROW_53_776 VGND VPWR sky130_fd_sc_hd__tapvpwrvgnd_1
XFILLER_23_472 VGND VGND VPWR VPWR sky130_fd_sc_hd__fill_2
XFILLER_70_589 VGND VGND VPWR VPWR sky130_fd_sc_hd__decap_3
XTAP_TAPCELL_ROW_81_1064 VGND VPWR sky130_fd_sc_hd__tapvpwrvgnd_1
XTAP_TAPCELL_ROW_25_478 VGND VPWR sky130_fd_sc_hd__tapvpwrvgnd_1
XFILLER_50_280 VGND VGND VPWR VPWR sky130_fd_sc_hd__decap_3
Xwire514 wire514/A VGND VGND VPWR VPWR _6105_/A sky130_fd_sc_hd__buf_4
XFILLER_10_144 VGND VGND VPWR VPWR sky130_fd_sc_hd__decap_3
XFILLER_6_137 VGND VGND VPWR VPWR sky130_fd_sc_hd__decap_3
XFILLER_88_44 VGND VGND VPWR VPWR sky130_fd_sc_hd__decap_3
XFILLER_88_88 VGND VGND VPWR VPWR sky130_fd_sc_hd__fill_1
XFILLER_77_111 VGND VGND VPWR VPWR sky130_fd_sc_hd__fill_1
XTAP_TAPCELL_ROW_92_1182 VGND VPWR sky130_fd_sc_hd__tapvpwrvgnd_1
XFILLER_77_133 VGND VGND VPWR VPWR sky130_fd_sc_hd__decap_3
XFILLER_65_306 VGND VGND VPWR VPWR sky130_fd_sc_hd__decap_3
XFILLER_18_211 VGND VGND VPWR VPWR sky130_fd_sc_hd__fill_2
XFILLER_18_222 VGND VGND VPWR VPWR sky130_fd_sc_hd__decap_3
XFILLER_46_520 VGND VGND VPWR VPWR sky130_fd_sc_hd__decap_3
XFILLER_92_136 VGND VGND VPWR VPWR sky130_fd_sc_hd__decap_3
XFILLER_92_147 VGND VGND VPWR VPWR sky130_fd_sc_hd__decap_3
XFILLER_92_158 VGND VGND VPWR VPWR sky130_fd_sc_hd__decap_3
XFILLER_80_309 VGND VGND VPWR VPWR sky130_fd_sc_hd__decap_3
XFILLER_18_288 VGND VGND VPWR VPWR sky130_fd_sc_hd__decap_3
XFILLER_33_214 VGND VGND VPWR VPWR sky130_fd_sc_hd__fill_2
XFILLER_33_225 VGND VGND VPWR VPWR sky130_fd_sc_hd__decap_3
XFILLER_46_597 VGND VGND VPWR VPWR sky130_fd_sc_hd__fill_1
XFILLER_33_258 VGND VGND VPWR VPWR sky130_fd_sc_hd__decap_3
XFILLER_33_269 VGND VGND VPWR VPWR sky130_fd_sc_hd__decap_3
XFILLER_61_567 VGND VGND VPWR VPWR sky130_fd_sc_hd__decap_3
XFILLER_53_91 VGND VGND VPWR VPWR sky130_fd_sc_hd__decap_3
X_3630_ _3631_/B _3631_/A VGND VGND VPWR VPWR _3630_/X sky130_fd_sc_hd__and2b_2
X_3561_ _3562_/A _3562_/B VGND VGND VPWR VPWR _3599_/B sky130_fd_sc_hd__nor2_2
X_5300_ _5341_/A _5300_/B _5321_/C _5321_/D VGND VGND VPWR VPWR _5300_/X sky130_fd_sc_hd__and4_2
X_6280_ _6273_/Y _6278_/B _6278_/A VGND VGND VPWR VPWR _6931_/C sky130_fd_sc_hd__a21oi_2
X_3492_ _4925_/D VGND VGND VPWR VPWR _5019_/B sky130_fd_sc_hd__inv_2
X_5231_ _5231_/A _5231_/B VGND VGND VPWR VPWR _5453_/B sky130_fd_sc_hd__xnor2_2
XFILLER_68_100 VGND VGND VPWR VPWR sky130_fd_sc_hd__decap_3
X_5162_ _5162_/A _5452_/B _5163_/B VGND VGND VPWR VPWR _5162_/X sky130_fd_sc_hd__and3_2
XFILLER_68_133 VGND VGND VPWR VPWR sky130_fd_sc_hd__decap_3
XFILLER_68_144 VGND VGND VPWR VPWR sky130_fd_sc_hd__decap_3
XFILLER_68_155 VGND VGND VPWR VPWR sky130_fd_sc_hd__decap_3
X_5093_ _5084_/X _5089_/C _5091_/Y _5092_/X VGND VGND VPWR VPWR _5093_/Y sky130_fd_sc_hd__o211ai_2
X_4113_ _3675_/A _4112_/X _4109_/B _4106_/B VGND VGND VPWR VPWR _4113_/X sky130_fd_sc_hd__o211a_2
XFILLER_68_188 VGND VGND VPWR VPWR sky130_fd_sc_hd__fill_1
XFILLER_96_475 VGND VGND VPWR VPWR sky130_fd_sc_hd__fill_1
XFILLER_17_18 VGND VGND VPWR VPWR sky130_fd_sc_hd__decap_3
XFILLER_37_542 VGND VGND VPWR VPWR sky130_fd_sc_hd__decap_3
XFILLER_56_339 VGND VGND VPWR VPWR sky130_fd_sc_hd__decap_3
X_4044_ _4044_/A _4044_/B VGND VGND VPWR VPWR _4046_/B sky130_fd_sc_hd__xnor2_2
XFILLER_37_564 VGND VGND VPWR VPWR sky130_fd_sc_hd__decap_3
XFILLER_37_575 VGND VGND VPWR VPWR sky130_fd_sc_hd__decap_3
XFILLER_52_501 VGND VGND VPWR VPWR sky130_fd_sc_hd__decap_3
XFILLER_83_158 VGND VGND VPWR VPWR sky130_fd_sc_hd__decap_3
XFILLER_83_169 VGND VGND VPWR VPWR sky130_fd_sc_hd__decap_3
XFILLER_37_597 VGND VGND VPWR VPWR sky130_fd_sc_hd__fill_1
XFILLER_52_545 VGND VGND VPWR VPWR sky130_fd_sc_hd__decap_3
XFILLER_64_383 VGND VGND VPWR VPWR sky130_fd_sc_hd__decap_3
X_5995_ _6276_/A _5995_/B VGND VGND VPWR VPWR _5996_/B sky130_fd_sc_hd__nand2_2
XFILLER_33_17 VGND VGND VPWR VPWR sky130_fd_sc_hd__fill_2
X_4946_ _5341_/B _5188_/C _4944_/D _5340_/A VGND VGND VPWR VPWR _4947_/C sky130_fd_sc_hd__a22oi_2
XFILLER_32_280 VGND VGND VPWR VPWR sky130_fd_sc_hd__fill_1
X_4877_ _4876_/A _4876_/B _4876_/C _4876_/D VGND VGND VPWR VPWR _4877_/X sky130_fd_sc_hd__a22o_2
XTAP_TAPCELL_ROW_50_746 VGND VPWR sky130_fd_sc_hd__tapvpwrvgnd_1
XTAP_TAPCELL_ROW_22_448 VGND VPWR sky130_fd_sc_hd__tapvpwrvgnd_1
XFILLER_20_475 VGND VGND VPWR VPWR sky130_fd_sc_hd__fill_1
X_6616_ _6383_/D _6235_/Y _6853_/A VGND VGND VPWR VPWR _6616_/Y sky130_fd_sc_hd__a21oi_2
X_3828_ _6019_/B _6014_/A VGND VGND VPWR VPWR _3830_/B sky130_fd_sc_hd__nand2_2
XFILLER_20_486 VGND VGND VPWR VPWR sky130_fd_sc_hd__decap_3
X_6547_ _6832_/S _6547_/B VGND VGND VPWR VPWR _6698_/B sky130_fd_sc_hd__nand2_2
XFILLER_3_107 VGND VGND VPWR VPWR sky130_fd_sc_hd__decap_3
X_3759_ _3754_/A _3754_/C _3754_/B VGND VGND VPWR VPWR _3760_/C sky130_fd_sc_hd__a21o_2
X_6478_ _6359_/X _6401_/X _6478_/S VGND VGND VPWR VPWR _6478_/X sky130_fd_sc_hd__mux2_1
X_5429_ _5355_/B _5355_/Y _5426_/Y _5428_/X VGND VGND VPWR VPWR _5433_/A sky130_fd_sc_hd__a211o_4
XFILLER_87_420 VGND VGND VPWR VPWR sky130_fd_sc_hd__decap_3
XFILLER_58_69 VGND VGND VPWR VPWR sky130_fd_sc_hd__decap_3
XFILLER_59_188 VGND VGND VPWR VPWR sky130_fd_sc_hd__decap_3
XFILLER_74_114 VGND VGND VPWR VPWR sky130_fd_sc_hd__decap_3
XFILLER_87_475 VGND VGND VPWR VPWR sky130_fd_sc_hd__fill_2
XTAP_TAPCELL_ROW_58_824 VGND VPWR sky130_fd_sc_hd__tapvpwrvgnd_1
XFILLER_28_531 VGND VGND VPWR VPWR sky130_fd_sc_hd__fill_1
XFILLER_74_147 VGND VGND VPWR VPWR sky130_fd_sc_hd__decap_3
XFILLER_43_501 VGND VGND VPWR VPWR sky130_fd_sc_hd__decap_3
XFILLER_62_309 VGND VGND VPWR VPWR sky130_fd_sc_hd__decap_3
XFILLER_15_203 VGND VGND VPWR VPWR sky130_fd_sc_hd__decap_3
XFILLER_55_372 VGND VGND VPWR VPWR sky130_fd_sc_hd__decap_3
XFILLER_70_320 VGND VGND VPWR VPWR sky130_fd_sc_hd__decap_3
XFILLER_15_247 VGND VGND VPWR VPWR sky130_fd_sc_hd__decap_3
XFILLER_15_258 VGND VGND VPWR VPWR sky130_fd_sc_hd__decap_3
XFILLER_43_567 VGND VGND VPWR VPWR sky130_fd_sc_hd__fill_2
XFILLER_82_191 VGND VGND VPWR VPWR sky130_fd_sc_hd__decap_3
XFILLER_11_431 VGND VGND VPWR VPWR sky130_fd_sc_hd__decap_3
XFILLER_23_50 VGND VGND VPWR VPWR sky130_fd_sc_hd__decap_3
XFILLER_23_72 VGND VGND VPWR VPWR sky130_fd_sc_hd__fill_2
XFILLER_7_413 VGND VGND VPWR VPWR sky130_fd_sc_hd__decap_3
XFILLER_11_497 VGND VGND VPWR VPWR sky130_fd_sc_hd__decap_3
Xwire344 _3552_/B VGND VGND VPWR VPWR _5976_/A sky130_fd_sc_hd__clkbuf_4
Xwire366 _6311_/A VGND VGND VPWR VPWR _6456_/S sky130_fd_sc_hd__clkbuf_4
XFILLER_99_10 VGND VGND VPWR VPWR sky130_fd_sc_hd__fill_1
XTAP_TAPCELL_ROW_94_1200 VGND VPWR sky130_fd_sc_hd__tapvpwrvgnd_1
Xload_slew305 _3872_/B VGND VGND VPWR VPWR _6924_/S sky130_fd_sc_hd__buf_4
XFILLER_78_442 VGND VGND VPWR VPWR sky130_fd_sc_hd__decap_3
XFILLER_93_423 VGND VGND VPWR VPWR sky130_fd_sc_hd__decap_3
XFILLER_17_6 VGND VGND VPWR VPWR sky130_fd_sc_hd__decap_3
XFILLER_19_531 VGND VGND VPWR VPWR sky130_fd_sc_hd__fill_2
XFILLER_19_542 VGND VGND VPWR VPWR sky130_fd_sc_hd__fill_2
XFILLER_48_91 VGND VGND VPWR VPWR sky130_fd_sc_hd__decap_3
XFILLER_65_125 VGND VGND VPWR VPWR sky130_fd_sc_hd__decap_3
XFILLER_93_434 VGND VGND VPWR VPWR sky130_fd_sc_hd__decap_3
XFILLER_0_21 VGND VGND VPWR VPWR sky130_fd_sc_hd__decap_3
XFILLER_19_575 VGND VGND VPWR VPWR sky130_fd_sc_hd__fill_1
XFILLER_65_158 VGND VGND VPWR VPWR sky130_fd_sc_hd__decap_3
XFILLER_65_169 VGND VGND VPWR VPWR sky130_fd_sc_hd__decap_3
XFILLER_93_467 VGND VGND VPWR VPWR sky130_fd_sc_hd__decap_3
XFILLER_80_128 VGND VGND VPWR VPWR sky130_fd_sc_hd__decap_3
XFILLER_34_545 VGND VGND VPWR VPWR sky130_fd_sc_hd__fill_1
X_4800_ _4800_/A _4800_/B VGND VGND VPWR VPWR _4977_/B sky130_fd_sc_hd__xnor2_2
XFILLER_21_217 VGND VGND VPWR VPWR sky130_fd_sc_hd__decap_3
XFILLER_21_228 VGND VGND VPWR VPWR sky130_fd_sc_hd__decap_3
XFILLER_61_375 VGND VGND VPWR VPWR sky130_fd_sc_hd__decap_3
X_5780_ _5780_/A _5790_/A VGND VGND VPWR VPWR _5792_/B sky130_fd_sc_hd__xnor2_2
XFILLER_14_291 VGND VGND VPWR VPWR sky130_fd_sc_hd__decap_3
X_4731_ _4724_/B _4935_/B _4722_/X VGND VGND VPWR VPWR _4747_/A sky130_fd_sc_hd__a21o_2
X_4662_ _4662_/A _4662_/B _4662_/C _4662_/D VGND VGND VPWR VPWR _4662_/X sky130_fd_sc_hd__and4_2
X_6401_ _3628_/C _3655_/A _6401_/S VGND VGND VPWR VPWR _6401_/X sky130_fd_sc_hd__mux2_1
X_3613_ _3613_/A _3613_/B _3652_/A VGND VGND VPWR VPWR _3633_/B sky130_fd_sc_hd__and3_2
X_4593_ _4593_/A _4593_/B _4593_/C _4593_/D VGND VGND VPWR VPWR _4593_/X sky130_fd_sc_hd__and4_2
X_6332_ _6332_/A _6332_/B _6332_/C VGND VGND VPWR VPWR _6332_/X sky130_fd_sc_hd__or3_2
X_3544_ _3544_/A _3960_/A _3969_/B _3969_/D VGND VGND VPWR VPWR _3797_/A sky130_fd_sc_hd__and4_2
XFILLER_88_206 VGND VGND VPWR VPWR sky130_fd_sc_hd__decap_3
X_6263_ _6077_/A _6263_/B VGND VGND VPWR VPWR _6263_/X sky130_fd_sc_hd__and2b_2
X_5214_ _5423_/A _5423_/B VGND VGND VPWR VPWR _5214_/X sky130_fd_sc_hd__and2_2
X_6194_ _6174_/Y _6919_/B _6193_/X _6176_/A VGND VGND VPWR VPWR _6194_/X sky130_fd_sc_hd__o211a_2
XFILLER_29_317 VGND VGND VPWR VPWR sky130_fd_sc_hd__decap_3
X_5145_ _5044_/X _5060_/Y _5145_/B1 _5059_/A VGND VGND VPWR VPWR _5145_/Y sky130_fd_sc_hd__o211ai_2
XFILLER_56_147 VGND VGND VPWR VPWR sky130_fd_sc_hd__decap_3
X_5076_ _4793_/A _5284_/B _5150_/B _5073_/X VGND VGND VPWR VPWR _5078_/B sky130_fd_sc_hd__a31o_2
XFILLER_96_294 VGND VGND VPWR VPWR sky130_fd_sc_hd__decap_3
XFILLER_44_309 VGND VGND VPWR VPWR sky130_fd_sc_hd__decap_3
XFILLER_84_489 VGND VGND VPWR VPWR sky130_fd_sc_hd__decap_3
X_4027_ _4026_/A _4026_/B _4026_/C VGND VGND VPWR VPWR _4028_/B sky130_fd_sc_hd__a21oi_2
XFILLER_25_523 VGND VGND VPWR VPWR sky130_fd_sc_hd__decap_3
XFILLER_37_383 VGND VGND VPWR VPWR sky130_fd_sc_hd__decap_3
XFILLER_71_139 VGND VGND VPWR VPWR sky130_fd_sc_hd__decap_3
XFILLER_44_27 VGND VGND VPWR VPWR sky130_fd_sc_hd__fill_1
X_5978_ _3972_/A input45/X _3973_/A _3971_/A VGND VGND VPWR VPWR _5979_/B sky130_fd_sc_hd__a31o_2
XTAP_TAPCELL_ROW_63_882 VGND VPWR sky130_fd_sc_hd__tapvpwrvgnd_1
X_4929_ _4685_/A _5018_/B _4928_/B _4925_/X VGND VGND VPWR VPWR _5017_/A sky130_fd_sc_hd__a31o_2
XTAP_TAPCELL_ROW_35_584 VGND VPWR sky130_fd_sc_hd__tapvpwrvgnd_1
XFILLER_100_88 VGND VGND VPWR VPWR sky130_fd_sc_hd__decap_3
XTAP_TAPCELL_ROW_7_287 VGND VPWR sky130_fd_sc_hd__tapvpwrvgnd_1
XFILLER_94_209 VGND VGND VPWR VPWR sky130_fd_sc_hd__fill_1
XFILLER_47_169 VGND VGND VPWR VPWR sky130_fd_sc_hd__decap_3
XFILLER_85_78 VGND VGND VPWR VPWR sky130_fd_sc_hd__decap_3
XFILLER_16_523 VGND VGND VPWR VPWR sky130_fd_sc_hd__fill_2
XFILLER_18_72 VGND VGND VPWR VPWR sky130_fd_sc_hd__decap_3
XFILLER_62_117 VGND VGND VPWR VPWR sky130_fd_sc_hd__decap_3
XFILLER_28_394 VGND VGND VPWR VPWR sky130_fd_sc_hd__decap_3
XFILLER_43_331 VGND VGND VPWR VPWR sky130_fd_sc_hd__decap_3
XFILLER_90_459 VGND VGND VPWR VPWR sky130_fd_sc_hd__decap_3
XFILLER_16_589 VGND VGND VPWR VPWR sky130_fd_sc_hd__decap_3
XFILLER_31_526 VGND VGND VPWR VPWR sky130_fd_sc_hd__decap_3
XFILLER_43_375 VGND VGND VPWR VPWR sky130_fd_sc_hd__fill_2
XFILLER_43_386 VGND VGND VPWR VPWR sky130_fd_sc_hd__decap_3
XFILLER_70_150 VGND VGND VPWR VPWR sky130_fd_sc_hd__decap_3
XFILLER_31_559 VGND VGND VPWR VPWR sky130_fd_sc_hd__fill_1
XFILLER_70_183 VGND VGND VPWR VPWR sky130_fd_sc_hd__decap_3
XFILLER_7_210 VGND VGND VPWR VPWR sky130_fd_sc_hd__decap_3
XFILLER_7_243 VGND VGND VPWR VPWR sky130_fd_sc_hd__decap_3
Xwire152 wire152/A VGND VGND VPWR VPWR _6757_/C sky130_fd_sc_hd__clkbuf_4
XFILLER_59_90 VGND VGND VPWR VPWR sky130_fd_sc_hd__decap_3
XFILLER_66_401 VGND VGND VPWR VPWR sky130_fd_sc_hd__decap_3
XFILLER_78_261 VGND VGND VPWR VPWR sky130_fd_sc_hd__decap_3
XFILLER_66_434 VGND VGND VPWR VPWR sky130_fd_sc_hd__decap_3
XFILLER_78_294 VGND VGND VPWR VPWR sky130_fd_sc_hd__decap_3
XFILLER_93_231 VGND VGND VPWR VPWR sky130_fd_sc_hd__decap_3
XFILLER_26_309 VGND VGND VPWR VPWR sky130_fd_sc_hd__decap_3
XFILLER_66_467 VGND VGND VPWR VPWR sky130_fd_sc_hd__decap_3
XFILLER_81_404 VGND VGND VPWR VPWR sky130_fd_sc_hd__decap_3
X_6950_ _6951_/A _6951_/B _6951_/C VGND VGND VPWR VPWR _6952_/B sky130_fd_sc_hd__a21oi_4
XFILLER_66_489 VGND VGND VPWR VPWR sky130_fd_sc_hd__fill_1
XFILLER_93_275 VGND VGND VPWR VPWR sky130_fd_sc_hd__decap_3
X_5901_ _4550_/A _4551_/X _5931_/A _5900_/Y VGND VGND VPWR VPWR _5931_/B sky130_fd_sc_hd__o211ai_2
X_6881_ _6371_/Y _6877_/X _6880_/X VGND VGND VPWR VPWR _6881_/X sky130_fd_sc_hd__a21bo_2
XFILLER_34_353 VGND VGND VPWR VPWR sky130_fd_sc_hd__decap_3
X_5832_ _5831_/A _5831_/B _5846_/B VGND VGND VPWR VPWR _5832_/X sky130_fd_sc_hd__o21a_2
XFILLER_22_537 VGND VGND VPWR VPWR sky130_fd_sc_hd__decap_3
XFILLER_61_172 VGND VGND VPWR VPWR sky130_fd_sc_hd__decap_3
XFILLER_61_194 VGND VGND VPWR VPWR sky130_fd_sc_hd__decap_3
X_5763_ _6123_/A _6125_/B _5763_/C _5763_/D VGND VGND VPWR VPWR _5775_/A sky130_fd_sc_hd__and4_2
X_4714_ _4942_/A _4855_/A _4714_/C VGND VGND VPWR VPWR _4834_/D sky130_fd_sc_hd__and3b_2
XTAP_TAPCELL_ROW_60_852 VGND VPWR sky130_fd_sc_hd__tapvpwrvgnd_1
XTAP_TAPCELL_ROW_32_554 VGND VPWR sky130_fd_sc_hd__tapvpwrvgnd_1
X_5694_ _5779_/A _5778_/C _5664_/A _5664_/C VGND VGND VPWR VPWR _5700_/B sky130_fd_sc_hd__a22o_2
XFILLER_30_18 VGND VGND VPWR VPWR sky130_fd_sc_hd__fill_2
XFILLER_30_29 VGND VGND VPWR VPWR sky130_fd_sc_hd__decap_3
X_4645_ _4925_/B _4646_/D VGND VGND VPWR VPWR _5186_/A sky130_fd_sc_hd__nand2_2
X_4576_ _4576_/A _4576_/B VGND VGND VPWR VPWR _4577_/B sky130_fd_sc_hd__xnor2_2
X_6315_ _6315_/A _6434_/S VGND VGND VPWR VPWR _6447_/B sky130_fd_sc_hd__or2_2
X_3527_ _3527_/A _3527_/B VGND VGND VPWR VPWR _3528_/C sky130_fd_sc_hd__xnor2_2
X_6246_ _6211_/A _6211_/B _6384_/B _6707_/B _6244_/Y VGND VGND VPWR VPWR _6247_/B
+ sky130_fd_sc_hd__o221ai_2
XFILLER_69_261 VGND VGND VPWR VPWR sky130_fd_sc_hd__decap_3
X_6177_ _6178_/A _6275_/B VGND VGND VPWR VPWR _6180_/A sky130_fd_sc_hd__or2_2
XFILLER_57_445 VGND VGND VPWR VPWR sky130_fd_sc_hd__decap_3
X_5128_ _5209_/A _5203_/D VGND VGND VPWR VPWR _5197_/A sky130_fd_sc_hd__nand2_2
XTAP_TAPCELL_ROW_68_930 VGND VPWR sky130_fd_sc_hd__tapvpwrvgnd_1
XTAP_TAPCELL_ROW_4_257 VGND VPWR sky130_fd_sc_hd__tapvpwrvgnd_1
XFILLER_84_253 VGND VGND VPWR VPWR sky130_fd_sc_hd__decap_3
XFILLER_72_437 VGND VGND VPWR VPWR sky130_fd_sc_hd__decap_3
X_5059_ _5059_/A _5059_/B _5059_/C VGND VGND VPWR VPWR _5126_/C sky130_fd_sc_hd__nand3_4
XFILLER_37_191 VGND VGND VPWR VPWR sky130_fd_sc_hd__fill_2
XFILLER_25_364 VGND VGND VPWR VPWR sky130_fd_sc_hd__decap_3
XFILLER_52_150 VGND VGND VPWR VPWR sky130_fd_sc_hd__decap_3
XFILLER_13_559 VGND VGND VPWR VPWR sky130_fd_sc_hd__fill_1
XFILLER_40_312 VGND VGND VPWR VPWR sky130_fd_sc_hd__decap_3
XFILLER_80_492 VGND VGND VPWR VPWR sky130_fd_sc_hd__fill_2
XFILLER_21_592 VGND VGND VPWR VPWR sky130_fd_sc_hd__decap_3
XTAP_TAPCELL_ROW_78_1036 VGND VPWR sky130_fd_sc_hd__tapvpwrvgnd_1
XFILLER_20_51 VGND VGND VPWR VPWR sky130_fd_sc_hd__decap_3
XFILLER_4_246 VGND VGND VPWR VPWR sky130_fd_sc_hd__decap_3
XFILLER_20_73 VGND VGND VPWR VPWR sky130_fd_sc_hd__decap_3
XFILLER_0_430 VGND VGND VPWR VPWR sky130_fd_sc_hd__decap_3
XFILLER_0_452 VGND VGND VPWR VPWR sky130_fd_sc_hd__decap_3
XFILLER_48_401 VGND VGND VPWR VPWR sky130_fd_sc_hd__fill_2
XFILLER_88_570 VGND VGND VPWR VPWR sky130_fd_sc_hd__decap_3
XFILLER_0_485 VGND VGND VPWR VPWR sky130_fd_sc_hd__decap_3
XFILLER_29_71 VGND VGND VPWR VPWR sky130_fd_sc_hd__decap_3
XFILLER_48_445 VGND VGND VPWR VPWR sky130_fd_sc_hd__decap_3
XFILLER_88_592 VGND VGND VPWR VPWR sky130_fd_sc_hd__decap_3
XTAP_TAPCELL_ROW_89_1154 VGND VPWR sky130_fd_sc_hd__tapvpwrvgnd_1
XFILLER_90_212 VGND VGND VPWR VPWR sky130_fd_sc_hd__decap_3
XPHY_EDGE_ROW_11_Left_112 VGND VGND VPWR VPWR sky130_fd_sc_hd__decap_3
XFILLER_16_320 VGND VGND VPWR VPWR sky130_fd_sc_hd__decap_3
XFILLER_28_191 VGND VGND VPWR VPWR sky130_fd_sc_hd__decap_3
XFILLER_90_256 VGND VGND VPWR VPWR sky130_fd_sc_hd__decap_3
XFILLER_16_353 VGND VGND VPWR VPWR sky130_fd_sc_hd__decap_3
XFILLER_43_150 VGND VGND VPWR VPWR sky130_fd_sc_hd__decap_3
XFILLER_45_70 VGND VGND VPWR VPWR sky130_fd_sc_hd__decap_3
XFILLER_50_109 VGND VGND VPWR VPWR sky130_fd_sc_hd__decap_3
XTAP_TAPCELL_ROW_74_999 VGND VPWR sky130_fd_sc_hd__tapvpwrvgnd_1
XFILLER_43_183 VGND VGND VPWR VPWR sky130_fd_sc_hd__fill_2
XFILLER_91_7 VGND VGND VPWR VPWR sky130_fd_sc_hd__fill_2
XFILLER_31_378 VGND VGND VPWR VPWR sky130_fd_sc_hd__decap_3
XFILLER_84_6 VGND VGND VPWR VPWR sky130_fd_sc_hd__decap_3
XFILLER_12_570 VGND VGND VPWR VPWR sky130_fd_sc_hd__decap_3
XFILLER_12_592 VGND VGND VPWR VPWR sky130_fd_sc_hd__fill_1
XANTENNA_2 input12/X VGND VGND VPWR VPWR sky130_fd_sc_hd__diode_2
XFILLER_8_585 VGND VGND VPWR VPWR sky130_fd_sc_hd__decap_3
X_4430_ _4431_/B _4431_/A VGND VGND VPWR VPWR _4430_/X sky130_fd_sc_hd__and2b_2
XPHY_EDGE_ROW_20_Left_121 VGND VGND VPWR VPWR sky130_fd_sc_hd__decap_3
XFILLER_6_64 VGND VGND VPWR VPWR sky130_fd_sc_hd__decap_3
X_6100_ _6100_/A _6100_/B VGND VGND VPWR VPWR _6748_/A sky130_fd_sc_hd__or2_2
X_4361_ _4617_/A _4483_/A _4361_/C _4361_/D VGND VGND VPWR VPWR _4364_/A sky130_fd_sc_hd__and4_2
XFILLER_98_312 VGND VGND VPWR VPWR sky130_fd_sc_hd__decap_3
X_4292_ _4304_/A _4304_/B VGND VGND VPWR VPWR _4305_/A sky130_fd_sc_hd__nor2_2
XFILLER_58_209 VGND VGND VPWR VPWR sky130_fd_sc_hd__decap_3
X_6031_ _6031_/A _6031_/B VGND VGND VPWR VPWR _6032_/B sky130_fd_sc_hd__xnor2_2
XFILLER_66_253 VGND VGND VPWR VPWR sky130_fd_sc_hd__decap_3
XTAP_TAPCELL_ROW_65_900 VGND VPWR sky130_fd_sc_hd__tapvpwrvgnd_1
XFILLER_94_551 VGND VGND VPWR VPWR sky130_fd_sc_hd__fill_2
XFILLER_66_264 VGND VGND VPWR VPWR sky130_fd_sc_hd__decap_3
XFILLER_66_297 VGND VGND VPWR VPWR sky130_fd_sc_hd__decap_3
XTAP_TAPCELL_ROW_37_602 VGND VPWR sky130_fd_sc_hd__tapvpwrvgnd_1
XTAP_TAPCELL_ROW_1_227 VGND VPWR sky130_fd_sc_hd__tapvpwrvgnd_1
XFILLER_54_448 VGND VGND VPWR VPWR sky130_fd_sc_hd__decap_3
XFILLER_81_223 VGND VGND VPWR VPWR sky130_fd_sc_hd__fill_1
XFILLER_81_234 VGND VGND VPWR VPWR sky130_fd_sc_hd__decap_3
X_6933_ _6203_/X _6919_/X _6920_/Y _6932_/X VGND VGND VPWR VPWR _6933_/X sky130_fd_sc_hd__o31a_2
XFILLER_22_301 VGND VGND VPWR VPWR sky130_fd_sc_hd__decap_3
X_6864_ _4900_/A _6928_/A2 _6928_/B1 _6860_/A _6863_/X VGND VGND VPWR VPWR _6864_/Y
+ sky130_fd_sc_hd__o221ai_2
XFILLER_22_312 VGND VGND VPWR VPWR sky130_fd_sc_hd__decap_3
XFILLER_34_183 VGND VGND VPWR VPWR sky130_fd_sc_hd__fill_1
X_5815_ _5720_/Y _5813_/X _6650_/B _5719_/X VGND VGND VPWR VPWR _5815_/X sky130_fd_sc_hd__a211o_4
XTAP_TAPCELL_ROW_45_690 VGND VPWR sky130_fd_sc_hd__tapvpwrvgnd_1
X_6795_ _6795_/A _6795_/B VGND VGND VPWR VPWR _6795_/Y sky130_fd_sc_hd__xnor2_2
XTAP_TAPCELL_ROW_17_392 VGND VPWR sky130_fd_sc_hd__tapvpwrvgnd_1
XFILLER_10_518 VGND VGND VPWR VPWR sky130_fd_sc_hd__fill_2
XFILLER_10_529 VGND VGND VPWR VPWR sky130_fd_sc_hd__decap_3
X_5746_ _5746_/A _5746_/B VGND VGND VPWR VPWR _5746_/X sky130_fd_sc_hd__xor2_2
X_5677_ _5678_/A _5678_/B _5711_/B _5678_/D VGND VGND VPWR VPWR _5681_/A sky130_fd_sc_hd__and4_2
X_4628_ _4925_/A _4925_/B _4628_/C _4646_/C VGND VGND VPWR VPWR _4631_/A sky130_fd_sc_hd__and4_2
XTAP_TAPCELL_ROW_9_316 VGND VPWR sky130_fd_sc_hd__tapvpwrvgnd_1
XFILLER_89_323 VGND VGND VPWR VPWR sky130_fd_sc_hd__decap_3
X_4559_ _4499_/X _4558_/X _4441_/X _4453_/Y VGND VGND VPWR VPWR _4559_/X sky130_fd_sc_hd__a211o_4
XFILLER_77_518 VGND VGND VPWR VPWR sky130_fd_sc_hd__fill_1
XFILLER_89_389 VGND VGND VPWR VPWR sky130_fd_sc_hd__decap_3
X_6229_ _6229_/A _6229_/B VGND VGND VPWR VPWR _6229_/X sky130_fd_sc_hd__or2_2
XFILLER_66_36 VGND VGND VPWR VPWR sky130_fd_sc_hd__decap_3
XFILLER_57_231 VGND VGND VPWR VPWR sky130_fd_sc_hd__decap_3
XFILLER_57_253 VGND VGND VPWR VPWR sky130_fd_sc_hd__decap_3
XFILLER_72_212 VGND VGND VPWR VPWR sky130_fd_sc_hd__decap_3
XFILLER_72_256 VGND VGND VPWR VPWR sky130_fd_sc_hd__decap_3
XFILLER_82_35 VGND VGND VPWR VPWR sky130_fd_sc_hd__decap_3
XFILLER_15_40 VGND VGND VPWR VPWR sky130_fd_sc_hd__decap_3
XFILLER_25_172 VGND VGND VPWR VPWR sky130_fd_sc_hd__fill_1
XFILLER_82_79 VGND VGND VPWR VPWR sky130_fd_sc_hd__decap_3
XTAP_TAPCELL_ROW_71_958 VGND VPWR sky130_fd_sc_hd__tapvpwrvgnd_1
XFILLER_15_73 VGND VGND VPWR VPWR sky130_fd_sc_hd__decap_3
XFILLER_40_120 VGND VGND VPWR VPWR sky130_fd_sc_hd__decap_3
XTAP_TAPCELL_ROW_84_1095 VGND VPWR sky130_fd_sc_hd__tapvpwrvgnd_1
XFILLER_9_305 VGND VGND VPWR VPWR sky130_fd_sc_hd__decap_3
XFILLER_5_511 VGND VGND VPWR VPWR sky130_fd_sc_hd__fill_2
Xrebuffer693 _5818_/Y VGND VGND VPWR VPWR _6705_/B1 sky130_fd_sc_hd__buf_6
Xrebuffer682 _5740_/A VGND VGND VPWR VPWR _5717_/A sky130_fd_sc_hd__buf_2
Xoutput94 _6994_/C VGND VGND VPWR VPWR result[30] sky130_fd_sc_hd__buf_6
Xoutput83 _6984_/C VGND VGND VPWR VPWR result[20] sky130_fd_sc_hd__buf_4
Xoutput72 _6987_/C VGND VGND VPWR VPWR result[10] sky130_fd_sc_hd__clkbuf_2
XFILLER_0_260 VGND VGND VPWR VPWR sky130_fd_sc_hd__decap_3
XFILLER_95_337 VGND VGND VPWR VPWR sky130_fd_sc_hd__fill_2
XFILLER_0_293 VGND VGND VPWR VPWR sky130_fd_sc_hd__decap_3
XFILLER_48_242 VGND VGND VPWR VPWR sky130_fd_sc_hd__decap_3
XFILLER_36_415 VGND VGND VPWR VPWR sky130_fd_sc_hd__decap_3
XFILLER_48_275 VGND VGND VPWR VPWR sky130_fd_sc_hd__fill_2
XFILLER_48_286 VGND VGND VPWR VPWR sky130_fd_sc_hd__decap_3
XFILLER_63_212 VGND VGND VPWR VPWR sky130_fd_sc_hd__decap_3
XFILLER_76_573 VGND VGND VPWR VPWR sky130_fd_sc_hd__decap_3
XFILLER_76_595 VGND VGND VPWR VPWR sky130_fd_sc_hd__decap_3
XFILLER_91_521 VGND VGND VPWR VPWR sky130_fd_sc_hd__fill_2
XFILLER_56_91 VGND VGND VPWR VPWR sky130_fd_sc_hd__decap_3
XFILLER_63_234 VGND VGND VPWR VPWR sky130_fd_sc_hd__decap_3
XFILLER_63_267 VGND VGND VPWR VPWR sky130_fd_sc_hd__decap_3
X_3930_ _3930_/A _3930_/B VGND VGND VPWR VPWR _3932_/C sky130_fd_sc_hd__xnor2_2
XFILLER_16_161 VGND VGND VPWR VPWR sky130_fd_sc_hd__decap_3
X_3861_ _3861_/A _3861_/B _3861_/C VGND VGND VPWR VPWR _3861_/Y sky130_fd_sc_hd__nor3_2
XFILLER_31_164 VGND VGND VPWR VPWR sky130_fd_sc_hd__decap_3
XFILLER_82_3 VGND VGND VPWR VPWR sky130_fd_sc_hd__decap_3
X_6580_ _6580_/A _6580_/B _6564_/X _6566_/X VGND VGND VPWR VPWR _6580_/X sky130_fd_sc_hd__or4bb_2
X_5600_ _5600_/A _5600_/B VGND VGND VPWR VPWR _5639_/B sky130_fd_sc_hd__xnor2_2
X_3792_ _3969_/A _5976_/A VGND VGND VPWR VPWR _3796_/A sky130_fd_sc_hd__nand2_2
XTAP_TAPCELL_ROW_42_660 VGND VPWR sky130_fd_sc_hd__tapvpwrvgnd_1
XTAP_TAPCELL_ROW_14_362 VGND VPWR sky130_fd_sc_hd__tapvpwrvgnd_1
X_5531_ _5701_/A _5695_/C _6121_/B _5588_/A VGND VGND VPWR VPWR _5532_/D sky130_fd_sc_hd__a22o_2
X_5462_ _5462_/A _5462_/B _5462_/C VGND VGND VPWR VPWR _5846_/A sky130_fd_sc_hd__and3_4
X_5393_ _5393_/A _5393_/B _5393_/C VGND VGND VPWR VPWR _5414_/A sky130_fd_sc_hd__or3_4
X_4413_ _4397_/A _4397_/C _4397_/B VGND VGND VPWR VPWR _4413_/Y sky130_fd_sc_hd__a21oi_2
X_4344_ _4344_/A _4344_/B VGND VGND VPWR VPWR _4466_/A sky130_fd_sc_hd__xor2_2
XFILLER_98_120 VGND VGND VPWR VPWR sky130_fd_sc_hd__decap_3
Xfanout306 _6545_/A VGND VGND VPWR VPWR _5953_/A2 sky130_fd_sc_hd__buf_4
Xfanout328 _6079_/A VGND VGND VPWR VPWR _3551_/A2 sky130_fd_sc_hd__clkdlybuf4s25_1
Xfanout339 _6266_/A VGND VGND VPWR VPWR _4457_/D sky130_fd_sc_hd__clkbuf_2
XFILLER_100_103 VGND VGND VPWR VPWR sky130_fd_sc_hd__fill_1
XFILLER_86_326 VGND VGND VPWR VPWR sky130_fd_sc_hd__decap_3
X_6014_ _6014_/A _6014_/B _6014_/C _6014_/D VGND VGND VPWR VPWR _6021_/B sky130_fd_sc_hd__and4_2
X_4275_ _4518_/A _4517_/C _4517_/D _4524_/A VGND VGND VPWR VPWR _4276_/B sky130_fd_sc_hd__a22o_2
XFILLER_39_231 VGND VGND VPWR VPWR sky130_fd_sc_hd__decap_3
XFILLER_100_169 VGND VGND VPWR VPWR sky130_fd_sc_hd__decap_3
XFILLER_27_426 VGND VGND VPWR VPWR sky130_fd_sc_hd__decap_3
XFILLER_39_275 VGND VGND VPWR VPWR sky130_fd_sc_hd__decap_3
XFILLER_82_510 VGND VGND VPWR VPWR sky130_fd_sc_hd__decap_3
X_6916_ _6904_/A _6979_/B1 _6912_/X _6915_/X VGND VGND VPWR VPWR _6916_/X sky130_fd_sc_hd__o211a_2
XFILLER_52_27 VGND VGND VPWR VPWR sky130_fd_sc_hd__fill_1
X_6847_ _6016_/D _3941_/C _3941_/A _6089_/B _6405_/S _6876_/S1 VGND VGND VPWR VPWR
+ _6847_/X sky130_fd_sc_hd__mux4_2
XFILLER_10_315 VGND VGND VPWR VPWR sky130_fd_sc_hd__decap_3
XFILLER_22_153 VGND VGND VPWR VPWR sky130_fd_sc_hd__decap_3
XFILLER_52_49 VGND VGND VPWR VPWR sky130_fd_sc_hd__fill_2
X_6778_ _6209_/A _6159_/X _6778_/B1 VGND VGND VPWR VPWR _6778_/X sky130_fd_sc_hd__a21o_2
XFILLER_22_197 VGND VGND VPWR VPWR sky130_fd_sc_hd__decap_3
XFILLER_50_495 VGND VGND VPWR VPWR sky130_fd_sc_hd__decap_3
X_5729_ _5726_/X _5729_/B VGND VGND VPWR VPWR _5761_/B sky130_fd_sc_hd__nand2b_2
XTAP_TAPCELL_ROW_75_1006 VGND VPWR sky130_fd_sc_hd__tapvpwrvgnd_1
XFILLER_2_536 VGND VGND VPWR VPWR sky130_fd_sc_hd__fill_1
XFILLER_77_46 VGND VGND VPWR VPWR sky130_fd_sc_hd__fill_1
XFILLER_89_164 VGND VGND VPWR VPWR sky130_fd_sc_hd__decap_3
XFILLER_77_326 VGND VGND VPWR VPWR sky130_fd_sc_hd__decap_3
XFILLER_77_337 VGND VGND VPWR VPWR sky130_fd_sc_hd__fill_2
XFILLER_77_79 VGND VGND VPWR VPWR sky130_fd_sc_hd__decap_3
XFILLER_89_197 VGND VGND VPWR VPWR sky130_fd_sc_hd__decap_3
XFILLER_58_551 VGND VGND VPWR VPWR sky130_fd_sc_hd__decap_3
XFILLER_77_359 VGND VGND VPWR VPWR sky130_fd_sc_hd__decap_3
XFILLER_18_404 VGND VGND VPWR VPWR sky130_fd_sc_hd__decap_3
XFILLER_58_573 VGND VGND VPWR VPWR sky130_fd_sc_hd__decap_3
XFILLER_92_329 VGND VGND VPWR VPWR sky130_fd_sc_hd__decap_3
XTAP_TAPCELL_ROW_48_719 VGND VPWR sky130_fd_sc_hd__tapvpwrvgnd_1
XFILLER_18_459 VGND VGND VPWR VPWR sky130_fd_sc_hd__decap_3
XFILLER_45_234 VGND VGND VPWR VPWR sky130_fd_sc_hd__decap_3
XFILLER_85_381 VGND VGND VPWR VPWR sky130_fd_sc_hd__decap_3
XTAP_TAPCELL_ROW_86_1124 VGND VPWR sky130_fd_sc_hd__tapvpwrvgnd_1
XFILLER_26_50 VGND VGND VPWR VPWR sky130_fd_sc_hd__decap_3
XFILLER_60_237 VGND VGND VPWR VPWR sky130_fd_sc_hd__decap_3
XFILLER_9_113 VGND VGND VPWR VPWR sky130_fd_sc_hd__fill_2
XTAP_TAPCELL_ROW_11_332 VGND VPWR sky130_fd_sc_hd__tapvpwrvgnd_1
XTAP_TAPCELL_ROW_97_1231 VGND VPWR sky130_fd_sc_hd__tapvpwrvgnd_1
XFILLER_5_330 VGND VGND VPWR VPWR sky130_fd_sc_hd__fill_2
XFILLER_5_385 VGND VGND VPWR VPWR sky130_fd_sc_hd__fill_2
XFILLER_3_76 VGND VGND VPWR VPWR sky130_fd_sc_hd__decap_3
X_4060_ _4060_/A _4060_/B VGND VGND VPWR VPWR _4081_/A sky130_fd_sc_hd__xor2_2
XFILLER_64_510 VGND VGND VPWR VPWR sky130_fd_sc_hd__decap_3
XTAP_TAPCELL_ROW_19_421 VGND VPWR sky130_fd_sc_hd__tapvpwrvgnd_1
XFILLER_91_340 VGND VGND VPWR VPWR sky130_fd_sc_hd__decap_3
XFILLER_91_373 VGND VGND VPWR VPWR sky130_fd_sc_hd__fill_2
X_4962_ _5151_/B _4757_/B _4758_/A _4757_/D VGND VGND VPWR VPWR _4963_/C sky130_fd_sc_hd__a22o_4
X_6701_ _6699_/X _6700_/Y _6764_/A VGND VGND VPWR VPWR _6701_/X sky130_fd_sc_hd__a21o_2
X_4893_ _4516_/X _4530_/Y _4859_/A _4529_/A VGND VGND VPWR VPWR _4893_/X sky130_fd_sc_hd__o211a_2
X_3913_ _3913_/A _3913_/B VGND VGND VPWR VPWR _3916_/C sky130_fd_sc_hd__xnor2_2
X_6632_ _6632_/A _6632_/B _6632_/C _6632_/D VGND VGND VPWR VPWR _6987_/B sky130_fd_sc_hd__or4_4
X_3844_ _3952_/B _3844_/B VGND VGND VPWR VPWR _3845_/B sky130_fd_sc_hd__nand2_2
X_6563_ _6381_/B _6134_/X wire161/A VGND VGND VPWR VPWR _6563_/Y sky130_fd_sc_hd__o21ai_2
X_3775_ _3775_/A _3775_/B VGND VGND VPWR VPWR _3776_/C sky130_fd_sc_hd__xnor2_2
X_6494_ _6589_/B _6731_/A _6493_/X VGND VGND VPWR VPWR _6494_/X sky130_fd_sc_hd__a21o_2
X_5514_ _5514_/A _5514_/B VGND VGND VPWR VPWR _5514_/Y sky130_fd_sc_hd__nand2_2
X_5445_ _5445_/A _5445_/B VGND VGND VPWR VPWR _5446_/B sky130_fd_sc_hd__nand2_2
XFILLER_59_304 VGND VGND VPWR VPWR sky130_fd_sc_hd__decap_3
X_5376_ _5377_/A _5377_/B _5377_/C VGND VGND VPWR VPWR _5376_/X sky130_fd_sc_hd__and3_2
XFILLER_59_337 VGND VGND VPWR VPWR sky130_fd_sc_hd__decap_3
XFILLER_86_112 VGND VGND VPWR VPWR sky130_fd_sc_hd__decap_3
Xfanout125 _6303_/Y VGND VGND VPWR VPWR _6961_/A1 sky130_fd_sc_hd__clkdlybuf4s25_1
Xfanout136 _6333_/X VGND VGND VPWR VPWR _6978_/B1 sky130_fd_sc_hd__clkdlybuf4s25_1
Xfanout147 _6062_/X VGND VGND VPWR VPWR _6841_/A sky130_fd_sc_hd__clkdlybuf4s25_1
X_4327_ _4327_/A _4327_/B VGND VGND VPWR VPWR _4448_/A sky130_fd_sc_hd__nand2_2
XFILLER_99_473 VGND VGND VPWR VPWR sky130_fd_sc_hd__decap_3
XFILLER_47_27 VGND VGND VPWR VPWR sky130_fd_sc_hd__fill_1
Xfanout158 wire161/A VGND VGND VPWR VPWR _6542_/A2 sky130_fd_sc_hd__clkdlybuf4s25_1
X_4258_ _4229_/Y _4253_/C _4256_/Y _4192_/X VGND VGND VPWR VPWR _4258_/Y sky130_fd_sc_hd__a211oi_2
XFILLER_47_38 VGND VGND VPWR VPWR sky130_fd_sc_hd__decap_3
XFILLER_74_318 VGND VGND VPWR VPWR sky130_fd_sc_hd__decap_3
XFILLER_86_189 VGND VGND VPWR VPWR sky130_fd_sc_hd__decap_3
X_4189_ _4189_/A _4189_/B _4304_/A VGND VGND VPWR VPWR _4190_/B sky130_fd_sc_hd__or3_2
XFILLER_55_554 VGND VGND VPWR VPWR sky130_fd_sc_hd__decap_3
XFILLER_82_362 VGND VGND VPWR VPWR sky130_fd_sc_hd__fill_2
XFILLER_27_278 VGND VGND VPWR VPWR sky130_fd_sc_hd__fill_2
XFILLER_63_26 VGND VGND VPWR VPWR sky130_fd_sc_hd__fill_2
XFILLER_63_48 VGND VGND VPWR VPWR sky130_fd_sc_hd__decap_3
XFILLER_70_524 VGND VGND VPWR VPWR sky130_fd_sc_hd__fill_2
XFILLER_42_248 VGND VGND VPWR VPWR sky130_fd_sc_hd__decap_3
XTAP_TAPCELL_ROW_81_1065 VGND VPWR sky130_fd_sc_hd__tapvpwrvgnd_1
XTAP_TAPCELL_ROW_53_777 VGND VPWR sky130_fd_sc_hd__tapvpwrvgnd_1
XTAP_TAPCELL_ROW_25_479 VGND VPWR sky130_fd_sc_hd__tapvpwrvgnd_1
XFILLER_6_105 VGND VGND VPWR VPWR sky130_fd_sc_hd__decap_3
XFILLER_6_149 VGND VGND VPWR VPWR sky130_fd_sc_hd__decap_3
Xload_slew509 _4607_/A VGND VGND VPWR VPWR _5999_/A1 sky130_fd_sc_hd__buf_4
XTAP_TAPCELL_ROW_92_1183 VGND VPWR sky130_fd_sc_hd__tapvpwrvgnd_1
XFILLER_77_145 VGND VGND VPWR VPWR sky130_fd_sc_hd__decap_3
XFILLER_65_318 VGND VGND VPWR VPWR sky130_fd_sc_hd__decap_3
XFILLER_77_167 VGND VGND VPWR VPWR sky130_fd_sc_hd__fill_1
XFILLER_92_115 VGND VGND VPWR VPWR sky130_fd_sc_hd__fill_2
XFILLER_58_392 VGND VGND VPWR VPWR sky130_fd_sc_hd__fill_1
XFILLER_18_256 VGND VGND VPWR VPWR sky130_fd_sc_hd__decap_3
XPHY_EDGE_ROW_16_Right_16 VGND VGND VPWR VPWR sky130_fd_sc_hd__decap_3
XFILLER_73_373 VGND VGND VPWR VPWR sky130_fd_sc_hd__decap_3
XFILLER_33_237 VGND VGND VPWR VPWR sky130_fd_sc_hd__decap_3
XFILLER_61_557 VGND VGND VPWR VPWR sky130_fd_sc_hd__decap_3
XFILLER_41_281 VGND VGND VPWR VPWR sky130_fd_sc_hd__decap_3
X_3560_ _3599_/A _3560_/B VGND VGND VPWR VPWR _3562_/B sky130_fd_sc_hd__or2_2
XPHY_EDGE_ROW_25_Right_25 VGND VGND VPWR VPWR sky130_fd_sc_hd__decap_3
X_5230_ _5286_/A _5284_/B VGND VGND VPWR VPWR _5453_/A sky130_fd_sc_hd__nand2_2
X_3491_ _5452_/A VGND VGND VPWR VPWR _6211_/A sky130_fd_sc_hd__inv_2
XFILLER_45_3 VGND VGND VPWR VPWR sky130_fd_sc_hd__decap_3
X_5161_ _5161_/A _5161_/B VGND VGND VPWR VPWR _5163_/B sky130_fd_sc_hd__xor2_2
XFILLER_96_421 VGND VGND VPWR VPWR sky130_fd_sc_hd__fill_1
X_5092_ _4998_/Y _5090_/X _5088_/Y _5089_/A VGND VGND VPWR VPWR _5092_/X sky130_fd_sc_hd__a211o_2
X_4112_ _3674_/A _3674_/B _3674_/C VGND VGND VPWR VPWR _4112_/X sky130_fd_sc_hd__o21a_2
XFILLER_56_318 VGND VGND VPWR VPWR sky130_fd_sc_hd__decap_3
XFILLER_68_167 VGND VGND VPWR VPWR sky130_fd_sc_hd__decap_3
X_4043_ _4043_/A _4043_/B VGND VGND VPWR VPWR _4049_/A sky130_fd_sc_hd__xnor2_2
XPHY_EDGE_ROW_3_Left_104 VGND VGND VPWR VPWR sky130_fd_sc_hd__decap_3
XFILLER_49_370 VGND VGND VPWR VPWR sky130_fd_sc_hd__decap_3
XFILLER_83_137 VGND VGND VPWR VPWR sky130_fd_sc_hd__decap_3
XPHY_EDGE_ROW_34_Right_34 VGND VGND VPWR VPWR sky130_fd_sc_hd__decap_3
XFILLER_37_554 VGND VGND VPWR VPWR sky130_fd_sc_hd__decap_3
XFILLER_64_351 VGND VGND VPWR VPWR sky130_fd_sc_hd__decap_3
XFILLER_52_513 VGND VGND VPWR VPWR sky130_fd_sc_hd__fill_1
XFILLER_64_395 VGND VGND VPWR VPWR sky130_fd_sc_hd__decap_3
X_5994_ _5994_/A _5994_/B VGND VGND VPWR VPWR _5998_/A sky130_fd_sc_hd__xor2_2
XFILLER_24_248 VGND VGND VPWR VPWR sky130_fd_sc_hd__decap_3
X_4945_ _5329_/A _5115_/B VGND VGND VPWR VPWR _4947_/B sky130_fd_sc_hd__nand2_2
XFILLER_20_432 VGND VGND VPWR VPWR sky130_fd_sc_hd__decap_3
X_4876_ _4876_/A _4876_/B _4876_/C _4876_/D VGND VGND VPWR VPWR _4876_/Y sky130_fd_sc_hd__nand4_2
XTAP_TAPCELL_ROW_50_747 VGND VPWR sky130_fd_sc_hd__tapvpwrvgnd_1
XTAP_TAPCELL_ROW_22_449 VGND VPWR sky130_fd_sc_hd__tapvpwrvgnd_1
X_6615_ _6615_/A1 _5812_/X _6614_/Y VGND VGND VPWR VPWR _6632_/D sky130_fd_sc_hd__o21a_2
X_3827_ _3938_/A _3827_/B VGND VGND VPWR VPWR _3830_/A sky130_fd_sc_hd__nor2_2
XPHY_EDGE_ROW_43_Right_43 VGND VGND VPWR VPWR sky130_fd_sc_hd__decap_3
X_6546_ _6832_/S _6417_/B _6545_/X _6589_/A VGND VGND VPWR VPWR _6546_/X sky130_fd_sc_hd__o211a_2
X_3758_ _3758_/A _4163_/A VGND VGND VPWR VPWR _3760_/B sky130_fd_sc_hd__nand2_2
X_6477_ _6356_/X _6358_/Y _6478_/S VGND VGND VPWR VPWR _6477_/X sky130_fd_sc_hd__mux2_1
X_3689_ _3707_/B VGND VGND VPWR VPWR _3717_/A sky130_fd_sc_hd__inv_2
X_5428_ _5428_/A _5428_/B _5428_/C VGND VGND VPWR VPWR _5428_/X sky130_fd_sc_hd__and3_2
XFILLER_58_15 VGND VGND VPWR VPWR sky130_fd_sc_hd__decap_3
X_5359_ _6102_/A _5582_/B VGND VGND VPWR VPWR _5375_/A sky130_fd_sc_hd__nand2_2
XFILLER_99_281 VGND VGND VPWR VPWR sky130_fd_sc_hd__decap_3
XFILLER_87_432 VGND VGND VPWR VPWR sky130_fd_sc_hd__decap_3
XPHY_EDGE_ROW_58_Left_159 VGND VGND VPWR VPWR sky130_fd_sc_hd__decap_3
XFILLER_47_318 VGND VGND VPWR VPWR sky130_fd_sc_hd__fill_2
XFILLER_59_178 VGND VGND VPWR VPWR sky130_fd_sc_hd__fill_1
XTAP_TAPCELL_ROW_58_825 VGND VPWR sky130_fd_sc_hd__tapvpwrvgnd_1
XPHY_EDGE_ROW_52_Right_52 VGND VGND VPWR VPWR sky130_fd_sc_hd__decap_3
XFILLER_74_159 VGND VGND VPWR VPWR sky130_fd_sc_hd__decap_3
XFILLER_15_215 VGND VGND VPWR VPWR sky130_fd_sc_hd__decap_3
XFILLER_55_384 VGND VGND VPWR VPWR sky130_fd_sc_hd__decap_3
XFILLER_74_69 VGND VGND VPWR VPWR sky130_fd_sc_hd__decap_3
XFILLER_82_170 VGND VGND VPWR VPWR sky130_fd_sc_hd__decap_3
XFILLER_43_546 VGND VGND VPWR VPWR sky130_fd_sc_hd__decap_3
XFILLER_30_218 VGND VGND VPWR VPWR sky130_fd_sc_hd__decap_3
XFILLER_70_376 VGND VGND VPWR VPWR sky130_fd_sc_hd__decap_3
XFILLER_23_270 VGND VGND VPWR VPWR sky130_fd_sc_hd__decap_3
XFILLER_23_281 VGND VGND VPWR VPWR sky130_fd_sc_hd__decap_3
XPHY_EDGE_ROW_67_Left_168 VGND VGND VPWR VPWR sky130_fd_sc_hd__decap_3
XPHY_EDGE_ROW_61_Right_61 VGND VGND VPWR VPWR sky130_fd_sc_hd__decap_3
XFILLER_11_443 VGND VGND VPWR VPWR sky130_fd_sc_hd__decap_3
XFILLER_7_469 VGND VGND VPWR VPWR sky130_fd_sc_hd__fill_2
XTAP_TAPCELL_ROW_94_1201 VGND VPWR sky130_fd_sc_hd__tapvpwrvgnd_1
XFILLER_99_44 VGND VGND VPWR VPWR sky130_fd_sc_hd__decap_3
XFILLER_99_88 VGND VGND VPWR VPWR sky130_fd_sc_hd__decap_3
XFILLER_31_9 VGND VGND VPWR VPWR sky130_fd_sc_hd__decap_3
XFILLER_78_421 VGND VGND VPWR VPWR sky130_fd_sc_hd__decap_3
Xload_slew317 _4767_/A VGND VGND VPWR VPWR _5152_/A sky130_fd_sc_hd__buf_4
XPHY_EDGE_ROW_76_Left_177 VGND VGND VPWR VPWR sky130_fd_sc_hd__decap_3
XPHY_EDGE_ROW_70_Right_70 VGND VGND VPWR VPWR sky130_fd_sc_hd__decap_3
XFILLER_78_454 VGND VGND VPWR VPWR sky130_fd_sc_hd__decap_3
XFILLER_38_318 VGND VGND VPWR VPWR sky130_fd_sc_hd__fill_1
XFILLER_93_402 VGND VGND VPWR VPWR sky130_fd_sc_hd__decap_3
XFILLER_65_137 VGND VGND VPWR VPWR sky130_fd_sc_hd__decap_3
XFILLER_93_446 VGND VGND VPWR VPWR sky130_fd_sc_hd__fill_2
XFILLER_93_479 VGND VGND VPWR VPWR sky130_fd_sc_hd__decap_3
XFILLER_46_384 VGND VGND VPWR VPWR sky130_fd_sc_hd__decap_3
XFILLER_0_99 VGND VGND VPWR VPWR sky130_fd_sc_hd__decap_3
XFILLER_34_557 VGND VGND VPWR VPWR sky130_fd_sc_hd__decap_3
XFILLER_64_91 VGND VGND VPWR VPWR sky130_fd_sc_hd__fill_1
XFILLER_73_181 VGND VGND VPWR VPWR sky130_fd_sc_hd__decap_3
XPHY_EDGE_ROW_85_Left_186 VGND VGND VPWR VPWR sky130_fd_sc_hd__decap_3
XFILLER_34_579 VGND VGND VPWR VPWR sky130_fd_sc_hd__fill_1
XFILLER_61_387 VGND VGND VPWR VPWR sky130_fd_sc_hd__decap_3
X_4730_ _4730_/A _4730_/B VGND VGND VPWR VPWR _4935_/B sky130_fd_sc_hd__nor2_2
X_4661_ _6238_/B _6106_/B VGND VGND VPWR VPWR _6141_/A sky130_fd_sc_hd__nand2_2
XFILLER_9_75 VGND VGND VPWR VPWR sky130_fd_sc_hd__decap_3
X_6400_ _6396_/X _6521_/B _6589_/B VGND VGND VPWR VPWR _6602_/B sky130_fd_sc_hd__mux2_1
X_3612_ _3613_/B _3652_/A _3613_/A VGND VGND VPWR VPWR _4054_/A sky130_fd_sc_hd__a21oi_2
X_6331_ _6331_/A _6331_/B VGND VGND VPWR VPWR _6331_/Y sky130_fd_sc_hd__nand2_2
X_4592_ _4592_/A _4592_/B VGND VGND VPWR VPWR _4596_/A sky130_fd_sc_hd__nand2_2
X_3543_ _4066_/B _4066_/A VGND VGND VPWR VPWR _3567_/A sky130_fd_sc_hd__and2b_2
X_6262_ _6258_/A _6794_/A _6386_/B VGND VGND VPWR VPWR _6874_/B sky130_fd_sc_hd__o21bai_2
XPHY_EDGE_ROW_94_Left_195 VGND VGND VPWR VPWR sky130_fd_sc_hd__decap_3
XFILLER_88_218 VGND VGND VPWR VPWR sky130_fd_sc_hd__decap_3
X_6193_ _6186_/Y _6192_/X _6931_/A _6904_/A VGND VGND VPWR VPWR _6193_/X sky130_fd_sc_hd__a211o_2
X_5213_ _5213_/A _5213_/B VGND VGND VPWR VPWR _5423_/B sky130_fd_sc_hd__xnor2_2
X_5144_ _5142_/A _5200_/A _5126_/X _5143_/Y VGND VGND VPWR VPWR _5144_/Y sky130_fd_sc_hd__a211oi_4
XFILLER_96_240 VGND VGND VPWR VPWR sky130_fd_sc_hd__decap_3
XFILLER_56_115 VGND VGND VPWR VPWR sky130_fd_sc_hd__fill_1
XFILLER_84_424 VGND VGND VPWR VPWR sky130_fd_sc_hd__decap_3
X_5075_ _5075_/A _5075_/B VGND VGND VPWR VPWR _5150_/B sky130_fd_sc_hd__xnor2_2
XFILLER_37_340 VGND VGND VPWR VPWR sky130_fd_sc_hd__fill_2
XFILLER_56_159 VGND VGND VPWR VPWR sky130_fd_sc_hd__decap_3
XFILLER_84_457 VGND VGND VPWR VPWR sky130_fd_sc_hd__decap_3
X_4026_ _4026_/A _4026_/B _4026_/C VGND VGND VPWR VPWR _4028_/A sky130_fd_sc_hd__and3_2
XFILLER_25_502 VGND VGND VPWR VPWR sky130_fd_sc_hd__fill_2
XFILLER_64_170 VGND VGND VPWR VPWR sky130_fd_sc_hd__decap_3
XFILLER_25_546 VGND VGND VPWR VPWR sky130_fd_sc_hd__decap_3
X_5977_ _5977_/A _5977_/B VGND VGND VPWR VPWR _5979_/A sky130_fd_sc_hd__nand2_2
XTAP_TAPCELL_ROW_63_883 VGND VPWR sky130_fd_sc_hd__tapvpwrvgnd_1
X_4928_ _4925_/X _4928_/B VGND VGND VPWR VPWR _5020_/B sky130_fd_sc_hd__and2b_2
XTAP_TAPCELL_ROW_35_585 VGND VPWR sky130_fd_sc_hd__tapvpwrvgnd_1
XFILLER_20_251 VGND VGND VPWR VPWR sky130_fd_sc_hd__fill_1
XFILLER_20_262 VGND VGND VPWR VPWR sky130_fd_sc_hd__decap_3
XFILLER_60_49 VGND VGND VPWR VPWR sky130_fd_sc_hd__decap_3
X_4859_ _4859_/A _4859_/B _4859_/C VGND VGND VPWR VPWR _4860_/A sky130_fd_sc_hd__and3_2
X_6529_ _6625_/A _6731_/A VGND VGND VPWR VPWR _6867_/A sky130_fd_sc_hd__nand2_2
XFILLER_79_218 VGND VGND VPWR VPWR sky130_fd_sc_hd__decap_3
XFILLER_75_413 VGND VGND VPWR VPWR sky130_fd_sc_hd__decap_3
XTAP_TAPCELL_ROW_7_288 VGND VPWR sky130_fd_sc_hd__tapvpwrvgnd_1
XFILLER_85_46 VGND VGND VPWR VPWR sky130_fd_sc_hd__decap_3
XFILLER_85_57 VGND VGND VPWR VPWR sky130_fd_sc_hd__decap_3
XFILLER_87_295 VGND VGND VPWR VPWR sky130_fd_sc_hd__decap_3
XFILLER_28_340 VGND VGND VPWR VPWR sky130_fd_sc_hd__decap_3
XFILLER_43_310 VGND VGND VPWR VPWR sky130_fd_sc_hd__fill_1
XFILLER_62_129 VGND VGND VPWR VPWR sky130_fd_sc_hd__fill_2
XFILLER_90_438 VGND VGND VPWR VPWR sky130_fd_sc_hd__decap_3
XFILLER_55_181 VGND VGND VPWR VPWR sky130_fd_sc_hd__decap_3
XFILLER_31_505 VGND VGND VPWR VPWR sky130_fd_sc_hd__decap_3
XFILLER_70_162 VGND VGND VPWR VPWR sky130_fd_sc_hd__decap_3
XFILLER_31_538 VGND VGND VPWR VPWR sky130_fd_sc_hd__decap_3
XFILLER_70_195 VGND VGND VPWR VPWR sky130_fd_sc_hd__fill_1
XFILLER_34_83 VGND VGND VPWR VPWR sky130_fd_sc_hd__fill_1
XFILLER_34_94 VGND VGND VPWR VPWR sky130_fd_sc_hd__decap_3
XFILLER_50_60 VGND VGND VPWR VPWR sky130_fd_sc_hd__fill_2
XFILLER_7_233 VGND VGND VPWR VPWR sky130_fd_sc_hd__decap_3
XFILLER_7_255 VGND VGND VPWR VPWR sky130_fd_sc_hd__fill_1
XFILLER_7_277 VGND VGND VPWR VPWR sky130_fd_sc_hd__decap_3
XFILLER_78_251 VGND VGND VPWR VPWR sky130_fd_sc_hd__fill_1
Xload_slew169 _6317_/S VGND VGND VPWR VPWR _6832_/S sky130_fd_sc_hd__buf_4
XFILLER_38_137 VGND VGND VPWR VPWR sky130_fd_sc_hd__decap_3
XFILLER_66_413 VGND VGND VPWR VPWR sky130_fd_sc_hd__decap_3
XFILLER_66_424 VGND VGND VPWR VPWR sky130_fd_sc_hd__fill_2
XFILLER_66_446 VGND VGND VPWR VPWR sky130_fd_sc_hd__decap_3
XFILLER_78_273 VGND VGND VPWR VPWR sky130_fd_sc_hd__decap_3
XFILLER_38_148 VGND VGND VPWR VPWR sky130_fd_sc_hd__fill_1
XFILLER_93_254 VGND VGND VPWR VPWR sky130_fd_sc_hd__decap_3
XFILLER_75_90 VGND VGND VPWR VPWR sky130_fd_sc_hd__decap_3
XFILLER_93_287 VGND VGND VPWR VPWR sky130_fd_sc_hd__decap_3
X_5900_ _5892_/X _5893_/Y _5896_/Y _5898_/X VGND VGND VPWR VPWR _5900_/Y sky130_fd_sc_hd__o211ai_2
XFILLER_46_170 VGND VGND VPWR VPWR sky130_fd_sc_hd__decap_3
XFILLER_81_449 VGND VGND VPWR VPWR sky130_fd_sc_hd__decap_3
X_6880_ _6313_/Y _6337_/Y _6506_/B _6190_/C _6879_/X VGND VGND VPWR VPWR _6880_/X
+ sky130_fd_sc_hd__o221a_2
XFILLER_34_365 VGND VGND VPWR VPWR sky130_fd_sc_hd__decap_3
X_5831_ _5831_/A _5831_/B _5846_/B VGND VGND VPWR VPWR _5831_/Y sky130_fd_sc_hd__nor3_4
X_5762_ _5778_/B _6121_/B _5778_/C _5778_/A VGND VGND VPWR VPWR _5763_/D sky130_fd_sc_hd__a22o_2
X_4713_ _4713_/A _4713_/B _4713_/C VGND VGND VPWR VPWR _4942_/A sky130_fd_sc_hd__nand3_2
XTAP_TAPCELL_ROW_60_842 VGND VPWR sky130_fd_sc_hd__tapvpwrvgnd_1
XTAP_TAPCELL_ROW_32_555 VGND VPWR sky130_fd_sc_hd__tapvpwrvgnd_1
XFILLER_30_571 VGND VGND VPWR VPWR sky130_fd_sc_hd__decap_3
X_5693_ _5670_/A _5670_/C _5670_/B VGND VGND VPWR VPWR _5705_/B sky130_fd_sc_hd__o21ai_2
X_4644_ _4643_/C _4643_/B _4643_/A VGND VGND VPWR VPWR _4644_/Y sky130_fd_sc_hd__o21ai_2
X_4575_ _4576_/B _4576_/A VGND VGND VPWR VPWR _4575_/X sky130_fd_sc_hd__and2b_2
X_6314_ _6363_/A _6314_/B VGND VGND VPWR VPWR _6746_/A sky130_fd_sc_hd__or2_2
X_3526_ _3527_/B _3527_/A VGND VGND VPWR VPWR _3531_/B sky130_fd_sc_hd__and2b_2
X_6245_ _6384_/B _6707_/B _6244_/Y VGND VGND VPWR VPWR _6725_/B sky130_fd_sc_hd__o21a_2
XFILLER_39_39 VGND VGND VPWR VPWR sky130_fd_sc_hd__fill_1
XFILLER_69_240 VGND VGND VPWR VPWR sky130_fd_sc_hd__decap_3
X_6176_ _6176_/A _6176_/B VGND VGND VPWR VPWR _6931_/A sky130_fd_sc_hd__nand2_2
XFILLER_69_273 VGND VGND VPWR VPWR sky130_fd_sc_hd__decap_3
XFILLER_69_284 VGND VGND VPWR VPWR sky130_fd_sc_hd__decap_3
Xload_slew670 _4088_/B VGND VGND VPWR VPWR _4457_/B sky130_fd_sc_hd__buf_4
X_5127_ _5340_/A _5311_/A _5341_/C _5341_/D VGND VGND VPWR VPWR _5127_/X sky130_fd_sc_hd__and4_2
XTAP_TAPCELL_ROW_68_931 VGND VPWR sky130_fd_sc_hd__tapvpwrvgnd_1
XFILLER_57_479 VGND VGND VPWR VPWR sky130_fd_sc_hd__decap_3
XFILLER_84_232 VGND VGND VPWR VPWR sky130_fd_sc_hd__decap_3
X_5058_ _5052_/A _5052_/C _5052_/B VGND VGND VPWR VPWR _5059_/B sky130_fd_sc_hd__a21o_4
XTAP_TAPCELL_ROW_4_258 VGND VPWR sky130_fd_sc_hd__tapvpwrvgnd_1
XPHY_EDGE_ROW_2_Right_2 VGND VGND VPWR VPWR sky130_fd_sc_hd__decap_3
XFILLER_44_129 VGND VGND VPWR VPWR sky130_fd_sc_hd__decap_3
XFILLER_55_38 VGND VGND VPWR VPWR sky130_fd_sc_hd__decap_3
XFILLER_72_416 VGND VGND VPWR VPWR sky130_fd_sc_hd__decap_3
XFILLER_72_427 VGND VGND VPWR VPWR sky130_fd_sc_hd__fill_2
XFILLER_84_265 VGND VGND VPWR VPWR sky130_fd_sc_hd__decap_3
XFILLER_84_287 VGND VGND VPWR VPWR sky130_fd_sc_hd__fill_2
X_4009_ _4009_/A _4009_/B VGND VGND VPWR VPWR _4022_/A sky130_fd_sc_hd__xor2_2
XFILLER_25_343 VGND VGND VPWR VPWR sky130_fd_sc_hd__decap_3
XFILLER_72_449 VGND VGND VPWR VPWR sky130_fd_sc_hd__decap_3
XFILLER_25_376 VGND VGND VPWR VPWR sky130_fd_sc_hd__fill_1
XFILLER_25_387 VGND VGND VPWR VPWR sky130_fd_sc_hd__decap_3
XFILLER_40_324 VGND VGND VPWR VPWR sky130_fd_sc_hd__fill_1
XFILLER_52_195 VGND VGND VPWR VPWR sky130_fd_sc_hd__fill_1
XFILLER_40_357 VGND VGND VPWR VPWR sky130_fd_sc_hd__decap_3
XFILLER_71_48 VGND VGND VPWR VPWR sky130_fd_sc_hd__decap_3
XTAP_TAPCELL_ROW_78_1037 VGND VPWR sky130_fd_sc_hd__tapvpwrvgnd_1
XFILLER_4_269 VGND VGND VPWR VPWR sky130_fd_sc_hd__decap_3
XFILLER_0_464 VGND VGND VPWR VPWR sky130_fd_sc_hd__decap_3
XFILLER_95_508 VGND VGND VPWR VPWR sky130_fd_sc_hd__fill_1
XFILLER_0_497 VGND VGND VPWR VPWR sky130_fd_sc_hd__decap_3
XFILLER_48_424 VGND VGND VPWR VPWR sky130_fd_sc_hd__decap_3
XFILLER_88_582 VGND VGND VPWR VPWR sky130_fd_sc_hd__decap_3
XFILLER_29_83 VGND VGND VPWR VPWR sky130_fd_sc_hd__decap_3
XFILLER_48_457 VGND VGND VPWR VPWR sky130_fd_sc_hd__fill_2
XTAP_TAPCELL_ROW_89_1155 VGND VPWR sky130_fd_sc_hd__tapvpwrvgnd_1
XFILLER_75_276 VGND VGND VPWR VPWR sky130_fd_sc_hd__decap_3
XFILLER_75_287 VGND VGND VPWR VPWR sky130_fd_sc_hd__decap_3
XFILLER_28_170 VGND VGND VPWR VPWR sky130_fd_sc_hd__decap_3
XFILLER_90_224 VGND VGND VPWR VPWR sky130_fd_sc_hd__decap_3
XFILLER_90_268 VGND VGND VPWR VPWR sky130_fd_sc_hd__decap_3
XTAP_TAPCELL_ROW_74_989 VGND VPWR sky130_fd_sc_hd__tapvpwrvgnd_1
XFILLER_31_324 VGND VGND VPWR VPWR sky130_fd_sc_hd__fill_2
XFILLER_43_162 VGND VGND VPWR VPWR sky130_fd_sc_hd__decap_3
XFILLER_61_81 VGND VGND VPWR VPWR sky130_fd_sc_hd__decap_3
XFILLER_8_553 VGND VGND VPWR VPWR sky130_fd_sc_hd__decap_3
XANTENNA_3 input12/X VGND VGND VPWR VPWR sky130_fd_sc_hd__diode_2
X_4360_ _4360_/A _4360_/B _4360_/C VGND VGND VPWR VPWR _4368_/A sky130_fd_sc_hd__nand3_2
X_4291_ _4432_/A _4568_/B _4187_/C VGND VGND VPWR VPWR _4304_/B sky130_fd_sc_hd__a21oi_2
XFILLER_98_357 VGND VGND VPWR VPWR sky130_fd_sc_hd__fill_2
X_6030_ _6030_/A _6030_/B VGND VGND VPWR VPWR _6031_/B sky130_fd_sc_hd__xnor2_2
XFILLER_100_318 VGND VGND VPWR VPWR sky130_fd_sc_hd__decap_3
XFILLER_39_413 VGND VGND VPWR VPWR sky130_fd_sc_hd__decap_3
XFILLER_39_468 VGND VGND VPWR VPWR sky130_fd_sc_hd__fill_2
XFILLER_66_221 VGND VGND VPWR VPWR sky130_fd_sc_hd__decap_3
XFILLER_54_427 VGND VGND VPWR VPWR sky130_fd_sc_hd__decap_3
XFILLER_81_202 VGND VGND VPWR VPWR sky130_fd_sc_hd__decap_3
XTAP_TAPCELL_ROW_65_901 VGND VPWR sky130_fd_sc_hd__tapvpwrvgnd_1
XTAP_TAPCELL_ROW_37_603 VGND VPWR sky130_fd_sc_hd__tapvpwrvgnd_1
XTAP_TAPCELL_ROW_1_228 VGND VPWR sky130_fd_sc_hd__tapvpwrvgnd_1
XFILLER_94_585 VGND VGND VPWR VPWR sky130_fd_sc_hd__decap_3
X_6932_ _6932_/A _6932_/B _6931_/X VGND VGND VPWR VPWR _6932_/X sky130_fd_sc_hd__or3b_2
XFILLER_81_279 VGND VGND VPWR VPWR sky130_fd_sc_hd__fill_1
X_6863_ _6076_/Y _6963_/A2 _6927_/B1 _6170_/A VGND VGND VPWR VPWR _6863_/X sky130_fd_sc_hd__o22a_2
X_5814_ _5720_/Y _5813_/X _5719_/X VGND VGND VPWR VPWR _6650_/C sky130_fd_sc_hd__a21oi_2
XFILLER_10_508 VGND VGND VPWR VPWR sky130_fd_sc_hd__decap_3
XFILLER_22_346 VGND VGND VPWR VPWR sky130_fd_sc_hd__decap_3
X_6794_ _6794_/A _6794_/B VGND VGND VPWR VPWR _6794_/Y sky130_fd_sc_hd__nor2_2
XTAP_TAPCELL_ROW_45_691 VGND VPWR sky130_fd_sc_hd__tapvpwrvgnd_1
XTAP_TAPCELL_ROW_17_393 VGND VPWR sky130_fd_sc_hd__tapvpwrvgnd_1
X_5745_ _5746_/A _5745_/B VGND VGND VPWR VPWR _5745_/Y sky130_fd_sc_hd__nor2_2
X_5676_ _5716_/B _5638_/C _5638_/A VGND VGND VPWR VPWR _5678_/D sky130_fd_sc_hd__a21o_2
X_4627_ _4627_/A _4627_/B VGND VGND VPWR VPWR _4642_/A sky130_fd_sc_hd__or2_4
XFILLER_89_302 VGND VGND VPWR VPWR sky130_fd_sc_hd__decap_3
X_4558_ _4558_/A _4558_/B _4558_/C _4558_/D VGND VGND VPWR VPWR _4558_/X sky130_fd_sc_hd__or4_4
X_4489_ _4489_/A _4841_/A VGND VGND VPWR VPWR _4491_/C sky130_fd_sc_hd__nand2_2
X_3509_ _3507_/X _3509_/B VGND VGND VPWR VPWR _3510_/B sky130_fd_sc_hd__and2b_2
XFILLER_89_357 VGND VGND VPWR VPWR sky130_fd_sc_hd__decap_3
XFILLER_89_379 VGND VGND VPWR VPWR sky130_fd_sc_hd__fill_1
X_6228_ _6228_/A _6897_/S VGND VGND VPWR VPWR _6229_/B sky130_fd_sc_hd__and2_2
X_6159_ _6208_/A _6758_/A _6758_/B _6097_/Y VGND VGND VPWR VPWR _6159_/X sky130_fd_sc_hd__a31o_2
XFILLER_57_243 VGND VGND VPWR VPWR sky130_fd_sc_hd__fill_2
XFILLER_66_48 VGND VGND VPWR VPWR sky130_fd_sc_hd__fill_1
XFILLER_85_530 VGND VGND VPWR VPWR sky130_fd_sc_hd__decap_3
XFILLER_97_390 VGND VGND VPWR VPWR sky130_fd_sc_hd__fill_2
XFILLER_57_265 VGND VGND VPWR VPWR sky130_fd_sc_hd__decap_3
XFILLER_57_298 VGND VGND VPWR VPWR sky130_fd_sc_hd__decap_3
XFILLER_72_224 VGND VGND VPWR VPWR sky130_fd_sc_hd__decap_3
XFILLER_25_140 VGND VGND VPWR VPWR sky130_fd_sc_hd__decap_3
XFILLER_60_419 VGND VGND VPWR VPWR sky130_fd_sc_hd__fill_1
XFILLER_72_268 VGND VGND VPWR VPWR sky130_fd_sc_hd__decap_3
XFILLER_25_162 VGND VGND VPWR VPWR sky130_fd_sc_hd__decap_3
XTAP_TAPCELL_ROW_71_959 VGND VPWR sky130_fd_sc_hd__tapvpwrvgnd_1
XTAP_TAPCELL_ROW_84_1096 VGND VPWR sky130_fd_sc_hd__tapvpwrvgnd_1
XFILLER_40_165 VGND VGND VPWR VPWR sky130_fd_sc_hd__decap_3
XFILLER_9_317 VGND VGND VPWR VPWR sky130_fd_sc_hd__decap_3
XFILLER_5_501 VGND VGND VPWR VPWR sky130_fd_sc_hd__decap_3
XFILLER_31_84 VGND VGND VPWR VPWR sky130_fd_sc_hd__decap_3
Xrebuffer694 _4502_/Y VGND VGND VPWR VPWR _5920_/B1 sky130_fd_sc_hd__buf_2
Xrebuffer683 _4558_/X VGND VGND VPWR VPWR _4560_/C1 sky130_fd_sc_hd__buf_2
Xoutput84 _6983_/B VGND VGND VPWR VPWR result[21] sky130_fd_sc_hd__clkbuf_2
Xoutput73 _6988_/A VGND VGND VPWR VPWR result[11] sky130_fd_sc_hd__clkbuf_2
XFILLER_95_305 VGND VGND VPWR VPWR sky130_fd_sc_hd__fill_1
XFILLER_0_272 VGND VGND VPWR VPWR sky130_fd_sc_hd__decap_3
Xoutput95 _6995_/A VGND VGND VPWR VPWR result[31] sky130_fd_sc_hd__buf_8
XFILLER_36_427 VGND VGND VPWR VPWR sky130_fd_sc_hd__decap_3
XFILLER_76_585 VGND VGND VPWR VPWR sky130_fd_sc_hd__decap_3
XFILLER_91_500 VGND VGND VPWR VPWR sky130_fd_sc_hd__decap_3
XFILLER_29_490 VGND VGND VPWR VPWR sky130_fd_sc_hd__decap_3
XFILLER_63_246 VGND VGND VPWR VPWR sky130_fd_sc_hd__decap_3
XFILLER_91_544 VGND VGND VPWR VPWR sky130_fd_sc_hd__decap_3
XFILLER_63_279 VGND VGND VPWR VPWR sky130_fd_sc_hd__fill_1
XFILLER_16_173 VGND VGND VPWR VPWR sky130_fd_sc_hd__fill_2
XFILLER_71_290 VGND VGND VPWR VPWR sky130_fd_sc_hd__decap_3
X_3860_ _3861_/A _3861_/B _3861_/C VGND VGND VPWR VPWR _5965_/A sky130_fd_sc_hd__o21a_2
X_3791_ _4044_/B _4044_/A VGND VGND VPWR VPWR _3808_/A sky130_fd_sc_hd__nand2b_2
XTAP_TAPCELL_ROW_42_661 VGND VPWR sky130_fd_sc_hd__tapvpwrvgnd_1
XTAP_TAPCELL_ROW_14_363 VGND VPWR sky130_fd_sc_hd__tapvpwrvgnd_1
XFILLER_75_3 VGND VGND VPWR VPWR sky130_fd_sc_hd__decap_3
X_5530_ _5701_/A _5588_/A _5695_/C _6121_/B VGND VGND VPWR VPWR _5533_/A sky130_fd_sc_hd__nand4_2
XFILLER_8_361 VGND VGND VPWR VPWR sky130_fd_sc_hd__decap_3
X_5461_ _5458_/X _5459_/Y _5433_/A _5461_/C1 VGND VGND VPWR VPWR _5462_/C sky130_fd_sc_hd__o211ai_2
X_4412_ _4412_/A _4412_/B _4412_/C VGND VGND VPWR VPWR _4516_/A sky130_fd_sc_hd__nand3_2
X_5392_ _5337_/A _5337_/C _5337_/B VGND VGND VPWR VPWR _5393_/C sky130_fd_sc_hd__a21oi_2
X_4343_ _4344_/A _4344_/B VGND VGND VPWR VPWR _4350_/B sky130_fd_sc_hd__nor2_2
XPHY_EDGE_ROW_99_Right_99 VGND VGND VPWR VPWR sky130_fd_sc_hd__decap_3
XFILLER_59_508 VGND VGND VPWR VPWR sky130_fd_sc_hd__decap_3
Xfanout307 _6527_/A2 VGND VGND VPWR VPWR _6545_/A sky130_fd_sc_hd__buf_4
Xfanout318 _3664_/A VGND VGND VPWR VPWR _4518_/A sky130_fd_sc_hd__clkdlybuf4s25_1
X_4274_ _4524_/B _4518_/B VGND VGND VPWR VPWR _4393_/A sky130_fd_sc_hd__nand2_2
XFILLER_39_210 VGND VGND VPWR VPWR sky130_fd_sc_hd__decap_3
XFILLER_86_338 VGND VGND VPWR VPWR sky130_fd_sc_hd__decap_3
X_6013_ _6014_/A _3941_/A _6014_/C _6014_/D VGND VGND VPWR VPWR _6021_/A sky130_fd_sc_hd__a22oi_2
XFILLER_100_137 VGND VGND VPWR VPWR sky130_fd_sc_hd__decap_3
XFILLER_39_243 VGND VGND VPWR VPWR sky130_fd_sc_hd__fill_2
XFILLER_67_552 VGND VGND VPWR VPWR sky130_fd_sc_hd__decap_3
XFILLER_27_405 VGND VGND VPWR VPWR sky130_fd_sc_hd__decap_3
XFILLER_94_371 VGND VGND VPWR VPWR sky130_fd_sc_hd__decap_3
XFILLER_39_287 VGND VGND VPWR VPWR sky130_fd_sc_hd__decap_3
XFILLER_54_213 VGND VGND VPWR VPWR sky130_fd_sc_hd__fill_1
XFILLER_67_596 VGND VGND VPWR VPWR sky130_fd_sc_hd__fill_2
XFILLER_82_522 VGND VGND VPWR VPWR sky130_fd_sc_hd__decap_3
XFILLER_82_533 VGND VGND VPWR VPWR sky130_fd_sc_hd__decap_3
XFILLER_94_393 VGND VGND VPWR VPWR sky130_fd_sc_hd__decap_3
XFILLER_54_268 VGND VGND VPWR VPWR sky130_fd_sc_hd__decap_3
XFILLER_82_555 VGND VGND VPWR VPWR sky130_fd_sc_hd__decap_3
X_6915_ _6764_/A _6641_/Y _6965_/A _6914_/X VGND VGND VPWR VPWR _6915_/X sky130_fd_sc_hd__o211a_2
XFILLER_22_121 VGND VGND VPWR VPWR sky130_fd_sc_hd__fill_2
XFILLER_50_430 VGND VGND VPWR VPWR sky130_fd_sc_hd__fill_1
XFILLER_62_290 VGND VGND VPWR VPWR sky130_fd_sc_hd__decap_3
X_6846_ _6313_/A _6765_/B _6575_/X _6845_/X VGND VGND VPWR VPWR _6846_/X sky130_fd_sc_hd__a31o_2
XFILLER_50_474 VGND VGND VPWR VPWR sky130_fd_sc_hd__fill_2
X_6777_ _6777_/A _6777_/B _6776_/X VGND VGND VPWR VPWR _6790_/A sky130_fd_sc_hd__or3b_2
XFILLER_10_338 VGND VGND VPWR VPWR sky130_fd_sc_hd__decap_3
XFILLER_22_187 VGND VGND VPWR VPWR sky130_fd_sc_hd__decap_3
X_5728_ _5726_/C _5726_/B _5763_/C VGND VGND VPWR VPWR _5729_/B sky130_fd_sc_hd__a21bo_2
X_3989_ _5993_/B _6008_/A VGND VGND VPWR VPWR _3995_/A sky130_fd_sc_hd__nand2_2
XFILLER_6_309 VGND VGND VPWR VPWR sky130_fd_sc_hd__decap_3
X_5659_ _5659_/A _6401_/S VGND VGND VPWR VPWR _5675_/B sky130_fd_sc_hd__and2_2
XTAP_TAPCELL_ROW_75_1007 VGND VPWR sky130_fd_sc_hd__tapvpwrvgnd_1
XFILLER_7_6 VGND VGND VPWR VPWR sky130_fd_sc_hd__decap_3
XFILLER_77_305 VGND VGND VPWR VPWR sky130_fd_sc_hd__decap_3
XFILLER_89_132 VGND VGND VPWR VPWR sky130_fd_sc_hd__decap_3
XFILLER_89_187 VGND VGND VPWR VPWR sky130_fd_sc_hd__decap_3
XFILLER_73_500 VGND VGND VPWR VPWR sky130_fd_sc_hd__decap_3
XFILLER_85_360 VGND VGND VPWR VPWR sky130_fd_sc_hd__decap_3
XFILLER_18_438 VGND VGND VPWR VPWR sky130_fd_sc_hd__decap_3
XFILLER_45_213 VGND VGND VPWR VPWR sky130_fd_sc_hd__decap_3
XFILLER_85_393 VGND VGND VPWR VPWR sky130_fd_sc_hd__decap_3
XTAP_TAPCELL_ROW_86_1125 VGND VPWR sky130_fd_sc_hd__tapvpwrvgnd_1
XFILLER_33_419 VGND VGND VPWR VPWR sky130_fd_sc_hd__decap_3
XFILLER_73_555 VGND VGND VPWR VPWR sky130_fd_sc_hd__decap_3
XFILLER_26_62 VGND VGND VPWR VPWR sky130_fd_sc_hd__fill_1
XFILLER_60_249 VGND VGND VPWR VPWR sky130_fd_sc_hd__decap_3
XFILLER_41_452 VGND VGND VPWR VPWR sky130_fd_sc_hd__decap_3
XFILLER_9_125 VGND VGND VPWR VPWR sky130_fd_sc_hd__fill_2
XTAP_TAPCELL_ROW_97_1232 VGND VPWR sky130_fd_sc_hd__tapvpwrvgnd_1
XTAP_TAPCELL_ROW_11_333 VGND VPWR sky130_fd_sc_hd__tapvpwrvgnd_1
XFILLER_1_570 VGND VGND VPWR VPWR sky130_fd_sc_hd__decap_3
XFILLER_68_305 VGND VGND VPWR VPWR sky130_fd_sc_hd__decap_3
XFILLER_49_585 VGND VGND VPWR VPWR sky130_fd_sc_hd__fill_2
XFILLER_76_360 VGND VGND VPWR VPWR sky130_fd_sc_hd__decap_3
XFILLER_83_308 VGND VGND VPWR VPWR sky130_fd_sc_hd__decap_3
XFILLER_64_522 VGND VGND VPWR VPWR sky130_fd_sc_hd__decap_3
XFILLER_76_371 VGND VGND VPWR VPWR sky130_fd_sc_hd__decap_3
XFILLER_91_330 VGND VGND VPWR VPWR sky130_fd_sc_hd__decap_3
XFILLER_91_352 VGND VGND VPWR VPWR sky130_fd_sc_hd__decap_3
XFILLER_17_482 VGND VGND VPWR VPWR sky130_fd_sc_hd__decap_3
XFILLER_51_205 VGND VGND VPWR VPWR sky130_fd_sc_hd__decap_3
XFILLER_91_385 VGND VGND VPWR VPWR sky130_fd_sc_hd__decap_3
X_4961_ _5053_/D _5203_/D _4960_/B _4957_/X VGND VGND VPWR VPWR _4963_/B sky130_fd_sc_hd__a31o_2
X_6700_ _6700_/A _6700_/B VGND VGND VPWR VPWR _6700_/Y sky130_fd_sc_hd__nand2_2
X_4892_ _5885_/B _4891_/B _4855_/B VGND VGND VPWR VPWR _4911_/B sky130_fd_sc_hd__o21bai_2
X_3912_ _3912_/A _3912_/B VGND VGND VPWR VPWR _3913_/B sky130_fd_sc_hd__xnor2_2
X_6631_ _6383_/D _6339_/Y _6628_/X _6630_/Y VGND VGND VPWR VPWR _6632_/A sky130_fd_sc_hd__a211o_2
X_3843_ _3842_/A _3842_/B _3842_/C VGND VGND VPWR VPWR _3844_/B sky130_fd_sc_hd__o21ai_2
XFILLER_32_485 VGND VGND VPWR VPWR sky130_fd_sc_hd__decap_3
X_6562_ _6562_/A _6562_/B VGND VGND VPWR VPWR _6562_/X sky130_fd_sc_hd__or2_2
X_3774_ _3775_/B _3775_/A VGND VGND VPWR VPWR _3778_/B sky130_fd_sc_hd__and2b_2
X_6493_ _6493_/A _6493_/B VGND VGND VPWR VPWR _6493_/X sky130_fd_sc_hd__and2_2
X_5513_ _5513_/A _5514_/B VGND VGND VPWR VPWR _5513_/X sky130_fd_sc_hd__and2_2
X_5444_ _5445_/A _5445_/B VGND VGND VPWR VPWR _5826_/A sky130_fd_sc_hd__or2_2
X_5375_ _5375_/A _5375_/B VGND VGND VPWR VPWR _5377_/C sky130_fd_sc_hd__xnor2_2
XFILLER_99_452 VGND VGND VPWR VPWR sky130_fd_sc_hd__decap_3
XFILLER_99_441 VGND VGND VPWR VPWR sky130_fd_sc_hd__decap_3
XFILLER_59_316 VGND VGND VPWR VPWR sky130_fd_sc_hd__decap_3
Xfanout126 _6960_/A VGND VGND VPWR VPWR _6765_/B sky130_fd_sc_hd__clkdlybuf4s25_1
Xfanout137 _6927_/B1 VGND VGND VPWR VPWR _6797_/A2 sky130_fd_sc_hd__clkdlybuf4s25_1
X_4326_ _4314_/Y _4316_/X _4259_/X _4313_/B VGND VGND VPWR VPWR _4327_/B sky130_fd_sc_hd__o211ai_2
Xfanout148 _6061_/Y VGND VGND VPWR VPWR _6923_/A sky130_fd_sc_hd__clkdlybuf4s25_1
X_4257_ _4192_/X _4256_/Y _4253_/C _4229_/Y VGND VGND VPWR VPWR _4257_/X sky130_fd_sc_hd__o211a_2
XFILLER_55_500 VGND VGND VPWR VPWR sky130_fd_sc_hd__decap_3
X_4188_ _4189_/B _4304_/A _4189_/A VGND VGND VPWR VPWR _4188_/X sky130_fd_sc_hd__o21a_2
XFILLER_55_511 VGND VGND VPWR VPWR sky130_fd_sc_hd__decap_3
XFILLER_67_393 VGND VGND VPWR VPWR sky130_fd_sc_hd__fill_1
XFILLER_82_330 VGND VGND VPWR VPWR sky130_fd_sc_hd__decap_3
XFILLER_82_374 VGND VGND VPWR VPWR sky130_fd_sc_hd__decap_3
XFILLER_35_290 VGND VGND VPWR VPWR sky130_fd_sc_hd__decap_3
XFILLER_70_547 VGND VGND VPWR VPWR sky130_fd_sc_hd__decap_3
XFILLER_23_463 VGND VGND VPWR VPWR sky130_fd_sc_hd__decap_3
X_6829_ _6829_/A _6829_/B VGND VGND VPWR VPWR _6834_/C sky130_fd_sc_hd__nor2_2
XTAP_TAPCELL_ROW_81_1066 VGND VPWR sky130_fd_sc_hd__tapvpwrvgnd_1
XTAP_TAPCELL_ROW_53_778 VGND VPWR sky130_fd_sc_hd__tapvpwrvgnd_1
XFILLER_50_271 VGND VGND VPWR VPWR sky130_fd_sc_hd__decap_3
XFILLER_5_3 VGND VGND VPWR VPWR sky130_fd_sc_hd__decap_3
XFILLER_77_113 VGND VGND VPWR VPWR sky130_fd_sc_hd__decap_3
XTAP_TAPCELL_ROW_92_1184 VGND VPWR sky130_fd_sc_hd__tapvpwrvgnd_1
Xfanout660 wire672/X VGND VGND VPWR VPWR wire661/A sky130_fd_sc_hd__clkdlybuf4s25_1
XFILLER_46_511 VGND VGND VPWR VPWR sky130_fd_sc_hd__decap_3
XFILLER_37_83 VGND VGND VPWR VPWR sky130_fd_sc_hd__decap_3
XFILLER_61_503 VGND VGND VPWR VPWR sky130_fd_sc_hd__fill_1
XFILLER_18_279 VGND VGND VPWR VPWR sky130_fd_sc_hd__decap_3
XFILLER_33_205 VGND VGND VPWR VPWR sky130_fd_sc_hd__decap_3
XFILLER_61_536 VGND VGND VPWR VPWR sky130_fd_sc_hd__fill_1
XFILLER_73_385 VGND VGND VPWR VPWR sky130_fd_sc_hd__decap_3
XFILLER_33_249 VGND VGND VPWR VPWR sky130_fd_sc_hd__decap_3
XFILLER_41_260 VGND VGND VPWR VPWR sky130_fd_sc_hd__decap_3
XFILLER_53_60 VGND VGND VPWR VPWR sky130_fd_sc_hd__decap_3
XFILLER_41_271 VGND VGND VPWR VPWR sky130_fd_sc_hd__decap_3
XFILLER_53_82 VGND VGND VPWR VPWR sky130_fd_sc_hd__decap_3
X_3490_ _4646_/D VGND VGND VPWR VPWR _3490_/Y sky130_fd_sc_hd__inv_2
XFILLER_5_172 VGND VGND VPWR VPWR sky130_fd_sc_hd__fill_1
XFILLER_5_194 VGND VGND VPWR VPWR sky130_fd_sc_hd__decap_3
X_5160_ _3748_/A _5284_/B _5222_/B _5157_/X VGND VGND VPWR VPWR _5161_/B sky130_fd_sc_hd__a31o_2
XFILLER_68_124 VGND VGND VPWR VPWR sky130_fd_sc_hd__decap_3
X_5091_ _5089_/A _5088_/Y _5090_/X _4998_/Y VGND VGND VPWR VPWR _5091_/Y sky130_fd_sc_hd__o211ai_2
X_4111_ _4111_/A _4111_/B _4225_/A VGND VGND VPWR VPWR _4111_/Y sky130_fd_sc_hd__nand3_2
XFILLER_68_179 VGND VGND VPWR VPWR sky130_fd_sc_hd__decap_3
X_4042_ _4042_/A _4042_/B VGND VGND VPWR VPWR _4055_/A sky130_fd_sc_hd__nand2_2
XFILLER_96_477 VGND VGND VPWR VPWR sky130_fd_sc_hd__decap_3
XFILLER_96_466 VGND VGND VPWR VPWR sky130_fd_sc_hd__decap_3
XFILLER_37_533 VGND VGND VPWR VPWR sky130_fd_sc_hd__decap_3
XFILLER_49_382 VGND VGND VPWR VPWR sky130_fd_sc_hd__fill_2
XFILLER_96_499 VGND VGND VPWR VPWR sky130_fd_sc_hd__fill_2
XFILLER_64_330 VGND VGND VPWR VPWR sky130_fd_sc_hd__decap_3
XFILLER_83_149 VGND VGND VPWR VPWR sky130_fd_sc_hd__decap_3
XFILLER_24_227 VGND VGND VPWR VPWR sky130_fd_sc_hd__decap_3
XFILLER_37_588 VGND VGND VPWR VPWR sky130_fd_sc_hd__decap_3
XFILLER_52_536 VGND VGND VPWR VPWR sky130_fd_sc_hd__decap_3
XFILLER_64_363 VGND VGND VPWR VPWR sky130_fd_sc_hd__fill_1
X_5993_ _5993_/A _5993_/B VGND VGND VPWR VPWR _5994_/B sky130_fd_sc_hd__nand2_2
XFILLER_91_193 VGND VGND VPWR VPWR sky130_fd_sc_hd__fill_2
X_4944_ _5341_/B _5340_/A _5188_/C _4944_/D VGND VGND VPWR VPWR _4947_/A sky130_fd_sc_hd__and4_2
X_4875_ _4876_/A _4876_/B _4876_/C _4876_/D VGND VGND VPWR VPWR _4875_/X sky130_fd_sc_hd__and4_2
XTAP_TAPCELL_ROW_50_737 VGND VPWR sky130_fd_sc_hd__tapvpwrvgnd_1
XFILLER_20_444 VGND VGND VPWR VPWR sky130_fd_sc_hd__decap_3
X_6614_ _6615_/A1 _5812_/X _6777_/A VGND VGND VPWR VPWR _6614_/Y sky130_fd_sc_hd__a21oi_2
X_3826_ _6025_/B _3933_/B _3933_/D _6024_/B VGND VGND VPWR VPWR _3827_/B sky130_fd_sc_hd__a22oi_2
X_6545_ _6545_/A _6545_/B VGND VGND VPWR VPWR _6545_/X sky130_fd_sc_hd__or2_2
X_3757_ _3757_/A _4526_/B _3758_/A _3757_/D VGND VGND VPWR VPWR _4163_/A sky130_fd_sc_hd__nand4_2
X_6476_ _6476_/A VGND VGND VPWR VPWR _6476_/Y sky130_fd_sc_hd__inv_2
X_3688_ _6079_/B _4526_/B _3688_/C _3688_/D VGND VGND VPWR VPWR _3707_/B sky130_fd_sc_hd__and4_2
X_5427_ _5428_/A _5428_/B _5428_/C VGND VGND VPWR VPWR _5451_/B sky130_fd_sc_hd__a21o_2
XFILLER_87_411 VGND VGND VPWR VPWR sky130_fd_sc_hd__decap_3
X_5358_ _5355_/Y _5356_/X _5320_/Y _5393_/B VGND VGND VPWR VPWR _5377_/B sky130_fd_sc_hd__a211o_2
XFILLER_99_271 VGND VGND VPWR VPWR sky130_fd_sc_hd__decap_3
XFILLER_59_113 VGND VGND VPWR VPWR sky130_fd_sc_hd__decap_3
X_4309_ _4309_/A _4309_/B _4309_/C VGND VGND VPWR VPWR _4309_/Y sky130_fd_sc_hd__nand3_2
XFILLER_87_466 VGND VGND VPWR VPWR sky130_fd_sc_hd__decap_3
X_5289_ _5431_/A _5431_/B VGND VGND VPWR VPWR _5289_/Y sky130_fd_sc_hd__nand2b_2
XFILLER_28_522 VGND VGND VPWR VPWR sky130_fd_sc_hd__decap_3
XFILLER_28_533 VGND VGND VPWR VPWR sky130_fd_sc_hd__decap_3
XTAP_TAPCELL_ROW_58_826 VGND VPWR sky130_fd_sc_hd__tapvpwrvgnd_1
XFILLER_55_352 VGND VGND VPWR VPWR sky130_fd_sc_hd__fill_2
XFILLER_67_190 VGND VGND VPWR VPWR sky130_fd_sc_hd__decap_3
XFILLER_74_26 VGND VGND VPWR VPWR sky130_fd_sc_hd__fill_2
XFILLER_43_558 VGND VGND VPWR VPWR sky130_fd_sc_hd__fill_2
XFILLER_55_396 VGND VGND VPWR VPWR sky130_fd_sc_hd__decap_3
XFILLER_82_182 VGND VGND VPWR VPWR sky130_fd_sc_hd__decap_3
XFILLER_70_388 VGND VGND VPWR VPWR sky130_fd_sc_hd__decap_3
XFILLER_11_422 VGND VGND VPWR VPWR sky130_fd_sc_hd__decap_3
XFILLER_90_58 VGND VGND VPWR VPWR sky130_fd_sc_hd__decap_3
XFILLER_23_293 VGND VGND VPWR VPWR sky130_fd_sc_hd__decap_3
XFILLER_23_63 VGND VGND VPWR VPWR sky130_fd_sc_hd__decap_3
XFILLER_7_404 VGND VGND VPWR VPWR sky130_fd_sc_hd__decap_3
Xwire357 wire357/A VGND VGND VPWR VPWR _6499_/S sky130_fd_sc_hd__clkbuf_4
XTAP_TAPCELL_ROW_94_1202 VGND VPWR sky130_fd_sc_hd__tapvpwrvgnd_1
XFILLER_78_400 VGND VGND VPWR VPWR sky130_fd_sc_hd__decap_3
Xload_slew329 _3551_/A2 VGND VGND VPWR VPWR _3969_/B sky130_fd_sc_hd__clkbuf_4
XFILLER_2_175 VGND VGND VPWR VPWR sky130_fd_sc_hd__decap_3
XFILLER_2_197 VGND VGND VPWR VPWR sky130_fd_sc_hd__fill_2
XFILLER_93_414 VGND VGND VPWR VPWR sky130_fd_sc_hd__decap_3
XFILLER_19_522 VGND VGND VPWR VPWR sky130_fd_sc_hd__decap_3
XFILLER_48_82 VGND VGND VPWR VPWR sky130_fd_sc_hd__fill_2
XFILLER_78_499 VGND VGND VPWR VPWR sky130_fd_sc_hd__fill_1
XFILLER_0_12 VGND VGND VPWR VPWR sky130_fd_sc_hd__decap_3
XFILLER_93_458 VGND VGND VPWR VPWR sky130_fd_sc_hd__decap_3
XFILLER_0_67 VGND VGND VPWR VPWR sky130_fd_sc_hd__decap_3
XFILLER_80_119 VGND VGND VPWR VPWR sky130_fd_sc_hd__decap_3
XFILLER_34_536 VGND VGND VPWR VPWR sky130_fd_sc_hd__decap_3
XFILLER_61_322 VGND VGND VPWR VPWR sky130_fd_sc_hd__decap_3
XFILLER_64_70 VGND VGND VPWR VPWR sky130_fd_sc_hd__decap_3
XFILLER_14_282 VGND VGND VPWR VPWR sky130_fd_sc_hd__decap_3
XFILLER_9_32 VGND VGND VPWR VPWR sky130_fd_sc_hd__decap_3
X_4660_ _6238_/B _6106_/B VGND VGND VPWR VPWR _6108_/A sky130_fd_sc_hd__and2_2
X_3611_ _3613_/B _3611_/B _3611_/C VGND VGND VPWR VPWR _3652_/A sky130_fd_sc_hd__nand3_2
X_6330_ _6332_/A _6332_/B _6384_/D VGND VGND VPWR VPWR _6330_/X sky130_fd_sc_hd__or3_2
X_4591_ _4867_/A _4867_/B VGND VGND VPWR VPWR _4591_/Y sky130_fd_sc_hd__nand2b_2
X_3542_ _3542_/A _4090_/A VGND VGND VPWR VPWR _4066_/B sky130_fd_sc_hd__nor2_2
XFILLER_6_492 VGND VGND VPWR VPWR sky130_fd_sc_hd__decap_3
X_6261_ _6842_/A _6807_/A _6261_/C _6860_/A VGND VGND VPWR VPWR _6386_/B sky130_fd_sc_hd__nand4_2
X_6192_ _6192_/A _6904_/B VGND VGND VPWR VPWR _6192_/X sky130_fd_sc_hd__or2_2
X_5212_ _5212_/A _5349_/A VGND VGND VPWR VPWR _5423_/A sky130_fd_sc_hd__nand2_2
X_5143_ _5126_/A _5126_/C _5126_/B VGND VGND VPWR VPWR _5143_/Y sky130_fd_sc_hd__a21oi_4
XFILLER_56_105 VGND VGND VPWR VPWR sky130_fd_sc_hd__fill_2
XFILLER_84_414 VGND VGND VPWR VPWR sky130_fd_sc_hd__decap_3
XFILLER_84_436 VGND VGND VPWR VPWR sky130_fd_sc_hd__decap_3
X_5074_ _6249_/B _5284_/B VGND VGND VPWR VPWR _5150_/A sky130_fd_sc_hd__nand2_2
XFILLER_84_469 VGND VGND VPWR VPWR sky130_fd_sc_hd__decap_3
X_4025_ _4030_/A _4030_/B VGND VGND VPWR VPWR _4026_/C sky130_fd_sc_hd__and2_2
XFILLER_25_558 VGND VGND VPWR VPWR sky130_fd_sc_hd__fill_2
XFILLER_52_344 VGND VGND VPWR VPWR sky130_fd_sc_hd__fill_2
XFILLER_64_182 VGND VGND VPWR VPWR sky130_fd_sc_hd__fill_2
XFILLER_64_193 VGND VGND VPWR VPWR sky130_fd_sc_hd__decap_3
XFILLER_92_480 VGND VGND VPWR VPWR sky130_fd_sc_hd__decap_3
XFILLER_92_491 VGND VGND VPWR VPWR sky130_fd_sc_hd__decap_3
XFILLER_40_506 VGND VGND VPWR VPWR sky130_fd_sc_hd__decap_3
XFILLER_52_377 VGND VGND VPWR VPWR sky130_fd_sc_hd__decap_3
X_5976_ _5976_/A _5976_/B _5976_/C _5976_/D VGND VGND VPWR VPWR _5977_/B sky130_fd_sc_hd__nand4_2
X_4927_ _4925_/B _4925_/C _4925_/D _4925_/A VGND VGND VPWR VPWR _4928_/B sky130_fd_sc_hd__a22o_2
XTAP_TAPCELL_ROW_35_586 VGND VPWR sky130_fd_sc_hd__tapvpwrvgnd_1
X_4858_ _4529_/A _4529_/C _4529_/B VGND VGND VPWR VPWR _4859_/C sky130_fd_sc_hd__a21o_2
X_3809_ _4048_/A _4048_/B _4048_/C VGND VGND VPWR VPWR _4051_/A sky130_fd_sc_hd__o21a_2
X_4789_ _4790_/B _4790_/A VGND VGND VPWR VPWR _4789_/X sky130_fd_sc_hd__and2b_2
XFILLER_4_429 VGND VGND VPWR VPWR sky130_fd_sc_hd__fill_1
X_6528_ _6960_/A _6528_/B VGND VGND VPWR VPWR _6813_/B sky130_fd_sc_hd__nand2_2
X_6459_ _6455_/X _6458_/X _6462_/S VGND VGND VPWR VPWR _6459_/X sky130_fd_sc_hd__mux2_1
XFILLER_87_263 VGND VGND VPWR VPWR sky130_fd_sc_hd__decap_3
XTAP_TAPCELL_ROW_7_289 VGND VPWR sky130_fd_sc_hd__tapvpwrvgnd_1
XFILLER_47_105 VGND VGND VPWR VPWR sky130_fd_sc_hd__decap_3
XFILLER_47_127 VGND VGND VPWR VPWR sky130_fd_sc_hd__decap_3
XFILLER_75_447 VGND VGND VPWR VPWR sky130_fd_sc_hd__fill_1
XFILLER_85_69 VGND VGND VPWR VPWR sky130_fd_sc_hd__decap_3
XFILLER_16_514 VGND VGND VPWR VPWR sky130_fd_sc_hd__decap_3
XFILLER_18_85 VGND VGND VPWR VPWR sky130_fd_sc_hd__decap_3
XFILLER_28_385 VGND VGND VPWR VPWR sky130_fd_sc_hd__fill_2
XFILLER_43_322 VGND VGND VPWR VPWR sky130_fd_sc_hd__decap_3
XFILLER_83_491 VGND VGND VPWR VPWR sky130_fd_sc_hd__decap_3
XFILLER_43_366 VGND VGND VPWR VPWR sky130_fd_sc_hd__decap_3
XFILLER_70_130 VGND VGND VPWR VPWR sky130_fd_sc_hd__decap_3
XFILLER_70_141 VGND VGND VPWR VPWR sky130_fd_sc_hd__decap_3
XFILLER_70_174 VGND VGND VPWR VPWR sky130_fd_sc_hd__decap_3
XFILLER_7_201 VGND VGND VPWR VPWR sky130_fd_sc_hd__decap_3
XFILLER_3_473 VGND VGND VPWR VPWR sky130_fd_sc_hd__decap_3
XFILLER_22_6 VGND VGND VPWR VPWR sky130_fd_sc_hd__decap_3
XFILLER_78_230 VGND VGND VPWR VPWR sky130_fd_sc_hd__decap_3
Xload_slew159 _6542_/A2 VGND VGND VPWR VPWR _6819_/A2 sky130_fd_sc_hd__clkbuf_4
XFILLER_78_285 VGND VGND VPWR VPWR sky130_fd_sc_hd__decap_3
XFILLER_93_222 VGND VGND VPWR VPWR sky130_fd_sc_hd__fill_2
XFILLER_66_458 VGND VGND VPWR VPWR sky130_fd_sc_hd__decap_3
XFILLER_19_363 VGND VGND VPWR VPWR sky130_fd_sc_hd__decap_3
XFILLER_93_266 VGND VGND VPWR VPWR sky130_fd_sc_hd__decap_3
XFILLER_74_491 VGND VGND VPWR VPWR sky130_fd_sc_hd__decap_3
XFILLER_93_299 VGND VGND VPWR VPWR sky130_fd_sc_hd__decap_3
XFILLER_34_377 VGND VGND VPWR VPWR sky130_fd_sc_hd__decap_3
XFILLER_61_130 VGND VGND VPWR VPWR sky130_fd_sc_hd__decap_3
X_5830_ _5830_/A _5830_/B _5830_/C _5830_/D VGND VGND VPWR VPWR _5846_/B sky130_fd_sc_hd__nand4_4
XFILLER_22_528 VGND VGND VPWR VPWR sky130_fd_sc_hd__decap_3
XFILLER_34_399 VGND VGND VPWR VPWR sky130_fd_sc_hd__decap_3
X_5761_ _5761_/A _5761_/B VGND VGND VPWR VPWR _5766_/A sky130_fd_sc_hd__xor2_2
X_4712_ _4678_/X _4684_/Y _4692_/X _4710_/Y VGND VGND VPWR VPWR _4713_/C sky130_fd_sc_hd__a211o_2
XTAP_TAPCELL_ROW_60_843 VGND VPWR sky130_fd_sc_hd__tapvpwrvgnd_1
XTAP_TAPCELL_ROW_32_556 VGND VPWR sky130_fd_sc_hd__tapvpwrvgnd_1
X_5692_ _5692_/A _5692_/B VGND VGND VPWR VPWR _5710_/A sky130_fd_sc_hd__nor2_2
X_4643_ _4643_/A _4643_/B _4643_/C VGND VGND VPWR VPWR _4643_/X sky130_fd_sc_hd__or3_4
X_4574_ _4989_/A _4785_/B _4573_/B _4570_/X VGND VGND VPWR VPWR _4576_/B sky130_fd_sc_hd__a31oi_2
X_6313_ _6313_/A _6313_/B VGND VGND VPWR VPWR _6313_/Y sky130_fd_sc_hd__nor2_2
X_3525_ _3525_/A _3769_/A VGND VGND VPWR VPWR _3527_/B sky130_fd_sc_hd__nor2_2
XFILLER_89_517 VGND VGND VPWR VPWR sky130_fd_sc_hd__fill_1
XFILLER_89_528 VGND VGND VPWR VPWR sky130_fd_sc_hd__decap_3
X_6244_ _6148_/B _6244_/B VGND VGND VPWR VPWR _6244_/Y sky130_fd_sc_hd__nand2b_2
XFILLER_69_252 VGND VGND VPWR VPWR sky130_fd_sc_hd__decap_3
X_6175_ _6175_/A _6175_/B VGND VGND VPWR VPWR _6176_/B sky130_fd_sc_hd__or2_2
XFILLER_69_296 VGND VGND VPWR VPWR sky130_fd_sc_hd__decap_3
XFILLER_84_200 VGND VGND VPWR VPWR sky130_fd_sc_hd__decap_3
X_5126_ _5126_/A _5126_/B _5126_/C VGND VGND VPWR VPWR _5126_/X sky130_fd_sc_hd__and3_4
XTAP_TAPCELL_ROW_68_932 VGND VPWR sky130_fd_sc_hd__tapvpwrvgnd_1
X_5057_ _5056_/B _5133_/A VGND VGND VPWR VPWR _5059_/C sky130_fd_sc_hd__nand2b_4
XTAP_TAPCELL_ROW_4_259 VGND VPWR sky130_fd_sc_hd__tapvpwrvgnd_1
XFILLER_84_277 VGND VGND VPWR VPWR sky130_fd_sc_hd__fill_1
X_4008_ _4024_/A _4024_/B VGND VGND VPWR VPWR _4009_/B sky130_fd_sc_hd__nand2b_2
XFILLER_25_333 VGND VGND VPWR VPWR sky130_fd_sc_hd__decap_3
XFILLER_37_182 VGND VGND VPWR VPWR sky130_fd_sc_hd__decap_3
XFILLER_65_491 VGND VGND VPWR VPWR sky130_fd_sc_hd__fill_1
XFILLER_84_299 VGND VGND VPWR VPWR sky130_fd_sc_hd__decap_3
XFILLER_25_355 VGND VGND VPWR VPWR sky130_fd_sc_hd__fill_1
XFILLER_52_141 VGND VGND VPWR VPWR sky130_fd_sc_hd__decap_3
XFILLER_80_450 VGND VGND VPWR VPWR sky130_fd_sc_hd__decap_3
XFILLER_80_483 VGND VGND VPWR VPWR sky130_fd_sc_hd__decap_3
X_5959_ _5959_/A _5959_/B _5959_/C _5959_/D VGND VGND VPWR VPWR _5959_/X sky130_fd_sc_hd__and4_2
XFILLER_21_561 VGND VGND VPWR VPWR sky130_fd_sc_hd__decap_3
XFILLER_4_215 VGND VGND VPWR VPWR sky130_fd_sc_hd__fill_2
XTAP_TAPCELL_ROW_78_1038 VGND VPWR sky130_fd_sc_hd__tapvpwrvgnd_1
XFILLER_20_42 VGND VGND VPWR VPWR sky130_fd_sc_hd__decap_3
XFILLER_4_237 VGND VGND VPWR VPWR sky130_fd_sc_hd__decap_3
XFILLER_0_421 VGND VGND VPWR VPWR sky130_fd_sc_hd__decap_3
XFILLER_96_24 VGND VGND VPWR VPWR sky130_fd_sc_hd__decap_3
XFILLER_29_51 VGND VGND VPWR VPWR sky130_fd_sc_hd__decap_3
XFILLER_75_200 VGND VGND VPWR VPWR sky130_fd_sc_hd__decap_3
XFILLER_29_95 VGND VGND VPWR VPWR sky130_fd_sc_hd__decap_3
XTAP_TAPCELL_ROW_89_1156 VGND VPWR sky130_fd_sc_hd__tapvpwrvgnd_1
XFILLER_28_182 VGND VGND VPWR VPWR sky130_fd_sc_hd__decap_3
XFILLER_75_299 VGND VGND VPWR VPWR sky130_fd_sc_hd__decap_3
XFILLER_16_344 VGND VGND VPWR VPWR sky130_fd_sc_hd__decap_3
XFILLER_43_141 VGND VGND VPWR VPWR sky130_fd_sc_hd__decap_3
XFILLER_16_399 VGND VGND VPWR VPWR sky130_fd_sc_hd__decap_3
XFILLER_71_494 VGND VGND VPWR VPWR sky130_fd_sc_hd__decap_3
XFILLER_8_565 VGND VGND VPWR VPWR sky130_fd_sc_hd__decap_3
XANTENNA_4 input29/X VGND VGND VPWR VPWR sky130_fd_sc_hd__diode_2
XFILLER_6_99 VGND VGND VPWR VPWR sky130_fd_sc_hd__decap_3
XFILLER_3_281 VGND VGND VPWR VPWR sky130_fd_sc_hd__decap_3
X_4290_ _4290_/A _4900_/B VGND VGND VPWR VPWR _4307_/A sky130_fd_sc_hd__nand2_2
XFILLER_3_292 VGND VGND VPWR VPWR sky130_fd_sc_hd__decap_3
XFILLER_66_200 VGND VGND VPWR VPWR sky130_fd_sc_hd__decap_3
XFILLER_79_594 VGND VGND VPWR VPWR sky130_fd_sc_hd__decap_3
XFILLER_94_520 VGND VGND VPWR VPWR sky130_fd_sc_hd__decap_3
XFILLER_39_447 VGND VGND VPWR VPWR sky130_fd_sc_hd__fill_1
XFILLER_39_458 VGND VGND VPWR VPWR sky130_fd_sc_hd__decap_3
XFILLER_66_233 VGND VGND VPWR VPWR sky130_fd_sc_hd__decap_3
XFILLER_94_542 VGND VGND VPWR VPWR sky130_fd_sc_hd__decap_3
XFILLER_54_406 VGND VGND VPWR VPWR sky130_fd_sc_hd__decap_3
XFILLER_54_417 VGND VGND VPWR VPWR sky130_fd_sc_hd__decap_3
XTAP_TAPCELL_ROW_65_902 VGND VPWR sky130_fd_sc_hd__tapvpwrvgnd_1
XTAP_TAPCELL_ROW_37_604 VGND VPWR sky130_fd_sc_hd__tapvpwrvgnd_1
XTAP_TAPCELL_ROW_1_229 VGND VPWR sky130_fd_sc_hd__tapvpwrvgnd_1
XFILLER_94_597 VGND VGND VPWR VPWR sky130_fd_sc_hd__fill_1
XFILLER_54_439 VGND VGND VPWR VPWR sky130_fd_sc_hd__fill_1
XFILLER_81_214 VGND VGND VPWR VPWR sky130_fd_sc_hd__decap_3
XFILLER_81_225 VGND VGND VPWR VPWR sky130_fd_sc_hd__decap_3
X_6931_ _6931_/A _6931_/B _6931_/C VGND VGND VPWR VPWR _6931_/X sky130_fd_sc_hd__or3_2
XFILLER_19_193 VGND VGND VPWR VPWR sky130_fd_sc_hd__decap_3
XFILLER_34_141 VGND VGND VPWR VPWR sky130_fd_sc_hd__fill_1
XFILLER_34_152 VGND VGND VPWR VPWR sky130_fd_sc_hd__decap_3
X_6862_ _6867_/B _6862_/B VGND VGND VPWR VPWR _6862_/Y sky130_fd_sc_hd__nand2_2
XFILLER_22_325 VGND VGND VPWR VPWR sky130_fd_sc_hd__fill_2
XFILLER_34_174 VGND VGND VPWR VPWR sky130_fd_sc_hd__decap_3
XFILLER_62_483 VGND VGND VPWR VPWR sky130_fd_sc_hd__fill_1
X_5813_ _5812_/X _5746_/X _5745_/Y VGND VGND VPWR VPWR _5813_/X sky130_fd_sc_hd__a21o_4
XFILLER_22_358 VGND VGND VPWR VPWR sky130_fd_sc_hd__decap_3
X_6793_ _6795_/B _6793_/B _6793_/C VGND VGND VPWR VPWR _6794_/B sky130_fd_sc_hd__nor3_2
XTAP_TAPCELL_ROW_45_692 VGND VPWR sky130_fd_sc_hd__tapvpwrvgnd_1
XTAP_TAPCELL_ROW_17_394 VGND VPWR sky130_fd_sc_hd__tapvpwrvgnd_1
X_5744_ _5743_/A _5752_/A VGND VGND VPWR VPWR _5746_/B sky130_fd_sc_hd__and2b_2
XFILLER_30_380 VGND VGND VPWR VPWR sky130_fd_sc_hd__fill_1
X_5675_ _5675_/A _5675_/B VGND VGND VPWR VPWR _5711_/B sky130_fd_sc_hd__xor2_4
X_4626_ _4625_/B _4625_/C _4625_/A VGND VGND VPWR VPWR _4627_/B sky130_fd_sc_hd__a21oi_2
XTAP_TAPCELL_ROW_9_307 VGND VPWR sky130_fd_sc_hd__tapvpwrvgnd_1
XFILLER_1_207 VGND VGND VPWR VPWR sky130_fd_sc_hd__decap_3
X_4557_ _4557_/A1 _4454_/X _4469_/A _5885_/A VGND VGND VPWR VPWR _4558_/A sky130_fd_sc_hd__o211a_2
X_4488_ _4489_/A _4488_/B _4488_/C VGND VGND VPWR VPWR _4841_/A sky130_fd_sc_hd__nand3_2
X_3508_ _4432_/A _6929_/A _3869_/D _4290_/A VGND VGND VPWR VPWR _3509_/B sky130_fd_sc_hd__a22o_2
X_6227_ _6381_/C _6227_/B _6227_/C VGND VGND VPWR VPWR _6229_/A sky130_fd_sc_hd__and3_2
XFILLER_66_27 VGND VGND VPWR VPWR sky130_fd_sc_hd__fill_1
X_6158_ _6155_/X _6157_/X _6255_/A VGND VGND VPWR VPWR _6758_/B sky130_fd_sc_hd__a21o_2
Xload_slew490 fanout489/X VGND VGND VPWR VPWR _6621_/A1 sky130_fd_sc_hd__buf_2
X_5109_ _5108_/A _5108_/C _5108_/B VGND VGND VPWR VPWR _5110_/B sky130_fd_sc_hd__o21ai_2
XFILLER_57_277 VGND VGND VPWR VPWR sky130_fd_sc_hd__decap_3
XFILLER_85_564 VGND VGND VPWR VPWR sky130_fd_sc_hd__decap_3
X_6089_ _6090_/A _6089_/B VGND VGND VPWR VPWR _6207_/A sky130_fd_sc_hd__nand2_2
XFILLER_17_119 VGND VGND VPWR VPWR sky130_fd_sc_hd__fill_1
XFILLER_45_428 VGND VGND VPWR VPWR sky130_fd_sc_hd__fill_2
XFILLER_85_597 VGND VGND VPWR VPWR sky130_fd_sc_hd__fill_1
XFILLER_72_247 VGND VGND VPWR VPWR sky130_fd_sc_hd__decap_3
XFILLER_82_26 VGND VGND VPWR VPWR sky130_fd_sc_hd__fill_2
XFILLER_13_314 VGND VGND VPWR VPWR sky130_fd_sc_hd__decap_3
XFILLER_53_461 VGND VGND VPWR VPWR sky130_fd_sc_hd__fill_2
XTAP_TAPCELL_ROW_84_1097 VGND VPWR sky130_fd_sc_hd__tapvpwrvgnd_1
XFILLER_13_369 VGND VGND VPWR VPWR sky130_fd_sc_hd__decap_3
XFILLER_40_177 VGND VGND VPWR VPWR sky130_fd_sc_hd__decap_3
XFILLER_21_380 VGND VGND VPWR VPWR sky130_fd_sc_hd__decap_3
XFILLER_40_188 VGND VGND VPWR VPWR sky130_fd_sc_hd__decap_3
XFILLER_31_52 VGND VGND VPWR VPWR sky130_fd_sc_hd__decap_3
XFILLER_5_535 VGND VGND VPWR VPWR sky130_fd_sc_hd__decap_3
Xrebuffer684 _4558_/X VGND VGND VPWR VPWR _5890_/B1 sky130_fd_sc_hd__buf_2
Xrebuffer695 _5166_/X VGND VGND VPWR VPWR _5253_/B1 sky130_fd_sc_hd__buf_2
Xoutput85 output85/A VGND VGND VPWR VPWR result[22] sky130_fd_sc_hd__buf_8
Xoutput74 _6988_/B VGND VGND VPWR VPWR result[12] sky130_fd_sc_hd__dlymetal6s4s_1
XFILLER_0_240 VGND VGND VPWR VPWR sky130_fd_sc_hd__decap_3
Xoutput96 _6985_/C VGND VGND VPWR VPWR result[3] sky130_fd_sc_hd__dlymetal6s4s_1
XFILLER_0_284 VGND VGND VPWR VPWR sky130_fd_sc_hd__fill_2
XFILLER_88_380 VGND VGND VPWR VPWR sky130_fd_sc_hd__decap_3
XFILLER_48_266 VGND VGND VPWR VPWR sky130_fd_sc_hd__decap_3
XFILLER_63_203 VGND VGND VPWR VPWR sky130_fd_sc_hd__decap_3
XFILLER_76_564 VGND VGND VPWR VPWR sky130_fd_sc_hd__decap_3
XFILLER_36_439 VGND VGND VPWR VPWR sky130_fd_sc_hd__decap_3
XFILLER_56_82 VGND VGND VPWR VPWR sky130_fd_sc_hd__fill_2
XFILLER_63_225 VGND VGND VPWR VPWR sky130_fd_sc_hd__decap_3
XFILLER_63_258 VGND VGND VPWR VPWR sky130_fd_sc_hd__decap_3
XFILLER_16_152 VGND VGND VPWR VPWR sky130_fd_sc_hd__decap_3
XFILLER_44_472 VGND VGND VPWR VPWR sky130_fd_sc_hd__decap_3
XFILLER_31_133 VGND VGND VPWR VPWR sky130_fd_sc_hd__decap_3
X_3790_ _3538_/A _3537_/B _3537_/A VGND VGND VPWR VPWR _4044_/B sky130_fd_sc_hd__o21ba_2
XTAP_TAPCELL_ROW_42_662 VGND VPWR sky130_fd_sc_hd__tapvpwrvgnd_1
XTAP_TAPCELL_ROW_14_364 VGND VPWR sky130_fd_sc_hd__tapvpwrvgnd_1
X_5460_ _5433_/Y _5433_/A _5458_/X _5459_/Y VGND VGND VPWR VPWR _5462_/B sky130_fd_sc_hd__a211o_4
X_4411_ _4405_/A _4405_/C _4405_/B VGND VGND VPWR VPWR _4412_/C sky130_fd_sc_hd__a21o_2
X_5391_ _5475_/A _5475_/B VGND VGND VPWR VPWR _5393_/A sky130_fd_sc_hd__nand2b_4
X_4342_ _4455_/A _4455_/B _4339_/X VGND VGND VPWR VPWR _4344_/B sky130_fd_sc_hd__a21oi_2
Xfanout308 _6527_/A2 VGND VGND VPWR VPWR _6589_/B sky130_fd_sc_hd__clkdlybuf4s25_1
Xfanout319 input5/X VGND VGND VPWR VPWR _5374_/A sky130_fd_sc_hd__buf_4
X_4273_ _4518_/A _4524_/A _4517_/C _4517_/D VGND VGND VPWR VPWR _4273_/X sky130_fd_sc_hd__and4_2
XFILLER_98_144 VGND VGND VPWR VPWR sky130_fd_sc_hd__fill_1
XFILLER_100_116 VGND VGND VPWR VPWR sky130_fd_sc_hd__fill_1
XFILLER_86_317 VGND VGND VPWR VPWR sky130_fd_sc_hd__decap_3
X_6012_ _6012_/A _6012_/B VGND VGND VPWR VPWR _6044_/B sky130_fd_sc_hd__xnor2_2
.ends

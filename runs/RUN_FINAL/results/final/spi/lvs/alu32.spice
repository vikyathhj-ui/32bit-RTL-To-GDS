* NGSPICE file created from alu32.ext - technology: sky130A

* Black-box entry subcircuit for sky130_fd_sc_hd__tapvpwrvgnd_1 abstract view
.subckt sky130_fd_sc_hd__tapvpwrvgnd_1 VGND VPWR
.ends

* Black-box entry subcircuit for sky130_fd_sc_hd__nor2_1 abstract view
.subckt sky130_fd_sc_hd__nor2_1 A B VGND VNB VPB VPWR Y
.ends

* Black-box entry subcircuit for sky130_fd_sc_hd__decap_6 abstract view
.subckt sky130_fd_sc_hd__decap_6 VGND VNB VPB VPWR
.ends

* Black-box entry subcircuit for sky130_fd_sc_hd__fill_1 abstract view
.subckt sky130_fd_sc_hd__fill_1 VGND VNB VPB VPWR
.ends

* Black-box entry subcircuit for sky130_fd_sc_hd__a211o_1 abstract view
.subckt sky130_fd_sc_hd__a211o_1 A1 A2 B1 C1 VGND VNB VPB VPWR X
.ends

* Black-box entry subcircuit for sky130_fd_sc_hd__decap_8 abstract view
.subckt sky130_fd_sc_hd__decap_8 VGND VNB VPB VPWR
.ends

* Black-box entry subcircuit for sky130_fd_sc_hd__and2_1 abstract view
.subckt sky130_fd_sc_hd__and2_1 A B VGND VNB VPB VPWR X
.ends

* Black-box entry subcircuit for sky130_fd_sc_hd__buf_4 abstract view
.subckt sky130_fd_sc_hd__buf_4 A VGND VNB VPB VPWR X
.ends

* Black-box entry subcircuit for sky130_fd_sc_hd__decap_4 abstract view
.subckt sky130_fd_sc_hd__decap_4 VGND VNB VPB VPWR
.ends

* Black-box entry subcircuit for sky130_fd_sc_hd__fill_2 abstract view
.subckt sky130_fd_sc_hd__fill_2 VGND VNB VPB VPWR
.ends

* Black-box entry subcircuit for sky130_fd_sc_hd__xnor2_1 abstract view
.subckt sky130_fd_sc_hd__xnor2_1 A B VGND VNB VPB VPWR Y
.ends

* Black-box entry subcircuit for sky130_fd_sc_hd__mux2_1 abstract view
.subckt sky130_fd_sc_hd__mux2_1 A0 A1 S VGND VNB VPB VPWR X
.ends

* Black-box entry subcircuit for sky130_fd_sc_hd__decap_3 abstract view
.subckt sky130_fd_sc_hd__decap_3 VGND VNB VPB VPWR
.ends

* Black-box entry subcircuit for sky130_ef_sc_hd__decap_12 abstract view
.subckt sky130_ef_sc_hd__decap_12 VPWR VGND VPB VNB
.ends

* Black-box entry subcircuit for sky130_fd_sc_hd__a31o_1 abstract view
.subckt sky130_fd_sc_hd__a31o_1 A1 A2 A3 B1 VGND VNB VPB VPWR X
.ends

* Black-box entry subcircuit for sky130_fd_sc_hd__a21o_1 abstract view
.subckt sky130_fd_sc_hd__a21o_1 A1 A2 B1 VGND VNB VPB VPWR X
.ends

* Black-box entry subcircuit for sky130_fd_sc_hd__clkbuf_2 abstract view
.subckt sky130_fd_sc_hd__clkbuf_2 A VGND VNB VPB VPWR X
.ends

* Black-box entry subcircuit for sky130_fd_sc_hd__a22oi_1 abstract view
.subckt sky130_fd_sc_hd__a22oi_1 A1 A2 B1 B2 VGND VNB VPB VPWR Y
.ends

* Black-box entry subcircuit for sky130_fd_sc_hd__clkbuf_4 abstract view
.subckt sky130_fd_sc_hd__clkbuf_4 A VGND VNB VPB VPWR X
.ends

* Black-box entry subcircuit for sky130_fd_sc_hd__nand3_2 abstract view
.subckt sky130_fd_sc_hd__nand3_2 A B C VGND VNB VPB VPWR Y
.ends

* Black-box entry subcircuit for sky130_fd_sc_hd__a211oi_2 abstract view
.subckt sky130_fd_sc_hd__a211oi_2 A1 A2 B1 C1 VGND VNB VPB VPWR Y
.ends

* Black-box entry subcircuit for sky130_fd_sc_hd__nor2_2 abstract view
.subckt sky130_fd_sc_hd__nor2_2 A B VGND VNB VPB VPWR Y
.ends

* Black-box entry subcircuit for sky130_fd_sc_hd__or3_2 abstract view
.subckt sky130_fd_sc_hd__or3_2 A B C VGND VNB VPB VPWR X
.ends

* Black-box entry subcircuit for sky130_fd_sc_hd__o211a_1 abstract view
.subckt sky130_fd_sc_hd__o211a_1 A1 A2 B1 C1 VGND VNB VPB VPWR X
.ends

* Black-box entry subcircuit for sky130_fd_sc_hd__or3_1 abstract view
.subckt sky130_fd_sc_hd__or3_1 A B C VGND VNB VPB VPWR X
.ends

* Black-box entry subcircuit for sky130_fd_sc_hd__and3_1 abstract view
.subckt sky130_fd_sc_hd__and3_1 A B C VGND VNB VPB VPWR X
.ends

* Black-box entry subcircuit for sky130_fd_sc_hd__nand2_1 abstract view
.subckt sky130_fd_sc_hd__nand2_1 A B VGND VNB VPB VPWR Y
.ends

* Black-box entry subcircuit for sky130_fd_sc_hd__xor2_1 abstract view
.subckt sky130_fd_sc_hd__xor2_1 A B VGND VNB VPB VPWR X
.ends

* Black-box entry subcircuit for sky130_fd_sc_hd__nor3_4 abstract view
.subckt sky130_fd_sc_hd__nor3_4 A B C VGND VNB VPB VPWR Y
.ends

* Black-box entry subcircuit for sky130_fd_sc_hd__buf_8 abstract view
.subckt sky130_fd_sc_hd__buf_8 A VGND VNB VPB VPWR X
.ends

* Black-box entry subcircuit for sky130_fd_sc_hd__and2b_1 abstract view
.subckt sky130_fd_sc_hd__and2b_1 A_N B VGND VNB VPB VPWR X
.ends

* Black-box entry subcircuit for sky130_fd_sc_hd__a21oi_1 abstract view
.subckt sky130_fd_sc_hd__a21oi_1 A1 A2 B1 VGND VNB VPB VPWR Y
.ends

* Black-box entry subcircuit for sky130_fd_sc_hd__inv_2 abstract view
.subckt sky130_fd_sc_hd__inv_2 A VGND VNB VPB VPWR Y
.ends

* Black-box entry subcircuit for sky130_fd_sc_hd__or2_1 abstract view
.subckt sky130_fd_sc_hd__or2_1 A B VGND VNB VPB VPWR X
.ends

* Black-box entry subcircuit for sky130_fd_sc_hd__o21ai_1 abstract view
.subckt sky130_fd_sc_hd__o21ai_1 A1 A2 B1 VGND VNB VPB VPWR Y
.ends

* Black-box entry subcircuit for sky130_fd_sc_hd__and4bb_2 abstract view
.subckt sky130_fd_sc_hd__and4bb_2 A_N B_N C D VGND VNB VPB VPWR X
.ends

* Black-box entry subcircuit for sky130_fd_sc_hd__o21ba_1 abstract view
.subckt sky130_fd_sc_hd__o21ba_1 A1 A2 B1_N VGND VNB VPB VPWR X
.ends

* Black-box entry subcircuit for sky130_fd_sc_hd__a32o_1 abstract view
.subckt sky130_fd_sc_hd__a32o_1 A1 A2 A3 B1 B2 VGND VNB VPB VPWR X
.ends

* Black-box entry subcircuit for sky130_fd_sc_hd__a22oi_2 abstract view
.subckt sky130_fd_sc_hd__a22oi_2 A1 A2 B1 B2 VGND VNB VPB VPWR Y
.ends

* Black-box entry subcircuit for sky130_fd_sc_hd__o41a_1 abstract view
.subckt sky130_fd_sc_hd__o41a_1 A1 A2 A3 A4 B1 VGND VNB VPB VPWR X
.ends

* Black-box entry subcircuit for sky130_fd_sc_hd__or4b_1 abstract view
.subckt sky130_fd_sc_hd__or4b_1 A B C D_N VGND VNB VPB VPWR X
.ends

* Black-box entry subcircuit for sky130_fd_sc_hd__nand3_1 abstract view
.subckt sky130_fd_sc_hd__nand3_1 A B C VGND VNB VPB VPWR Y
.ends

* Black-box entry subcircuit for sky130_fd_sc_hd__xnor2_2 abstract view
.subckt sky130_fd_sc_hd__xnor2_2 A B VGND VNB VPB VPWR Y
.ends

* Black-box entry subcircuit for sky130_fd_sc_hd__o311a_2 abstract view
.subckt sky130_fd_sc_hd__o311a_2 A1 A2 A3 B1 C1 VGND VNB VPB VPWR X
.ends

* Black-box entry subcircuit for sky130_fd_sc_hd__o221a_1 abstract view
.subckt sky130_fd_sc_hd__o221a_1 A1 A2 B1 B2 C1 VGND VNB VPB VPWR X
.ends

* Black-box entry subcircuit for sky130_fd_sc_hd__buf_6 abstract view
.subckt sky130_fd_sc_hd__buf_6 A VGND VNB VPB VPWR X
.ends

* Black-box entry subcircuit for sky130_fd_sc_hd__diode_2 abstract view
.subckt sky130_fd_sc_hd__diode_2 DIODE VGND VNB VPB VPWR
.ends

* Black-box entry subcircuit for sky130_fd_sc_hd__buf_2 abstract view
.subckt sky130_fd_sc_hd__buf_2 A VGND VNB VPB VPWR X
.ends

* Black-box entry subcircuit for sky130_fd_sc_hd__dlymetal6s4s_1 abstract view
.subckt sky130_fd_sc_hd__dlymetal6s4s_1 A VGND VNB VPB VPWR X
.ends

* Black-box entry subcircuit for sky130_fd_sc_hd__a2bb2oi_1 abstract view
.subckt sky130_fd_sc_hd__a2bb2oi_1 A1_N A2_N B1 B2 VGND VNB VPB VPWR Y
.ends

* Black-box entry subcircuit for sky130_fd_sc_hd__o21a_1 abstract view
.subckt sky130_fd_sc_hd__o21a_1 A1 A2 B1 VGND VNB VPB VPWR X
.ends

* Black-box entry subcircuit for sky130_fd_sc_hd__and4_1 abstract view
.subckt sky130_fd_sc_hd__and4_1 A B C D VGND VNB VPB VPWR X
.ends

* Black-box entry subcircuit for sky130_fd_sc_hd__o21ai_2 abstract view
.subckt sky130_fd_sc_hd__o21ai_2 A1 A2 B1 VGND VNB VPB VPWR Y
.ends

* Black-box entry subcircuit for sky130_fd_sc_hd__mux2_2 abstract view
.subckt sky130_fd_sc_hd__mux2_2 A0 A1 S VGND VNB VPB VPWR X
.ends

* Black-box entry subcircuit for sky130_fd_sc_hd__nor3_2 abstract view
.subckt sky130_fd_sc_hd__nor3_2 A B C VGND VNB VPB VPWR Y
.ends

* Black-box entry subcircuit for sky130_fd_sc_hd__nand4b_2 abstract view
.subckt sky130_fd_sc_hd__nand4b_2 A_N B C D VGND VNB VPB VPWR Y
.ends

* Black-box entry subcircuit for sky130_fd_sc_hd__o211ai_2 abstract view
.subckt sky130_fd_sc_hd__o211ai_2 A1 A2 B1 C1 VGND VNB VPB VPWR Y
.ends

* Black-box entry subcircuit for sky130_fd_sc_hd__o22a_1 abstract view
.subckt sky130_fd_sc_hd__o22a_1 A1 A2 B1 B2 VGND VNB VPB VPWR X
.ends

* Black-box entry subcircuit for sky130_fd_sc_hd__nand2b_2 abstract view
.subckt sky130_fd_sc_hd__nand2b_2 A_N B VGND VNB VPB VPWR Y
.ends

* Black-box entry subcircuit for sky130_fd_sc_hd__a21oi_2 abstract view
.subckt sky130_fd_sc_hd__a21oi_2 A1 A2 B1 VGND VNB VPB VPWR Y
.ends

* Black-box entry subcircuit for sky130_fd_sc_hd__nand3_4 abstract view
.subckt sky130_fd_sc_hd__nand3_4 A B C VGND VNB VPB VPWR Y
.ends

* Black-box entry subcircuit for sky130_fd_sc_hd__o211a_2 abstract view
.subckt sky130_fd_sc_hd__o211a_2 A1 A2 B1 C1 VGND VNB VPB VPWR X
.ends

* Black-box entry subcircuit for sky130_fd_sc_hd__a221oi_1 abstract view
.subckt sky130_fd_sc_hd__a221oi_1 A1 A2 B1 B2 C1 VGND VNB VPB VPWR Y
.ends

* Black-box entry subcircuit for sky130_fd_sc_hd__a22o_1 abstract view
.subckt sky130_fd_sc_hd__a22o_1 A1 A2 B1 B2 VGND VNB VPB VPWR X
.ends

* Black-box entry subcircuit for sky130_fd_sc_hd__o32a_1 abstract view
.subckt sky130_fd_sc_hd__o32a_1 A1 A2 A3 B1 B2 VGND VNB VPB VPWR X
.ends

* Black-box entry subcircuit for sky130_fd_sc_hd__or3b_1 abstract view
.subckt sky130_fd_sc_hd__or3b_1 A B C_N VGND VNB VPB VPWR X
.ends

* Black-box entry subcircuit for sky130_fd_sc_hd__a2bb2o_1 abstract view
.subckt sky130_fd_sc_hd__a2bb2o_1 A1_N A2_N B1 B2 VGND VNB VPB VPWR X
.ends

* Black-box entry subcircuit for sky130_fd_sc_hd__a21bo_1 abstract view
.subckt sky130_fd_sc_hd__a21bo_1 A1 A2 B1_N VGND VNB VPB VPWR X
.ends

* Black-box entry subcircuit for sky130_fd_sc_hd__o211a_4 abstract view
.subckt sky130_fd_sc_hd__o211a_4 A1 A2 B1 C1 VGND VNB VPB VPWR X
.ends

* Black-box entry subcircuit for sky130_fd_sc_hd__and3_4 abstract view
.subckt sky130_fd_sc_hd__and3_4 A B C VGND VNB VPB VPWR X
.ends

* Black-box entry subcircuit for sky130_fd_sc_hd__or2b_1 abstract view
.subckt sky130_fd_sc_hd__or2b_1 A B_N VGND VNB VPB VPWR X
.ends

* Black-box entry subcircuit for sky130_fd_sc_hd__mux4_1 abstract view
.subckt sky130_fd_sc_hd__mux4_1 A0 A1 A2 A3 S0 S1 VGND VNB VPB VPWR X
.ends

* Black-box entry subcircuit for sky130_fd_sc_hd__clkbuf_1 abstract view
.subckt sky130_fd_sc_hd__clkbuf_1 A VGND VNB VPB VPWR X
.ends

* Black-box entry subcircuit for sky130_fd_sc_hd__dlygate4sd1_1 abstract view
.subckt sky130_fd_sc_hd__dlygate4sd1_1 A VGND VNB VPB VPWR X
.ends

* Black-box entry subcircuit for sky130_fd_sc_hd__nor3_1 abstract view
.subckt sky130_fd_sc_hd__nor3_1 A B C VGND VNB VPB VPWR Y
.ends

* Black-box entry subcircuit for sky130_fd_sc_hd__a211oi_1 abstract view
.subckt sky130_fd_sc_hd__a211oi_1 A1 A2 B1 C1 VGND VNB VPB VPWR Y
.ends

* Black-box entry subcircuit for sky130_fd_sc_hd__a211oi_4 abstract view
.subckt sky130_fd_sc_hd__a211oi_4 A1 A2 B1 C1 VGND VNB VPB VPWR Y
.ends

* Black-box entry subcircuit for sky130_fd_sc_hd__o311a_1 abstract view
.subckt sky130_fd_sc_hd__o311a_1 A1 A2 A3 B1 C1 VGND VNB VPB VPWR X
.ends

* Black-box entry subcircuit for sky130_fd_sc_hd__o22ai_1 abstract view
.subckt sky130_fd_sc_hd__o22ai_1 A1 A2 B1 B2 VGND VNB VPB VPWR Y
.ends

* Black-box entry subcircuit for sky130_fd_sc_hd__nand4_1 abstract view
.subckt sky130_fd_sc_hd__nand4_1 A B C D VGND VNB VPB VPWR Y
.ends

* Black-box entry subcircuit for sky130_fd_sc_hd__or3_4 abstract view
.subckt sky130_fd_sc_hd__or3_4 A B C VGND VNB VPB VPWR X
.ends

* Black-box entry subcircuit for sky130_fd_sc_hd__a41o_1 abstract view
.subckt sky130_fd_sc_hd__a41o_1 A1 A2 A3 A4 B1 VGND VNB VPB VPWR X
.ends

* Black-box entry subcircuit for sky130_fd_sc_hd__or4bb_4 abstract view
.subckt sky130_fd_sc_hd__or4bb_4 A B C_N D_N VGND VNB VPB VPWR X
.ends

* Black-box entry subcircuit for sky130_fd_sc_hd__nand3b_1 abstract view
.subckt sky130_fd_sc_hd__nand3b_1 A_N B C VGND VNB VPB VPWR Y
.ends

* Black-box entry subcircuit for sky130_fd_sc_hd__o211ai_1 abstract view
.subckt sky130_fd_sc_hd__o211ai_1 A1 A2 B1 C1 VGND VNB VPB VPWR Y
.ends

* Black-box entry subcircuit for sky130_fd_sc_hd__a311o_1 abstract view
.subckt sky130_fd_sc_hd__a311o_1 A1 A2 A3 B1 C1 VGND VNB VPB VPWR X
.ends

* Black-box entry subcircuit for sky130_fd_sc_hd__dlymetal6s2s_1 abstract view
.subckt sky130_fd_sc_hd__dlymetal6s2s_1 A VGND VNB VPB VPWR X
.ends

* Black-box entry subcircuit for sky130_fd_sc_hd__mux2_4 abstract view
.subckt sky130_fd_sc_hd__mux2_4 A0 A1 S VGND VNB VPB VPWR X
.ends

* Black-box entry subcircuit for sky130_fd_sc_hd__o31a_1 abstract view
.subckt sky130_fd_sc_hd__o31a_1 A1 A2 A3 B1 VGND VNB VPB VPWR X
.ends

* Black-box entry subcircuit for sky130_fd_sc_hd__or3b_4 abstract view
.subckt sky130_fd_sc_hd__or3b_4 A B C_N VGND VNB VPB VPWR X
.ends

* Black-box entry subcircuit for sky130_fd_sc_hd__a21o_2 abstract view
.subckt sky130_fd_sc_hd__a21o_2 A1 A2 B1 VGND VNB VPB VPWR X
.ends

* Black-box entry subcircuit for sky130_fd_sc_hd__nor4_1 abstract view
.subckt sky130_fd_sc_hd__nor4_1 A B C D VGND VNB VPB VPWR Y
.ends

* Black-box entry subcircuit for sky130_fd_sc_hd__nand2_2 abstract view
.subckt sky130_fd_sc_hd__nand2_2 A B VGND VNB VPB VPWR Y
.ends

* Black-box entry subcircuit for sky130_fd_sc_hd__o2bb2a_1 abstract view
.subckt sky130_fd_sc_hd__o2bb2a_1 A1_N A2_N B1 B2 VGND VNB VPB VPWR X
.ends

* Black-box entry subcircuit for sky130_fd_sc_hd__a31oi_2 abstract view
.subckt sky130_fd_sc_hd__a31oi_2 A1 A2 A3 B1 VGND VNB VPB VPWR Y
.ends

* Black-box entry subcircuit for sky130_fd_sc_hd__a211o_2 abstract view
.subckt sky130_fd_sc_hd__a211o_2 A1 A2 B1 C1 VGND VNB VPB VPWR X
.ends

* Black-box entry subcircuit for sky130_fd_sc_hd__o31a_2 abstract view
.subckt sky130_fd_sc_hd__o31a_2 A1 A2 A3 B1 VGND VNB VPB VPWR X
.ends

* Black-box entry subcircuit for sky130_fd_sc_hd__o31ai_2 abstract view
.subckt sky130_fd_sc_hd__o31ai_2 A1 A2 A3 B1 VGND VNB VPB VPWR Y
.ends

* Black-box entry subcircuit for sky130_fd_sc_hd__o211ai_4 abstract view
.subckt sky130_fd_sc_hd__o211ai_4 A1 A2 B1 C1 VGND VNB VPB VPWR Y
.ends

* Black-box entry subcircuit for sky130_fd_sc_hd__buf_1 abstract view
.subckt sky130_fd_sc_hd__buf_1 A VGND VNB VPB VPWR X
.ends

* Black-box entry subcircuit for sky130_fd_sc_hd__a221o_1 abstract view
.subckt sky130_fd_sc_hd__a221o_1 A1 A2 B1 B2 C1 VGND VNB VPB VPWR X
.ends

* Black-box entry subcircuit for sky130_fd_sc_hd__nand4_2 abstract view
.subckt sky130_fd_sc_hd__nand4_2 A B C D VGND VNB VPB VPWR Y
.ends

* Black-box entry subcircuit for sky130_fd_sc_hd__o21bai_1 abstract view
.subckt sky130_fd_sc_hd__o21bai_1 A1 A2 B1_N VGND VNB VPB VPWR Y
.ends

* Black-box entry subcircuit for sky130_fd_sc_hd__a211o_4 abstract view
.subckt sky130_fd_sc_hd__a211o_4 A1 A2 B1 C1 VGND VNB VPB VPWR X
.ends

* Black-box entry subcircuit for sky130_fd_sc_hd__or4_4 abstract view
.subckt sky130_fd_sc_hd__or4_4 A B C D VGND VNB VPB VPWR X
.ends

* Black-box entry subcircuit for sky130_fd_sc_hd__and3b_1 abstract view
.subckt sky130_fd_sc_hd__and3b_1 A_N B C VGND VNB VPB VPWR X
.ends

* Black-box entry subcircuit for sky130_fd_sc_hd__a2111o_1 abstract view
.subckt sky130_fd_sc_hd__a2111o_1 A1 A2 B1 C1 D1 VGND VNB VPB VPWR X
.ends

* Black-box entry subcircuit for sky130_fd_sc_hd__or2_4 abstract view
.subckt sky130_fd_sc_hd__or2_4 A B VGND VNB VPB VPWR X
.ends

* Black-box entry subcircuit for sky130_fd_sc_hd__nand2_4 abstract view
.subckt sky130_fd_sc_hd__nand2_4 A B VGND VNB VPB VPWR Y
.ends

* Black-box entry subcircuit for sky130_fd_sc_hd__a311oi_2 abstract view
.subckt sky130_fd_sc_hd__a311oi_2 A1 A2 A3 B1 C1 VGND VNB VPB VPWR Y
.ends

* Black-box entry subcircuit for sky130_fd_sc_hd__o31ai_1 abstract view
.subckt sky130_fd_sc_hd__o31ai_1 A1 A2 A3 B1 VGND VNB VPB VPWR Y
.ends

* Black-box entry subcircuit for sky130_fd_sc_hd__nor2b_2 abstract view
.subckt sky130_fd_sc_hd__nor2b_2 A B_N VGND VNB VPB VPWR Y
.ends

* Black-box entry subcircuit for sky130_fd_sc_hd__and4bb_1 abstract view
.subckt sky130_fd_sc_hd__and4bb_1 A_N B_N C D VGND VNB VPB VPWR X
.ends

* Black-box entry subcircuit for sky130_fd_sc_hd__or4_1 abstract view
.subckt sky130_fd_sc_hd__or4_1 A B C D VGND VNB VPB VPWR X
.ends

* Black-box entry subcircuit for sky130_fd_sc_hd__a21oi_4 abstract view
.subckt sky130_fd_sc_hd__a21oi_4 A1 A2 B1 VGND VNB VPB VPWR Y
.ends

* Black-box entry subcircuit for sky130_fd_sc_hd__nand4_4 abstract view
.subckt sky130_fd_sc_hd__nand4_4 A B C D VGND VNB VPB VPWR Y
.ends

* Black-box entry subcircuit for sky130_fd_sc_hd__nor2b_1 abstract view
.subckt sky130_fd_sc_hd__nor2b_1 A B_N VGND VNB VPB VPWR Y
.ends

* Black-box entry subcircuit for sky130_fd_sc_hd__o22ai_2 abstract view
.subckt sky130_fd_sc_hd__o22ai_2 A1 A2 B1 B2 VGND VNB VPB VPWR Y
.ends

* Black-box entry subcircuit for sky130_fd_sc_hd__o311ai_4 abstract view
.subckt sky130_fd_sc_hd__o311ai_4 A1 A2 A3 B1 C1 VGND VNB VPB VPWR Y
.ends

* Black-box entry subcircuit for sky130_fd_sc_hd__or2_2 abstract view
.subckt sky130_fd_sc_hd__or2_2 A B VGND VNB VPB VPWR X
.ends

* Black-box entry subcircuit for sky130_fd_sc_hd__nor3b_2 abstract view
.subckt sky130_fd_sc_hd__nor3b_2 A B C_N VGND VNB VPB VPWR Y
.ends

* Black-box entry subcircuit for sky130_fd_sc_hd__xor2_4 abstract view
.subckt sky130_fd_sc_hd__xor2_4 A B VGND VNB VPB VPWR X
.ends

* Black-box entry subcircuit for sky130_fd_sc_hd__nand3b_2 abstract view
.subckt sky130_fd_sc_hd__nand3b_2 A_N B C VGND VNB VPB VPWR Y
.ends

* Black-box entry subcircuit for sky130_fd_sc_hd__a31oi_1 abstract view
.subckt sky130_fd_sc_hd__a31oi_1 A1 A2 A3 B1 VGND VNB VPB VPWR Y
.ends

* Black-box entry subcircuit for sky130_fd_sc_hd__a21boi_1 abstract view
.subckt sky130_fd_sc_hd__a21boi_1 A1 A2 B1_N VGND VNB VPB VPWR Y
.ends

* Black-box entry subcircuit for sky130_fd_sc_hd__and3b_2 abstract view
.subckt sky130_fd_sc_hd__and3b_2 A_N B C VGND VNB VPB VPWR X
.ends

* Black-box entry subcircuit for sky130_fd_sc_hd__or4_2 abstract view
.subckt sky130_fd_sc_hd__or4_2 A B C D VGND VNB VPB VPWR X
.ends

* Black-box entry subcircuit for sky130_fd_sc_hd__o221ai_2 abstract view
.subckt sky130_fd_sc_hd__o221ai_2 A1 A2 B1 B2 C1 VGND VNB VPB VPWR Y
.ends

* Black-box entry subcircuit for sky130_fd_sc_hd__clkbuf_16 abstract view
.subckt sky130_fd_sc_hd__clkbuf_16 A VGND VNB VPB VPWR X
.ends

* Black-box entry subcircuit for sky130_fd_sc_hd__buf_12 abstract view
.subckt sky130_fd_sc_hd__buf_12 A VGND VNB VPB VPWR X
.ends

* Black-box entry subcircuit for sky130_fd_sc_hd__nor4_2 abstract view
.subckt sky130_fd_sc_hd__nor4_2 A B C D VGND VNB VPB VPWR Y
.ends

* Black-box entry subcircuit for sky130_fd_sc_hd__xor2_2 abstract view
.subckt sky130_fd_sc_hd__xor2_2 A B VGND VNB VPB VPWR X
.ends

* Black-box entry subcircuit for sky130_fd_sc_hd__nor4_4 abstract view
.subckt sky130_fd_sc_hd__nor4_4 A B C D VGND VNB VPB VPWR Y
.ends

* Black-box entry subcircuit for sky130_fd_sc_hd__a22oi_4 abstract view
.subckt sky130_fd_sc_hd__a22oi_4 A1 A2 B1 B2 VGND VNB VPB VPWR Y
.ends

* Black-box entry subcircuit for sky130_fd_sc_hd__o21ba_4 abstract view
.subckt sky130_fd_sc_hd__o21ba_4 A1 A2 B1_N VGND VNB VPB VPWR X
.ends

* Black-box entry subcircuit for sky130_fd_sc_hd__nor4b_4 abstract view
.subckt sky130_fd_sc_hd__nor4b_4 A B C D_N VGND VNB VPB VPWR Y
.ends

* Black-box entry subcircuit for sky130_fd_sc_hd__and2_4 abstract view
.subckt sky130_fd_sc_hd__and2_4 A B VGND VNB VPB VPWR X
.ends

* Black-box entry subcircuit for sky130_fd_sc_hd__o21bai_2 abstract view
.subckt sky130_fd_sc_hd__o21bai_2 A1 A2 B1_N VGND VNB VPB VPWR Y
.ends

* Black-box entry subcircuit for sky130_fd_sc_hd__clkbuf_8 abstract view
.subckt sky130_fd_sc_hd__clkbuf_8 A VGND VNB VPB VPWR X
.ends

* Black-box entry subcircuit for sky130_fd_sc_hd__o2111a_1 abstract view
.subckt sky130_fd_sc_hd__o2111a_1 A1 A2 B1 C1 D1 VGND VNB VPB VPWR X
.ends

* Black-box entry subcircuit for sky130_fd_sc_hd__a311oi_4 abstract view
.subckt sky130_fd_sc_hd__a311oi_4 A1 A2 A3 B1 C1 VGND VNB VPB VPWR Y
.ends

* Black-box entry subcircuit for sky130_fd_sc_hd__and3_2 abstract view
.subckt sky130_fd_sc_hd__and3_2 A B C VGND VNB VPB VPWR X
.ends

* Black-box entry subcircuit for sky130_fd_sc_hd__a31o_4 abstract view
.subckt sky130_fd_sc_hd__a31o_4 A1 A2 A3 B1 VGND VNB VPB VPWR X
.ends

* Black-box entry subcircuit for sky130_fd_sc_hd__o32ai_1 abstract view
.subckt sky130_fd_sc_hd__o32ai_1 A1 A2 A3 B1 B2 VGND VNB VPB VPWR Y
.ends

* Black-box entry subcircuit for sky130_fd_sc_hd__and2_2 abstract view
.subckt sky130_fd_sc_hd__and2_2 A B VGND VNB VPB VPWR X
.ends

* Black-box entry subcircuit for sky130_fd_sc_hd__xnor2_4 abstract view
.subckt sky130_fd_sc_hd__xnor2_4 A B VGND VNB VPB VPWR Y
.ends

* Black-box entry subcircuit for sky130_fd_sc_hd__nor3b_1 abstract view
.subckt sky130_fd_sc_hd__nor3b_1 A B C_N VGND VNB VPB VPWR Y
.ends

* Black-box entry subcircuit for sky130_fd_sc_hd__or3b_2 abstract view
.subckt sky130_fd_sc_hd__or3b_2 A B C_N VGND VNB VPB VPWR X
.ends

* Black-box entry subcircuit for sky130_fd_sc_hd__o22ai_4 abstract view
.subckt sky130_fd_sc_hd__o22ai_4 A1 A2 B1 B2 VGND VNB VPB VPWR Y
.ends

* Black-box entry subcircuit for sky130_fd_sc_hd__and4b_1 abstract view
.subckt sky130_fd_sc_hd__and4b_1 A_N B C D VGND VNB VPB VPWR X
.ends

* Black-box entry subcircuit for sky130_fd_sc_hd__a311o_4 abstract view
.subckt sky130_fd_sc_hd__a311o_4 A1 A2 A3 B1 C1 VGND VNB VPB VPWR X
.ends

* Black-box entry subcircuit for sky130_fd_sc_hd__or2b_4 abstract view
.subckt sky130_fd_sc_hd__or2b_4 A B_N VGND VNB VPB VPWR X
.ends

* Black-box entry subcircuit for sky130_fd_sc_hd__a2111oi_1 abstract view
.subckt sky130_fd_sc_hd__a2111oi_1 A1 A2 B1 C1 D1 VGND VNB VPB VPWR Y
.ends

* Black-box entry subcircuit for sky130_fd_sc_hd__nor2_4 abstract view
.subckt sky130_fd_sc_hd__nor2_4 A B VGND VNB VPB VPWR Y
.ends

* Black-box entry subcircuit for sky130_fd_sc_hd__and4_4 abstract view
.subckt sky130_fd_sc_hd__and4_4 A B C D VGND VNB VPB VPWR X
.ends

* Black-box entry subcircuit for sky130_fd_sc_hd__nor3b_4 abstract view
.subckt sky130_fd_sc_hd__nor3b_4 A B C_N VGND VNB VPB VPWR Y
.ends

* Black-box entry subcircuit for sky130_fd_sc_hd__or4b_4 abstract view
.subckt sky130_fd_sc_hd__or4b_4 A B C D_N VGND VNB VPB VPWR X
.ends

.subckt alu32 A[0] A[10] A[11] A[12] A[13] A[14] A[15] A[16] A[17] A[18] A[19] A[1]
+ A[20] A[21] A[22] A[23] A[24] A[25] A[26] A[27] A[28] A[29] A[2] A[30] A[31] A[3]
+ A[4] A[5] A[6] A[7] A[8] A[9] B[0] B[10] B[11] B[12] B[13] B[14] B[15] B[16] B[17]
+ B[18] B[19] B[1] B[20] B[21] B[22] B[23] B[24] B[25] B[26] B[27] B[28] B[29] B[2]
+ B[30] B[31] B[3] B[4] B[5] B[6] B[7] B[8] B[9] VGND VPWR carry opcode[0] opcode[1]
+ opcode[2] opcode[3] overflow result[0] result[10] result[11] result[12] result[13]
+ result[14] result[15] result[16] result[17] result[18] result[19] result[1] result[20]
+ result[21] result[22] result[23] result[24] result[25] result[26] result[27] result[28]
+ result[29] result[2] result[30] result[31] result[3] result[4] result[5] result[6]
+ result[7] result[8] result[9] zero
XTAP_TAPCELL_ROW_68_1015 VGND VPWR sky130_fd_sc_hd__tapvpwrvgnd_1
X_6914_ _2368_ _2369_ VGND VGND VPWR VPWR _2370_ sky130_fd_sc_hd__nor2_1
XFILLER_0_77_634 VGND VGND VPWR VPWR sky130_fd_sc_hd__decap_6
XFILLER_0_76_155 VGND VGND VPWR VPWR sky130_fd_sc_hd__fill_1
X_6845_ _2129_ _2131_ _2293_ _2294_ VGND VGND VPWR VPWR _2295_ sky130_fd_sc_hd__a211o_1
XFILLER_0_107_419 VGND VGND VPWR VPWR sky130_fd_sc_hd__decap_6
XFILLER_0_76_188 VGND VGND VPWR VPWR sky130_fd_sc_hd__decap_8
X_6776_ _2109_ _2110_ VGND VGND VPWR VPWR _2219_ sky130_fd_sc_hd__and2_1
X_3988_ _1610_ VGND VGND VPWR VPWR _1621_ sky130_fd_sc_hd__buf_4
XFILLER_0_91_169 VGND VGND VPWR VPWR sky130_fd_sc_hd__decap_4
XFILLER_0_45_542 VGND VGND VPWR VPWR sky130_fd_sc_hd__fill_2
X_5727_ _1071_ _1072_ VGND VGND VPWR VPWR _1073_ sky130_fd_sc_hd__nor2_1
XFILLER_0_45_597 VGND VGND VPWR VPWR sky130_fd_sc_hd__fill_1
XTAP_TAPCELL_ROW_79_1144 VGND VPWR sky130_fd_sc_hd__tapvpwrvgnd_1
X_5658_ _0994_ _0996_ VGND VGND VPWR VPWR _0997_ sky130_fd_sc_hd__xnor2_1
XTAP_TAPCELL_ROW_92_1300 VGND VPWR sky130_fd_sc_hd__tapvpwrvgnd_1
X_4609_ _3599_ _3714_ _3407_ VGND VGND VPWR VPWR _3715_ sky130_fd_sc_hd__mux2_1
XFILLER_0_60_589 VGND VGND VPWR VPWR sky130_fd_sc_hd__decap_3
XFILLER_0_13_461 VPWR VGND VPWR VGND sky130_ef_sc_hd__decap_12
X_5589_ _3163_ net36 _0756_ _0755_ VGND VGND VPWR VPWR _0923_ sky130_fd_sc_hd__a31o_1
X_7328_ _2821_ _2822_ VGND VGND VPWR VPWR _2823_ sky130_fd_sc_hd__xnor2_1
X_7259_ _2525_ _2732_ _2746_ VGND VGND VPWR VPWR _2748_ sky130_fd_sc_hd__a21o_1
XFILLER_0_40_291 VGND VGND VPWR VPWR sky130_fd_sc_hd__decap_6
XFILLER_0_99_225 VGND VGND VPWR VPWR sky130_fd_sc_hd__fill_1
XFILLER_0_68_601 VPWR VGND VPWR VGND sky130_ef_sc_hd__decap_12
XFILLER_0_68_645 VGND VGND VPWR VPWR sky130_fd_sc_hd__decap_6
XFILLER_0_95_453 VGND VGND VPWR VPWR sky130_fd_sc_hd__fill_1
XFILLER_0_83_626 VGND VGND VPWR VPWR sky130_fd_sc_hd__decap_6
XFILLER_0_83_604 VGND VGND VPWR VPWR sky130_fd_sc_hd__fill_1
XFILLER_0_28_509 VGND VGND VPWR VPWR sky130_fd_sc_hd__decap_8
XFILLER_0_82_114 VGND VGND VPWR VPWR sky130_fd_sc_hd__fill_1
XFILLER_0_82_158 VGND VGND VPWR VPWR sky130_fd_sc_hd__decap_8
XFILLER_0_36_531 VGND VGND VPWR VPWR sky130_fd_sc_hd__fill_1
XFILLER_0_36_597 VGND VGND VPWR VPWR sky130_fd_sc_hd__fill_1
XTAP_TAPCELL_ROW_11_367 VGND VPWR sky130_fd_sc_hd__tapvpwrvgnd_1
Xrebuffer7 _1190_ VGND VGND VPWR VPWR net125 sky130_fd_sc_hd__clkbuf_2
XFILLER_0_23_225 VGND VGND VPWR VPWR sky130_fd_sc_hd__fill_1
XFILLER_0_106_485 VGND VGND VPWR VPWR sky130_fd_sc_hd__fill_1
XFILLER_0_48_48 VGND VGND VPWR VPWR sky130_fd_sc_hd__fill_1
XFILLER_0_3_39 VPWR VGND VPWR VGND sky130_ef_sc_hd__decap_12
XFILLER_0_59_601 VPWR VGND VPWR VGND sky130_ef_sc_hd__decap_12
XTAP_TAPCELL_ROW_19_456 VGND VPWR sky130_fd_sc_hd__tapvpwrvgnd_1
XFILLER_0_86_442 VGND VGND VPWR VPWR sky130_fd_sc_hd__fill_2
XFILLER_0_80_13 VPWR VGND VPWR VGND sky130_ef_sc_hd__decap_12
X_4960_ _2386_ _3623_ _1566_ _3449_ VGND VGND VPWR VPWR _0237_ sky130_fd_sc_hd__a22oi_1
XTAP_TAPCELL_ROW_47_776 VGND VPWR sky130_fd_sc_hd__tapvpwrvgnd_1
X_3911_ _0769_ VGND VGND VPWR VPWR _0780_ sky130_fd_sc_hd__clkbuf_4
X_4891_ _0128_ _0160_ _0161_ VGND VGND VPWR VPWR _0162_ sky130_fd_sc_hd__nand3_2
XFILLER_0_46_306 VGND VGND VPWR VPWR sky130_fd_sc_hd__fill_2
XFILLER_0_104_53 VPWR VGND VPWR VGND sky130_ef_sc_hd__decap_12
XFILLER_0_80_68 VPWR VGND VPWR VGND sky130_ef_sc_hd__decap_12
XFILLER_0_13_51 VGND VGND VPWR VPWR sky130_fd_sc_hd__decap_4
X_6630_ _2056_ _2057_ _1906_ _1908_ VGND VGND VPWR VPWR _2060_ sky130_fd_sc_hd__a211oi_2
XFILLER_0_104_97 VGND VGND VPWR VPWR sky130_fd_sc_hd__decap_6
X_6561_ _3489_ _0010_ VGND VGND VPWR VPWR _1985_ sky130_fd_sc_hd__nor2_2
XFILLER_0_73_169 VPWR VGND VPWR VGND sky130_ef_sc_hd__decap_12
XFILLER_0_39_391 VGND VGND VPWR VPWR sky130_fd_sc_hd__fill_1
XFILLER_0_89_33 VGND VGND VPWR VPWR sky130_fd_sc_hd__decap_3
XFILLER_0_89_11 VGND VGND VPWR VPWR sky130_fd_sc_hd__decap_3
X_5512_ _0747_ _0718_ _0837_ VGND VGND VPWR VPWR _0839_ sky130_fd_sc_hd__or3_2
XFILLER_0_6_469 VGND VGND VPWR VPWR sky130_fd_sc_hd__decap_6
XFILLER_0_89_55 VGND VGND VPWR VPWR sky130_fd_sc_hd__fill_1
X_6492_ _1906_ _1907_ _1742_ _1744_ VGND VGND VPWR VPWR _1909_ sky130_fd_sc_hd__o211a_1
X_5443_ _0760_ _0761_ _0762_ VGND VGND VPWR VPWR _0763_ sky130_fd_sc_hd__or3_1
XFILLER_0_42_589 VPWR VGND VPWR VGND sky130_ef_sc_hd__decap_12
X_5374_ _0687_ _0686_ _0667_ VGND VGND VPWR VPWR _0688_ sky130_fd_sc_hd__and3_1
XFILLER_0_1_152 VGND VGND VPWR VPWR sky130_fd_sc_hd__fill_1
X_4325_ _3434_ _3435_ _3311_ VGND VGND VPWR VPWR _3436_ sky130_fd_sc_hd__mux2_1
X_7113_ _1577_ _0802_ VGND VGND VPWR VPWR _2588_ sky130_fd_sc_hd__nand2_1
XTAP_TAPCELL_ROW_74_1085 VGND VPWR sky130_fd_sc_hd__tapvpwrvgnd_1
XFILLER_0_10_475 VGND VGND VPWR VPWR sky130_fd_sc_hd__fill_1
X_4256_ _3349_ _3353_ _3359_ _3367_ VGND VGND VPWR VPWR _3368_ sky130_fd_sc_hd__a211o_1
X_7044_ _2510_ _2511_ VGND VGND VPWR VPWR _2512_ sky130_fd_sc_hd__xor2_1
X_4187_ net63 net64 _3298_ VGND VGND VPWR VPWR _3299_ sky130_fd_sc_hd__nor3_4
XFILLER_0_49_111 VGND VGND VPWR VPWR sky130_fd_sc_hd__fill_1
XFILLER_0_49_144 VPWR VGND VPWR VGND sky130_ef_sc_hd__decap_12
XFILLER_0_92_412 VGND VGND VPWR VPWR sky130_fd_sc_hd__decap_8
X_6828_ _2049_ _2051_ _2274_ VGND VGND VPWR VPWR _2276_ sky130_fd_sc_hd__and3_1
XFILLER_0_49_188 VPWR VGND VPWR VGND sky130_ef_sc_hd__decap_12
XFILLER_0_92_445 VPWR VGND VPWR VGND sky130_ef_sc_hd__decap_12
XFILLER_0_64_136 VGND VGND VPWR VPWR sky130_fd_sc_hd__decap_4
XFILLER_0_52_309 VPWR VGND VPWR VGND sky130_ef_sc_hd__decap_12
XFILLER_0_92_489 VGND VGND VPWR VPWR sky130_fd_sc_hd__decap_8
X_6759_ _2192_ _2193_ _2198_ VGND VGND VPWR VPWR _2201_ sky130_fd_sc_hd__a21o_1
XFILLER_0_72_191 VGND VGND VPWR VPWR sky130_fd_sc_hd__decap_4
XFILLER_0_33_523 VGND VGND VPWR VPWR sky130_fd_sc_hd__decap_6
XFILLER_0_45_383 VGND VGND VPWR VPWR sky130_fd_sc_hd__decap_8
XFILLER_0_60_375 VGND VGND VPWR VPWR sky130_fd_sc_hd__fill_1
XFILLER_0_18_29 VGND VGND VPWR VPWR sky130_fd_sc_hd__decap_4
XFILLER_0_87_239 VGND VGND VPWR VPWR sky130_fd_sc_hd__fill_2
XTAP_TAPCELL_ROW_16_415 VGND VPWR sky130_fd_sc_hd__tapvpwrvgnd_1
XTAP_TAPCELL_ROW_16_426 VGND VPWR sky130_fd_sc_hd__tapvpwrvgnd_1
XTAP_TAPCELL_ROW_44_746 VGND VPWR sky130_fd_sc_hd__tapvpwrvgnd_1
XFILLER_0_83_434 VGND VGND VPWR VPWR sky130_fd_sc_hd__decap_4
XFILLER_0_56_637 VGND VGND VPWR VPWR sky130_fd_sc_hd__decap_6
XFILLER_0_50_49 VGND VGND VPWR VPWR sky130_fd_sc_hd__decap_3
XFILLER_0_55_136 VPWR VGND VPWR VGND sky130_ef_sc_hd__decap_12
XFILLER_0_71_629 VGND VGND VPWR VPWR sky130_fd_sc_hd__decap_6
XFILLER_0_63_180 VPWR VGND VPWR VGND sky130_ef_sc_hd__decap_12
XFILLER_0_36_383 VGND VGND VPWR VPWR sky130_fd_sc_hd__fill_2
XFILLER_0_3_428 VGND VGND VPWR VPWR sky130_fd_sc_hd__fill_1
XFILLER_0_24_589 VGND VGND VPWR VPWR sky130_fd_sc_hd__decap_4
XFILLER_0_59_47 VGND VGND VPWR VPWR sky130_fd_sc_hd__decap_8
XFILLER_0_11_217 VGND VGND VPWR VPWR sky130_fd_sc_hd__decap_6
XFILLER_0_75_46 VGND VGND VPWR VPWR sky130_fd_sc_hd__decap_8
X_5090_ _3257_ net117 VGND VGND VPWR VPWR _0379_ sky130_fd_sc_hd__nand2_1
X_4110_ net53 VGND VGND VPWR VPWR _2955_ sky130_fd_sc_hd__buf_8
XFILLER_0_75_57 VGND VGND VPWR VPWR sky130_fd_sc_hd__fill_1
X_4041_ _0780_ _0813_ VGND VGND VPWR VPWR _2200_ sky130_fd_sc_hd__and2b_1
XTAP_TAPCELL_ROW_108_1479 VGND VPWR sky130_fd_sc_hd__tapvpwrvgnd_1
X_5992_ _1064_ _1094_ _0717_ _1362_ VGND VGND VPWR VPWR _1363_ sky130_fd_sc_hd__o211a_1
X_4943_ _0207_ _0208_ _0217_ VGND VGND VPWR VPWR _0218_ sky130_fd_sc_hd__a21oi_1
XFILLER_0_47_615 VGND VGND VPWR VPWR sky130_fd_sc_hd__fill_1
X_7662_ _3177_ _3188_ VGND VGND VPWR VPWR _3189_ sky130_fd_sc_hd__xnor2_1
X_4874_ _3032_ _1654_ VGND VGND VPWR VPWR _0143_ sky130_fd_sc_hd__nand2_1
X_6613_ _2030_ _2040_ VGND VGND VPWR VPWR _2041_ sky130_fd_sc_hd__xnor2_1
X_7593_ _3111_ _3112_ VGND VGND VPWR VPWR _3113_ sky130_fd_sc_hd__xnor2_1
XFILLER_0_27_361 VPWR VGND VPWR VGND sky130_ef_sc_hd__decap_12
XFILLER_0_34_309 VGND VGND VPWR VPWR sky130_fd_sc_hd__decap_3
XFILLER_0_46_169 VGND VGND VPWR VPWR sky130_fd_sc_hd__decap_4
X_6544_ _1648_ VGND VGND VPWR VPWR _1966_ sky130_fd_sc_hd__inv_2
XTAP_TAPCELL_ROW_76_1114 VGND VPWR sky130_fd_sc_hd__tapvpwrvgnd_1
XFILLER_0_70_651 VGND VGND VPWR VPWR sky130_fd_sc_hd__fill_1
X_6475_ _1490_ _1839_ VGND VGND VPWR VPWR _1890_ sky130_fd_sc_hd__and2_1
XFILLER_0_40_82 VGND VGND VPWR VPWR sky130_fd_sc_hd__fill_2
X_5426_ _0735_ _0742_ VGND VGND VPWR VPWR _0744_ sky130_fd_sc_hd__or2_1
XFILLER_0_30_548 VPWR VGND VPWR VGND sky130_ef_sc_hd__decap_12
XFILLER_0_2_461 VGND VGND VPWR VPWR sky130_fd_sc_hd__decap_8
X_5357_ _3448_ _2036_ _1555_ _3622_ VGND VGND VPWR VPWR _0669_ sky130_fd_sc_hd__a22oi_1
X_4308_ _3410_ _3418_ VGND VGND VPWR VPWR _3419_ sky130_fd_sc_hd__nand2_1
X_5288_ _2014_ _0395_ _1435_ VGND VGND VPWR VPWR _0594_ sky130_fd_sc_hd__o21ai_1
X_4239_ net63 net66 net65 net64 VGND VGND VPWR VPWR _3351_ sky130_fd_sc_hd__and4bb_2
X_7027_ _2323_ _2469_ _2470_ VGND VGND VPWR VPWR _2493_ sky130_fd_sc_hd__o21ba_1
XFILLER_0_4_93 VGND VGND VPWR VPWR sky130_fd_sc_hd__fill_2
XTAP_TAPCELL_ROW_87_1232 VGND VPWR sky130_fd_sc_hd__tapvpwrvgnd_1
XFILLER_0_77_261 VGND VGND VPWR VPWR sky130_fd_sc_hd__decap_6
XFILLER_0_65_412 VPWR VGND VPWR VGND sky130_ef_sc_hd__decap_12
XTAP_TAPCELL_ROW_41_705 VGND VPWR sky130_fd_sc_hd__tapvpwrvgnd_1
XFILLER_0_108_525 VGND VGND VPWR VPWR sky130_fd_sc_hd__decap_6
XFILLER_0_77_294 VGND VGND VPWR VPWR sky130_fd_sc_hd__fill_1
XFILLER_0_37_125 VPWR VGND VPWR VGND sky130_ef_sc_hd__decap_12
XFILLER_0_92_286 VPWR VGND VPWR VGND sky130_ef_sc_hd__decap_12
XFILLER_0_92_253 VGND VGND VPWR VPWR sky130_fd_sc_hd__decap_4
XFILLER_0_52_117 VPWR VGND VPWR VGND sky130_ef_sc_hd__decap_12
XFILLER_0_53_629 VGND VGND VPWR VPWR sky130_fd_sc_hd__decap_3
XFILLER_0_18_372 VPWR VGND VPWR VGND sky130_ef_sc_hd__decap_12
XFILLER_0_33_331 VGND VGND VPWR VPWR sky130_fd_sc_hd__decap_4
XTAP_TAPCELL_ROW_98_1361 VGND VPWR sky130_fd_sc_hd__tapvpwrvgnd_1
XTAP_TAPCELL_ROW_21_473 VGND VPWR sky130_fd_sc_hd__tapvpwrvgnd_1
XFILLER_0_21_526 VGND VGND VPWR VPWR sky130_fd_sc_hd__decap_6
XFILLER_0_103_263 VGND VGND VPWR VPWR sky130_fd_sc_hd__fill_1
XFILLER_0_60_194 VGND VGND VPWR VPWR sky130_fd_sc_hd__fill_2
XFILLER_0_103_296 VGND VGND VPWR VPWR sky130_fd_sc_hd__fill_2
XTAP_TAPCELL_ROW_49_805 VGND VPWR sky130_fd_sc_hd__tapvpwrvgnd_1
XPHY_EDGE_ROW_100_Left_210 VGND VGND VPWR VPWR sky130_fd_sc_hd__decap_3
XFILLER_0_88_504 VGND VGND VPWR VPWR sky130_fd_sc_hd__decap_3
XTAP_TAPCELL_ROW_29_573 VGND VPWR sky130_fd_sc_hd__tapvpwrvgnd_1
XTAP_TAPCELL_ROW_57_893 VGND VPWR sky130_fd_sc_hd__tapvpwrvgnd_1
XFILLER_0_0_29 VPWR VGND VPWR VGND sky130_ef_sc_hd__decap_12
XFILLER_0_68_272 VGND VGND VPWR VPWR sky130_fd_sc_hd__fill_1
XFILLER_0_56_401 VPWR VGND VPWR VGND sky130_ef_sc_hd__decap_12
XFILLER_0_29_615 VGND VGND VPWR VPWR sky130_fd_sc_hd__fill_1
XFILLER_0_83_220 VGND VGND VPWR VPWR sky130_fd_sc_hd__decap_4
XFILLER_0_83_253 VPWR VGND VPWR VGND sky130_ef_sc_hd__decap_12
XFILLER_0_71_426 VGND VGND VPWR VPWR sky130_fd_sc_hd__fill_1
XFILLER_0_71_404 VGND VGND VPWR VPWR sky130_fd_sc_hd__decap_3
XFILLER_0_44_629 VGND VGND VPWR VPWR sky130_fd_sc_hd__decap_4
XPHY_EDGE_ROW_104_Right_104 VGND VGND VPWR VPWR sky130_fd_sc_hd__decap_3
XFILLER_0_71_459 VGND VGND VPWR VPWR sky130_fd_sc_hd__fill_2
X_4590_ _3043_ _2572_ _3629_ _3559_ _3509_ VGND VGND VPWR VPWR _3696_ sky130_fd_sc_hd__a32o_1
XFILLER_0_9_27 VPWR VGND VPWR VGND sky130_ef_sc_hd__decap_12
XFILLER_0_3_225 VPWR VGND VPWR VGND sky130_ef_sc_hd__decap_12
XFILLER_0_52_651 VGND VGND VPWR VPWR sky130_fd_sc_hd__fill_1
XFILLER_0_10_41 VPWR VGND VPWR VGND sky130_ef_sc_hd__decap_12
X_6260_ _2157_ _3379_ _1089_ VGND VGND VPWR VPWR _1656_ sky130_fd_sc_hd__mux2_1
XFILLER_0_10_85 VGND VGND VPWR VPWR sky130_fd_sc_hd__fill_1
X_5211_ _0501_ _0509_ VGND VGND VPWR VPWR _0510_ sky130_fd_sc_hd__nor2_1
X_6191_ _1578_ _1579_ VGND VGND VPWR VPWR _1580_ sky130_fd_sc_hd__nor2_1
XFILLER_0_20_581 VGND VGND VPWR VPWR sky130_fd_sc_hd__decap_6
X_5142_ _3119_ _1796_ _1599_ _3692_ VGND VGND VPWR VPWR _0435_ sky130_fd_sc_hd__a22oi_2
XTAP_TAPCELL_ROW_71_1055 VGND VPWR sky130_fd_sc_hd__tapvpwrvgnd_1
X_5073_ _0259_ _0307_ _0358_ _0359_ VGND VGND VPWR VPWR _0360_ sky130_fd_sc_hd__a211o_1
X_4024_ _1993_ _2003_ VGND VGND VPWR VPWR _2014_ sky130_fd_sc_hd__or2_1
XFILLER_0_94_507 VGND VGND VPWR VPWR sky130_fd_sc_hd__decap_8
XFILLER_0_66_209 VPWR VGND VPWR VGND sky130_ef_sc_hd__decap_12
XFILLER_0_35_93 VPWR VGND VPWR VGND sky130_ef_sc_hd__decap_12
X_5975_ _1205_ _1343_ VGND VGND VPWR VPWR _1344_ sky130_fd_sc_hd__xor2_1
X_7714_ _0050_ _3062_ _3066_ _3223_ _1214_ VGND VGND VPWR VPWR _3244_ sky130_fd_sc_hd__o41a_1
X_4926_ _3374_ _0193_ _0199_ VGND VGND VPWR VPWR _0200_ sky130_fd_sc_hd__a21oi_1
XFILLER_0_19_125 VGND VGND VPWR VPWR sky130_fd_sc_hd__decap_8
X_7645_ _2846_ _2594_ _0083_ net50 VGND VGND VPWR VPWR _3170_ sky130_fd_sc_hd__or4b_1
XTAP_TAPCELL_ROW_82_1184 VGND VPWR sky130_fd_sc_hd__tapvpwrvgnd_1
XFILLER_0_7_520 VPWR VGND VPWR VGND sky130_ef_sc_hd__decap_12
XFILLER_0_19_169 VGND VGND VPWR VPWR sky130_fd_sc_hd__decap_6
XFILLER_0_35_629 VGND VGND VPWR VPWR sky130_fd_sc_hd__decap_3
X_4857_ _0122_ _0123_ VGND VGND VPWR VPWR _0124_ sky130_fd_sc_hd__or2_1
X_7576_ _3092_ _3093_ VGND VGND VPWR VPWR _3094_ sky130_fd_sc_hd__and2b_1
X_6527_ _1787_ _1886_ _1945_ _1946_ VGND VGND VPWR VPWR _1947_ sky130_fd_sc_hd__o211a_1
X_4788_ _2671_ _2627_ _1665_ net149 VGND VGND VPWR VPWR _0049_ sky130_fd_sc_hd__a22oi_2
XFILLER_0_15_364 VGND VGND VPWR VPWR sky130_fd_sc_hd__fill_1
XFILLER_0_30_356 VGND VGND VPWR VPWR sky130_fd_sc_hd__decap_8
X_6458_ _1865_ _1869_ _1870_ VGND VGND VPWR VPWR _1871_ sky130_fd_sc_hd__nand3_1
X_5409_ _2058_ _1479_ _3360_ VGND VGND VPWR VPWR _0727_ sky130_fd_sc_hd__mux2_1
XFILLER_0_2_280 VGND VGND VPWR VPWR sky130_fd_sc_hd__fill_2
X_6389_ _1794_ net119 _1629_ net108 VGND VGND VPWR VPWR _1797_ sky130_fd_sc_hd__a211oi_2
XFILLER_0_30_389 VPWR VGND VPWR VGND sky130_ef_sc_hd__decap_12
XFILLER_0_100_244 VGND VGND VPWR VPWR sky130_fd_sc_hd__fill_1
XFILLER_0_97_334 VGND VGND VPWR VPWR sky130_fd_sc_hd__fill_2
XTAP_TAPCELL_ROW_26_532 VGND VPWR sky130_fd_sc_hd__tapvpwrvgnd_1
XTAP_TAPCELL_ROW_54_852 VGND VPWR sky130_fd_sc_hd__tapvpwrvgnd_1
XTAP_TAPCELL_ROW_54_863 VGND VPWR sky130_fd_sc_hd__tapvpwrvgnd_1
XFILLER_0_38_434 VGND VGND VPWR VPWR sky130_fd_sc_hd__fill_1
XFILLER_0_18_191 VGND VGND VPWR VPWR sky130_fd_sc_hd__decap_4
XFILLER_0_34_651 VGND VGND VPWR VPWR sky130_fd_sc_hd__fill_1
XFILLER_0_53_459 VGND VGND VPWR VPWR sky130_fd_sc_hd__decap_6
XFILLER_0_61_481 VPWR VGND VPWR VGND sky130_ef_sc_hd__decap_12
XFILLER_0_40_109 VPWR VGND VPWR VGND sky130_ef_sc_hd__decap_12
XFILLER_0_104_572 VPWR VGND VPWR VGND sky130_ef_sc_hd__decap_12
XFILLER_0_56_37 VGND VGND VPWR VPWR sky130_fd_sc_hd__fill_1
XFILLER_0_72_58 VPWR VGND VPWR VGND sky130_ef_sc_hd__decap_12
XTAP_TAPCELL_ROW_105_1449 VGND VPWR sky130_fd_sc_hd__tapvpwrvgnd_1
XFILLER_0_69_581 VGND VGND VPWR VPWR sky130_fd_sc_hd__decap_8
X_5760_ _0994_ VGND VGND VPWR VPWR _1109_ sky130_fd_sc_hd__inv_2
XFILLER_0_56_253 VGND VGND VPWR VPWR sky130_fd_sc_hd__fill_2
X_5691_ _1033_ _1027_ VGND VGND VPWR VPWR _1034_ sky130_fd_sc_hd__xnor2_2
XFILLER_0_17_607 VGND VGND VPWR VPWR sky130_fd_sc_hd__decap_8
XFILLER_0_17_629 VPWR VGND VPWR VGND sky130_ef_sc_hd__decap_12
X_4711_ _3813_ _3814_ VGND VGND VPWR VPWR _3815_ sky130_fd_sc_hd__xnor2_1
X_4642_ _3417_ VGND VGND VPWR VPWR _3747_ sky130_fd_sc_hd__clkbuf_4
X_7430_ _2932_ _2934_ VGND VGND VPWR VPWR _2935_ sky130_fd_sc_hd__xor2_1
XFILLER_0_56_286 VGND VGND VPWR VPWR sky130_fd_sc_hd__decap_8
XFILLER_0_16_128 VPWR VGND VPWR VGND sky130_ef_sc_hd__decap_12
XFILLER_0_102_509 VGND VGND VPWR VPWR sky130_fd_sc_hd__decap_8
X_7361_ _2679_ _2689_ _2688_ VGND VGND VPWR VPWR _2859_ sky130_fd_sc_hd__a21o_1
X_4573_ _2747_ _3607_ _3653_ _3678_ _2539_ VGND VGND VPWR VPWR _3679_ sky130_fd_sc_hd__o311a_2
XFILLER_0_4_545 VPWR VGND VPWR VGND sky130_ef_sc_hd__decap_12
XFILLER_0_97_55 VGND VGND VPWR VPWR sky130_fd_sc_hd__fill_1
X_7292_ _2779_ _2781_ _2782_ VGND VGND VPWR VPWR _2784_ sky130_fd_sc_hd__and3_1
XFILLER_0_4_589 VPWR VGND VPWR VGND sky130_ef_sc_hd__decap_12
X_6312_ _1705_ _1710_ _1711_ VGND VGND VPWR VPWR _1712_ sky130_fd_sc_hd__and3_1
XFILLER_0_40_643 VGND VGND VPWR VPWR sky130_fd_sc_hd__fill_1
XFILLER_0_52_492 VPWR VGND VPWR VGND sky130_ef_sc_hd__decap_12
XFILLER_0_97_77 VPWR VGND VPWR VGND sky130_ef_sc_hd__decap_12
XFILLER_0_12_356 VGND VGND VPWR VPWR sky130_fd_sc_hd__decap_4
X_6243_ _1634_ _1635_ _1529_ VGND VGND VPWR VPWR _1637_ sky130_fd_sc_hd__a21oi_1
X_6174_ _1558_ _1559_ _1545_ VGND VGND VPWR VPWR _1561_ sky130_fd_sc_hd__a21oi_1
X_5125_ _3259_ _3751_ _3747_ _0413_ _0415_ VGND VGND VPWR VPWR _0416_ sky130_fd_sc_hd__o221a_1
XFILLER_0_34_3 VGND VGND VPWR VPWR sky130_fd_sc_hd__decap_8
XFILLER_0_98_109 VGND VGND VPWR VPWR sky130_fd_sc_hd__decap_3
X_5056_ _3520_ _1829_ _1643_ _0242_ VGND VGND VPWR VPWR _0341_ sky130_fd_sc_hd__a22oi_2
X_4007_ net2 VGND VGND VPWR VPWR _1829_ sky130_fd_sc_hd__buf_6
XFILLER_0_46_92 VGND VGND VPWR VPWR sky130_fd_sc_hd__decap_8
XTAP_TAPCELL_ROW_84_1202 VGND VPWR sky130_fd_sc_hd__tapvpwrvgnd_1
XFILLER_0_79_367 VGND VGND VPWR VPWR sky130_fd_sc_hd__decap_8
XFILLER_0_94_315 VGND VGND VPWR VPWR sky130_fd_sc_hd__fill_1
X_5958_ _1305_ _1323_ _1324_ VGND VGND VPWR VPWR _1325_ sky130_fd_sc_hd__and3_1
XTAP_TAPCELL_ROW_23_502 VGND VPWR sky130_fd_sc_hd__tapvpwrvgnd_1
XTAP_TAPCELL_ROW_51_822 VGND VPWR sky130_fd_sc_hd__tapvpwrvgnd_1
X_4909_ _0087_ _0026_ VGND VGND VPWR VPWR _0182_ sky130_fd_sc_hd__nand2_1
XFILLER_0_90_521 VGND VGND VPWR VPWR sky130_fd_sc_hd__decap_3
X_5889_ _1117_ _1125_ VGND VGND VPWR VPWR _1250_ sky130_fd_sc_hd__nand2_1
XFILLER_0_90_554 VPWR VGND VPWR VGND sky130_ef_sc_hd__decap_12
X_7628_ _3140_ _3150_ VGND VGND VPWR VPWR _3151_ sky130_fd_sc_hd__xnor2_2
X_7559_ _3314_ net23 VGND VGND VPWR VPWR _3076_ sky130_fd_sc_hd__nand2_1
XFILLER_0_15_150 VGND VGND VPWR VPWR sky130_fd_sc_hd__fill_2
XTAP_TAPCELL_ROW_31_590 VGND VPWR sky130_fd_sc_hd__tapvpwrvgnd_1
XFILLER_0_50_429 VGND VGND VPWR VPWR sky130_fd_sc_hd__fill_1
XTAP_TAPCELL_ROW_95_1331 VGND VPWR sky130_fd_sc_hd__tapvpwrvgnd_1
XFILLER_0_101_586 VGND VGND VPWR VPWR sky130_fd_sc_hd__fill_1
XTAP_TAPCELL_ROW_59_911 VGND VPWR sky130_fd_sc_hd__tapvpwrvgnd_1
XTAP_TAPCELL_ROW_3_271 VGND VPWR sky130_fd_sc_hd__tapvpwrvgnd_1
XFILLER_0_97_142 VGND VGND VPWR VPWR sky130_fd_sc_hd__decap_4
XFILLER_0_58_507 VPWR VGND VPWR VGND sky130_ef_sc_hd__decap_12
XTAP_TAPCELL_ROW_39_690 VGND VPWR sky130_fd_sc_hd__tapvpwrvgnd_1
XFILLER_0_85_359 VPWR VGND VPWR VGND sky130_ef_sc_hd__decap_12
XFILLER_0_85_337 VPWR VGND VPWR VGND sky130_ef_sc_hd__decap_12
XFILLER_0_42_39 VPWR VGND VPWR VGND sky130_ef_sc_hd__decap_12
XFILLER_0_38_242 VGND VGND VPWR VPWR sky130_fd_sc_hd__fill_1
XFILLER_0_38_253 VGND VGND VPWR VPWR sky130_fd_sc_hd__decap_3
XFILLER_0_53_223 VGND VGND VPWR VPWR sky130_fd_sc_hd__fill_1
XFILLER_0_53_256 VPWR VGND VPWR VGND sky130_ef_sc_hd__decap_12
XFILLER_0_41_429 VPWR VGND VPWR VGND sky130_ef_sc_hd__decap_12
XANTENNA_5 _2714_ VGND VGND VPWR VPWR sky130_fd_sc_hd__diode_2
XFILLER_0_22_621 VPWR VGND VPWR VGND sky130_ef_sc_hd__decap_12
XFILLER_0_34_492 VGND VGND VPWR VPWR sky130_fd_sc_hd__fill_2
XFILLER_0_1_537 VGND VGND VPWR VPWR sky130_fd_sc_hd__decap_6
XFILLER_0_1_559 VGND VGND VPWR VPWR sky130_fd_sc_hd__fill_1
XFILLER_0_67_25 VGND VGND VPWR VPWR sky130_fd_sc_hd__decap_3
XFILLER_0_83_35 VGND VGND VPWR VPWR sky130_fd_sc_hd__decap_3
XFILLER_0_83_57 VGND VGND VPWR VPWR sky130_fd_sc_hd__decap_8
Xrebuffer17 _1055_ VGND VGND VPWR VPWR net135 sky130_fd_sc_hd__buf_2
Xrebuffer28 _2122_ VGND VGND VPWR VPWR net146 sky130_fd_sc_hd__dlymetal6s4s_1
X_6930_ _2361_ _2362_ _2384_ _2385_ VGND VGND VPWR VPWR _2388_ sky130_fd_sc_hd__a2bb2oi_1
X_6861_ _1657_ _2312_ _1366_ VGND VGND VPWR VPWR _2313_ sky130_fd_sc_hd__mux2_1
XFILLER_0_88_197 VPWR VGND VPWR VGND sky130_ef_sc_hd__decap_12
X_5812_ _1555_ _1719_ VGND VGND VPWR VPWR _1166_ sky130_fd_sc_hd__nand2_1
X_6792_ _2228_ _2236_ VGND VGND VPWR VPWR _2237_ sky130_fd_sc_hd__xnor2_1
X_5743_ _0841_ _1090_ _0842_ VGND VGND VPWR VPWR _1091_ sky130_fd_sc_hd__mux2_1
XFILLER_0_57_573 VPWR VGND VPWR VGND sky130_ef_sc_hd__decap_12
XFILLER_0_8_125 VGND VGND VPWR VPWR sky130_fd_sc_hd__fill_1
X_5674_ _1013_ _1014_ VGND VGND VPWR VPWR _1015_ sky130_fd_sc_hd__nor2_1
X_7413_ _2899_ _2901_ _2914_ VGND VGND VPWR VPWR _2916_ sky130_fd_sc_hd__o21a_1
X_4625_ _2780_ _3593_ _2791_ _2758_ VGND VGND VPWR VPWR _3731_ sky130_fd_sc_hd__o211a_1
X_4556_ _2813_ VGND VGND VPWR VPWR _3663_ sky130_fd_sc_hd__inv_2
X_7344_ _2839_ _2840_ VGND VGND VPWR VPWR _2841_ sky130_fd_sc_hd__or2_1
X_4487_ _2780_ _3593_ VGND VGND VPWR VPWR _3595_ sky130_fd_sc_hd__or2_1
X_7275_ _1577_ _1850_ _1293_ _1206_ VGND VGND VPWR VPWR _2765_ sky130_fd_sc_hd__and4_1
XFILLER_0_12_197 VPWR VGND VPWR VGND sky130_ef_sc_hd__decap_12
X_6226_ _1615_ _1616_ _1607_ VGND VGND VPWR VPWR _1618_ sky130_fd_sc_hd__a21o_1
XTAP_TAPCELL_ROW_90_1272 VGND VPWR sky130_fd_sc_hd__tapvpwrvgnd_1
X_6157_ _1396_ _1399_ _1397_ VGND VGND VPWR VPWR _1542_ sky130_fd_sc_hd__o21ba_1
X_5108_ _0374_ _0375_ _0380_ _0397_ VGND VGND VPWR VPWR _0398_ sky130_fd_sc_hd__o211a_1
X_6088_ net42 net12 VGND VGND VPWR VPWR _1467_ sky130_fd_sc_hd__nand2_1
XFILLER_0_79_120 VPWR VGND VPWR VGND sky130_ef_sc_hd__decap_12
XTAP_TAPCELL_ROW_0_230 VGND VPWR sky130_fd_sc_hd__tapvpwrvgnd_1
X_5039_ _0226_ _0228_ VGND VGND VPWR VPWR _0323_ sky130_fd_sc_hd__nand2_1
XTAP_TAPCELL_ROW_0_241 VGND VPWR sky130_fd_sc_hd__tapvpwrvgnd_1
XFILLER_0_79_197 VGND VGND VPWR VPWR sky130_fd_sc_hd__decap_6
XFILLER_0_67_337 VGND VGND VPWR VPWR sky130_fd_sc_hd__decap_4
XFILLER_0_35_223 VGND VGND VPWR VPWR sky130_fd_sc_hd__fill_1
XFILLER_0_106_601 VPWR VGND VPWR VGND sky130_ef_sc_hd__decap_12
XFILLER_0_106_645 VGND VGND VPWR VPWR sky130_fd_sc_hd__decap_6
XFILLER_0_105_111 VGND VGND VPWR VPWR sky130_fd_sc_hd__fill_1
XTAP_TAPCELL_ROW_8_330 VGND VPWR sky130_fd_sc_hd__tapvpwrvgnd_1
Xoutput75 net75 VGND VGND VPWR VPWR result[15] sky130_fd_sc_hd__buf_2
Xoutput86 net86 VGND VGND VPWR VPWR result[25] sky130_fd_sc_hd__clkbuf_4
Xoutput97 net97 VGND VGND VPWR VPWR result[6] sky130_fd_sc_hd__buf_2
XFILLER_0_98_451 VGND VGND VPWR VPWR sky130_fd_sc_hd__decap_8
XFILLER_0_86_613 VPWR VGND VPWR VGND sky130_ef_sc_hd__decap_12
XTAP_TAPCELL_ROW_102_1408 VGND VPWR sky130_fd_sc_hd__tapvpwrvgnd_1
XFILLER_0_39_584 VGND VGND VPWR VPWR sky130_fd_sc_hd__decap_8
XFILLER_0_109_483 VGND VGND VPWR VPWR sky130_fd_sc_hd__decap_8
XTAP_TAPCELL_ROW_14_398 VGND VPWR sky130_fd_sc_hd__tapvpwrvgnd_1
XFILLER_0_26_256 VPWR VGND VPWR VGND sky130_ef_sc_hd__decap_12
XFILLER_0_81_373 VGND VGND VPWR VPWR sky130_fd_sc_hd__fill_2
XFILLER_0_54_587 VGND VGND VPWR VPWR sky130_fd_sc_hd__fill_1
X_4410_ net1 net11 _3518_ _2966_ VGND VGND VPWR VPWR _3519_ sky130_fd_sc_hd__and4_1
X_5390_ _0701_ _0702_ _0581_ VGND VGND VPWR VPWR _0706_ sky130_fd_sc_hd__o21ai_2
X_4341_ _3447_ _3451_ _3313_ VGND VGND VPWR VPWR _3452_ sky130_fd_sc_hd__mux2_1
XFILLER_0_22_473 VGND VGND VPWR VPWR sky130_fd_sc_hd__decap_3
X_4272_ _0192_ _0148_ _3307_ VGND VGND VPWR VPWR _3384_ sky130_fd_sc_hd__mux2_2
X_7060_ _2515_ _2516_ _2529_ VGND VGND VPWR VPWR _2530_ sky130_fd_sc_hd__nor3_2
X_6011_ _1355_ _1358_ _1373_ _1383_ VGND VGND VPWR VPWR net81 sky130_fd_sc_hd__nand4b_2
XFILLER_0_27_50 VGND VGND VPWR VPWR sky130_fd_sc_hd__decap_6
XTAP_TAPCELL_ROW_68_1016 VGND VPWR sky130_fd_sc_hd__tapvpwrvgnd_1
X_6913_ _2047_ _1468_ _1413_ _3254_ VGND VGND VPWR VPWR _2369_ sky130_fd_sc_hd__and4_1
XFILLER_0_49_304 VPWR VGND VPWR VGND sky130_ef_sc_hd__decap_12
XFILLER_0_76_167 VGND VGND VPWR VPWR sky130_fd_sc_hd__fill_1
X_6844_ _2291_ _2292_ _2019_ _2158_ VGND VGND VPWR VPWR _2294_ sky130_fd_sc_hd__a211oi_2
XFILLER_0_43_71 VPWR VGND VPWR VGND sky130_ef_sc_hd__decap_12
XFILLER_0_57_381 VGND VGND VPWR VPWR sky130_fd_sc_hd__decap_4
X_3987_ _1599_ VGND VGND VPWR VPWR _1610_ sky130_fd_sc_hd__clkbuf_4
X_6775_ _2215_ _2216_ _2082_ _2184_ VGND VGND VPWR VPWR _2218_ sky130_fd_sc_hd__o211a_1
X_5726_ _1069_ _1070_ _0978_ VGND VGND VPWR VPWR _1072_ sky130_fd_sc_hd__a21oi_1
XFILLER_0_72_362 VGND VGND VPWR VPWR sky130_fd_sc_hd__fill_2
XFILLER_0_103_604 VPWR VGND VPWR VGND sky130_ef_sc_hd__decap_12
XTAP_TAPCELL_ROW_79_1145 VGND VPWR sky130_fd_sc_hd__tapvpwrvgnd_1
X_5657_ _0740_ _0929_ _0995_ VGND VGND VPWR VPWR _0996_ sky130_fd_sc_hd__o21a_1
X_4608_ _3325_ _2802_ _3317_ VGND VGND VPWR VPWR _3714_ sky130_fd_sc_hd__mux2_1
X_5588_ _0752_ _0773_ _0771_ VGND VGND VPWR VPWR _0921_ sky130_fd_sc_hd__o21ai_1
X_4539_ _3589_ _3645_ VGND VGND VPWR VPWR _3646_ sky130_fd_sc_hd__nor2_2
X_7327_ _2933_ _0116_ VGND VGND VPWR VPWR _2822_ sky130_fd_sc_hd__nand2_1
XFILLER_0_13_473 VPWR VGND VPWR VGND sky130_ef_sc_hd__decap_12
X_7258_ _2738_ _2745_ VGND VGND VPWR VPWR _2746_ sky130_fd_sc_hd__xnor2_1
X_6209_ _1591_ _1597_ _1598_ VGND VGND VPWR VPWR _1600_ sky130_fd_sc_hd__and3_1
X_7189_ _0442_ _2669_ VGND VGND VPWR VPWR _2672_ sky130_fd_sc_hd__or2_1
XFILLER_0_68_613 VPWR VGND VPWR VGND sky130_ef_sc_hd__decap_12
XTAP_TAPCELL_ROW_11_368 VGND VPWR sky130_fd_sc_hd__tapvpwrvgnd_1
XFILLER_0_2_109 VPWR VGND VPWR VGND sky130_ef_sc_hd__decap_12
Xrebuffer8 _1784_ VGND VGND VPWR VPWR net126 sky130_fd_sc_hd__buf_4
XFILLER_0_51_568 VGND VGND VPWR VPWR sky130_fd_sc_hd__fill_2
XFILLER_0_31_281 VGND VGND VPWR VPWR sky130_fd_sc_hd__decap_4
XFILLER_0_31_292 VGND VGND VPWR VPWR sky130_fd_sc_hd__decap_6
XFILLER_0_101_191 VGND VGND VPWR VPWR sky130_fd_sc_hd__fill_1
XFILLER_0_64_15 VPWR VGND VPWR VGND sky130_ef_sc_hd__decap_12
XFILLER_0_64_37 VGND VGND VPWR VPWR sky130_fd_sc_hd__fill_1
XFILLER_0_59_613 VGND VGND VPWR VPWR sky130_fd_sc_hd__decap_3
XFILLER_0_86_421 VGND VGND VPWR VPWR sky130_fd_sc_hd__decap_6
XFILLER_0_59_646 VGND VGND VPWR VPWR sky130_fd_sc_hd__fill_2
XTAP_TAPCELL_ROW_19_457 VGND VPWR sky130_fd_sc_hd__tapvpwrvgnd_1
XTAP_TAPCELL_ROW_47_777 VGND VPWR sky130_fd_sc_hd__tapvpwrvgnd_1
XFILLER_0_80_25 VGND VGND VPWR VPWR sky130_fd_sc_hd__decap_3
X_3910_ _0758_ VGND VGND VPWR VPWR _0769_ sky130_fd_sc_hd__clkbuf_4
X_4890_ _0157_ _0158_ _0065_ _0067_ VGND VGND VPWR VPWR _0161_ sky130_fd_sc_hd__o211ai_2
XFILLER_0_73_104 VGND VGND VPWR VPWR sky130_fd_sc_hd__fill_1
XFILLER_0_104_65 VPWR VGND VPWR VGND sky130_ef_sc_hd__decap_12
X_6560_ _3536_ _0017_ _3300_ VGND VGND VPWR VPWR _1984_ sky130_fd_sc_hd__a21oi_1
XFILLER_0_73_148 VGND VGND VPWR VPWR sky130_fd_sc_hd__decap_8
XFILLER_0_54_340 VGND VGND VPWR VPWR sky130_fd_sc_hd__fill_1
X_5511_ _0718_ _0837_ _0747_ VGND VGND VPWR VPWR _0838_ sky130_fd_sc_hd__o21a_1
XFILLER_0_27_587 VGND VGND VPWR VPWR sky130_fd_sc_hd__fill_1
XFILLER_0_89_45 VGND VGND VPWR VPWR sky130_fd_sc_hd__fill_2
XFILLER_0_14_226 VGND VGND VPWR VPWR sky130_fd_sc_hd__decap_4
X_6491_ _1742_ _1744_ _1906_ _1907_ VGND VGND VPWR VPWR _1908_ sky130_fd_sc_hd__a211oi_2
X_5442_ _2441_ _0433_ _1599_ _2375_ VGND VGND VPWR VPWR _0762_ sky130_fd_sc_hd__a22oi_2
XFILLER_0_42_557 VGND VGND VPWR VPWR sky130_fd_sc_hd__fill_1
XFILLER_0_10_410 VGND VGND VPWR VPWR sky130_fd_sc_hd__decap_8
X_5373_ _0683_ _0684_ _0685_ VGND VGND VPWR VPWR _0687_ sky130_fd_sc_hd__a21o_1
XFILLER_0_2_643 VGND VGND VPWR VPWR sky130_fd_sc_hd__fill_1
X_4324_ net19 net20 _3306_ VGND VGND VPWR VPWR _3435_ sky130_fd_sc_hd__mux2_1
X_7112_ _2585_ _2586_ VGND VGND VPWR VPWR _2587_ sky130_fd_sc_hd__nor2_1
XFILLER_0_10_421 VPWR VGND VPWR VGND sky130_ef_sc_hd__decap_12
X_7043_ _2714_ _0922_ VGND VGND VPWR VPWR _2511_ sky130_fd_sc_hd__nand2_1
XTAP_TAPCELL_ROW_74_1086 VGND VPWR sky130_fd_sc_hd__tapvpwrvgnd_1
X_4255_ _3330_ _3360_ _3362_ _3366_ VGND VGND VPWR VPWR _3367_ sky130_fd_sc_hd__o22a_1
X_4186_ net65 net66 VGND VGND VPWR VPWR _3298_ sky130_fd_sc_hd__nand2b_2
XFILLER_0_38_82 VGND VGND VPWR VPWR sky130_fd_sc_hd__fill_2
XFILLER_0_96_218 VGND VGND VPWR VPWR sky130_fd_sc_hd__decap_8
XFILLER_0_89_281 VPWR VGND VPWR VGND sky130_ef_sc_hd__decap_12
XFILLER_0_49_156 VPWR VGND VPWR VGND sky130_ef_sc_hd__decap_12
X_6827_ _2049_ _2051_ _2274_ VGND VGND VPWR VPWR _2275_ sky130_fd_sc_hd__a21oi_2
XFILLER_0_92_468 VGND VGND VPWR VPWR sky130_fd_sc_hd__fill_1
X_6758_ _2192_ _2193_ _2198_ VGND VGND VPWR VPWR _2199_ sky130_fd_sc_hd__nand3_1
XFILLER_0_60_332 VGND VGND VPWR VPWR sky130_fd_sc_hd__decap_4
X_5709_ net134 _1051_ _1050_ VGND VGND VPWR VPWR _1054_ sky130_fd_sc_hd__nand3_4
X_6689_ _1947_ _1950_ _2122_ _2123_ VGND VGND VPWR VPWR _2125_ sky130_fd_sc_hd__o211a_2
XFILLER_0_60_365 VGND VGND VPWR VPWR sky130_fd_sc_hd__decap_3
XFILLER_0_60_354 VGND VGND VPWR VPWR sky130_fd_sc_hd__decap_8
XFILLER_0_33_557 VGND VGND VPWR VPWR sky130_fd_sc_hd__decap_3
XFILLER_0_13_281 VGND VGND VPWR VPWR sky130_fd_sc_hd__decap_8
XFILLER_0_87_229 VGND VGND VPWR VPWR sky130_fd_sc_hd__fill_1
XFILLER_0_68_421 VGND VGND VPWR VPWR sky130_fd_sc_hd__fill_2
XTAP_TAPCELL_ROW_16_416 VGND VPWR sky130_fd_sc_hd__tapvpwrvgnd_1
XTAP_TAPCELL_ROW_44_747 VGND VPWR sky130_fd_sc_hd__tapvpwrvgnd_1
XFILLER_0_56_627 VGND VGND VPWR VPWR sky130_fd_sc_hd__fill_2
XFILLER_0_28_329 VPWR VGND VPWR VGND sky130_ef_sc_hd__decap_12
XFILLER_0_55_148 VPWR VGND VPWR VGND sky130_ef_sc_hd__decap_12
XFILLER_0_36_340 VPWR VGND VPWR VGND sky130_ef_sc_hd__decap_12
XFILLER_0_106_250 VGND VGND VPWR VPWR sky130_fd_sc_hd__fill_2
XFILLER_0_63_192 VPWR VGND VPWR VGND sky130_ef_sc_hd__decap_12
XFILLER_0_59_15 VPWR VGND VPWR VGND sky130_ef_sc_hd__decap_12
X_4040_ _0671_ VGND VGND VPWR VPWR _2189_ sky130_fd_sc_hd__inv_2
X_5991_ _1053_ _1096_ _3598_ _0961_ _1361_ VGND VGND VPWR VPWR _1362_ sky130_fd_sc_hd__a221oi_1
XFILLER_0_59_443 VGND VGND VPWR VPWR sky130_fd_sc_hd__decap_4
XFILLER_0_24_51 VPWR VGND VPWR VGND sky130_ef_sc_hd__decap_12
X_4942_ _0215_ _0216_ VGND VGND VPWR VPWR _0217_ sky130_fd_sc_hd__or2_1
X_7661_ _3179_ _3187_ VGND VGND VPWR VPWR _3188_ sky130_fd_sc_hd__xnor2_1
XFILLER_0_19_318 VGND VGND VPWR VPWR sky130_fd_sc_hd__decap_4
X_4873_ _2791_ _0141_ VGND VGND VPWR VPWR _0142_ sky130_fd_sc_hd__xnor2_1
X_6612_ _2038_ _2039_ VGND VGND VPWR VPWR _2040_ sky130_fd_sc_hd__and2b_1
X_7592_ _2935_ _2936_ _2938_ VGND VGND VPWR VPWR _3112_ sky130_fd_sc_hd__a21oi_1
XFILLER_0_6_212 VPWR VGND VPWR VGND sky130_ef_sc_hd__decap_12
XFILLER_0_15_502 VGND VGND VPWR VPWR sky130_fd_sc_hd__fill_2
XFILLER_0_15_513 VGND VGND VPWR VPWR sky130_fd_sc_hd__fill_1
XFILLER_0_27_373 VPWR VGND VPWR VGND sky130_ef_sc_hd__decap_12
X_6543_ _1963_ _1964_ VGND VGND VPWR VPWR _1965_ sky130_fd_sc_hd__nand2_1
XTAP_TAPCELL_ROW_76_1115 VGND VPWR sky130_fd_sc_hd__tapvpwrvgnd_1
XFILLER_0_6_278 VPWR VGND VPWR VGND sky130_ef_sc_hd__decap_12
X_6474_ _1938_ _3254_ _1566_ _1413_ VGND VGND VPWR VPWR _1889_ sky130_fd_sc_hd__a22o_1
XFILLER_0_42_365 VPWR VGND VPWR VGND sky130_ef_sc_hd__decap_12
XPHY_EDGE_ROW_12_Right_12 VGND VGND VPWR VPWR sky130_fd_sc_hd__decap_3
X_5425_ _0735_ _0742_ VGND VGND VPWR VPWR _0743_ sky130_fd_sc_hd__nand2_1
XFILLER_0_64_3 VPWR VGND VPWR VGND sky130_ef_sc_hd__decap_12
XFILLER_0_100_448 VGND VGND VPWR VPWR sky130_fd_sc_hd__fill_1
X_5356_ _3064_ _2605_ net124 _0465_ VGND VGND VPWR VPWR _0668_ sky130_fd_sc_hd__and4_1
X_4307_ _3411_ _3413_ _3416_ _3417_ _3412_ VGND VGND VPWR VPWR _3418_ sky130_fd_sc_hd__o32a_1
X_5287_ _2014_ _0395_ _1435_ _3262_ VGND VGND VPWR VPWR _0593_ sky130_fd_sc_hd__o211a_1
X_4238_ _2638_ VGND VGND VPWR VPWR _3350_ sky130_fd_sc_hd__clkbuf_4
X_7026_ _2491_ _2471_ _2298_ VGND VGND VPWR VPWR _2492_ sky130_fd_sc_hd__or3b_1
XFILLER_0_4_83 VGND VGND VPWR VPWR sky130_fd_sc_hd__fill_1
XFILLER_0_97_505 VGND VGND VPWR VPWR sky130_fd_sc_hd__decap_6
XTAP_TAPCELL_ROW_87_1233 VGND VPWR sky130_fd_sc_hd__tapvpwrvgnd_1
X_4169_ _1370_ _3266_ _3280_ VGND VGND VPWR VPWR _3281_ sky130_fd_sc_hd__and3_1
XPHY_EDGE_ROW_21_Right_21 VGND VGND VPWR VPWR sky130_fd_sc_hd__decap_3
XFILLER_0_77_251 VGND VGND VPWR VPWR sky130_fd_sc_hd__decap_4
XFILLER_0_65_424 VGND VGND VPWR VPWR sky130_fd_sc_hd__decap_4
XTAP_TAPCELL_ROW_41_706 VGND VPWR sky130_fd_sc_hd__tapvpwrvgnd_1
XFILLER_0_92_221 VGND VGND VPWR VPWR sky130_fd_sc_hd__decap_8
XFILLER_0_37_137 VGND VGND VPWR VPWR sky130_fd_sc_hd__decap_6
XFILLER_0_92_298 VGND VGND VPWR VPWR sky130_fd_sc_hd__decap_8
XFILLER_0_73_490 VPWR VGND VPWR VGND sky130_ef_sc_hd__decap_12
XFILLER_0_18_384 VPWR VGND VPWR VGND sky130_ef_sc_hd__decap_12
XFILLER_0_52_129 VGND VGND VPWR VPWR sky130_fd_sc_hd__decap_8
XTAP_TAPCELL_ROW_98_1362 VGND VPWR sky130_fd_sc_hd__tapvpwrvgnd_1
XFILLER_0_61_641 VGND VGND VPWR VPWR sky130_fd_sc_hd__decap_8
XTAP_TAPCELL_ROW_21_474 VGND VPWR sky130_fd_sc_hd__tapvpwrvgnd_1
XFILLER_0_21_505 VGND VGND VPWR VPWR sky130_fd_sc_hd__decap_3
XPHY_EDGE_ROW_30_Right_30 VGND VGND VPWR VPWR sky130_fd_sc_hd__decap_3
XFILLER_0_103_275 VGND VGND VPWR VPWR sky130_fd_sc_hd__fill_2
XFILLER_0_45_28 VGND VGND VPWR VPWR sky130_fd_sc_hd__fill_1
XTAP_TAPCELL_ROW_57_894 VGND VPWR sky130_fd_sc_hd__tapvpwrvgnd_1
XTAP_TAPCELL_ROW_29_574 VGND VPWR sky130_fd_sc_hd__tapvpwrvgnd_1
XFILLER_0_56_413 VGND VGND VPWR VPWR sky130_fd_sc_hd__decap_6
XFILLER_0_83_210 VGND VGND VPWR VPWR sky130_fd_sc_hd__fill_1
XFILLER_0_29_649 VGND VGND VPWR VPWR sky130_fd_sc_hd__decap_3
XFILLER_0_83_265 VPWR VGND VPWR VGND sky130_ef_sc_hd__decap_12
XFILLER_0_9_39 VPWR VGND VPWR VGND sky130_ef_sc_hd__decap_12
XFILLER_0_24_321 VGND VGND VPWR VPWR sky130_fd_sc_hd__fill_1
XFILLER_0_24_332 VPWR VGND VPWR VGND sky130_ef_sc_hd__decap_12
XFILLER_0_101_55 VGND VGND VPWR VPWR sky130_fd_sc_hd__fill_1
XFILLER_0_12_527 VGND VGND VPWR VPWR sky130_fd_sc_hd__decap_4
XFILLER_0_12_505 VGND VGND VPWR VPWR sky130_fd_sc_hd__decap_4
XFILLER_0_10_53 VPWR VGND VPWR VGND sky130_ef_sc_hd__decap_12
XFILLER_0_3_237 VPWR VGND VPWR VGND sky130_ef_sc_hd__decap_12
XFILLER_0_24_365 VGND VGND VPWR VPWR sky130_fd_sc_hd__decap_8
X_5210_ _0369_ _0494_ VGND VGND VPWR VPWR _0509_ sky130_fd_sc_hd__and2b_1
XFILLER_0_86_24 VGND VGND VPWR VPWR sky130_fd_sc_hd__fill_1
X_6190_ _0457_ net144 _0433_ _0093_ VGND VGND VPWR VPWR _1579_ sky130_fd_sc_hd__and4_1
X_5141_ net25 _2550_ _0433_ _1599_ VGND VGND VPWR VPWR _0434_ sky130_fd_sc_hd__and4_1
XTAP_TAPCELL_ROW_71_1056 VGND VPWR sky130_fd_sc_hd__tapvpwrvgnd_1
X_5072_ _0356_ _0357_ _0320_ VGND VGND VPWR VPWR _0359_ sky130_fd_sc_hd__o21a_1
X_4023_ _1960_ _1971_ VGND VGND VPWR VPWR _2003_ sky130_fd_sc_hd__and2_1
XFILLER_0_79_505 VPWR VGND VPWR VGND sky130_ef_sc_hd__decap_12
X_7713_ _3239_ _3240_ _3241_ _0366_ VGND VGND VPWR VPWR _3243_ sky130_fd_sc_hd__a31o_1
X_5974_ _1341_ _1342_ VGND VGND VPWR VPWR _1343_ sky130_fd_sc_hd__xnor2_2
X_4925_ _0110_ _0196_ _0198_ _3743_ VGND VGND VPWR VPWR _0199_ sky130_fd_sc_hd__a22o_1
XTAP_TAPCELL_ROW_82_1174 VGND VPWR sky130_fd_sc_hd__tapvpwrvgnd_1
X_7644_ _3336_ net51 _0257_ _3324_ VGND VGND VPWR VPWR _3169_ sky130_fd_sc_hd__a22o_1
XTAP_TAPCELL_ROW_82_1185 VGND VPWR sky130_fd_sc_hd__tapvpwrvgnd_1
XFILLER_0_74_243 VGND VGND VPWR VPWR sky130_fd_sc_hd__decap_8
XFILLER_0_7_532 VGND VGND VPWR VPWR sky130_fd_sc_hd__decap_4
X_4856_ _3287_ _3331_ _1818_ _1621_ VGND VGND VPWR VPWR _0123_ sky130_fd_sc_hd__and4_1
X_7575_ _3090_ _3091_ _3088_ _3089_ VGND VGND VPWR VPWR _3093_ sky130_fd_sc_hd__a211o_1
XFILLER_0_15_310 VGND VGND VPWR VPWR sky130_fd_sc_hd__fill_2
X_6526_ _1908_ _1909_ _1943_ _1944_ VGND VGND VPWR VPWR _1946_ sky130_fd_sc_hd__a2bb2o_1
XFILLER_0_27_181 VPWR VGND VPWR VGND sky130_ef_sc_hd__decap_12
X_4787_ _3449_ _3621_ _3623_ _1654_ VGND VGND VPWR VPWR _0048_ sky130_fd_sc_hd__and4_1
XFILLER_0_43_641 VGND VGND VPWR VPWR sky130_fd_sc_hd__decap_8
XFILLER_0_42_151 VPWR VGND VPWR VGND sky130_ef_sc_hd__decap_12
XFILLER_0_30_335 VPWR VGND VPWR VGND sky130_ef_sc_hd__decap_12
X_6457_ _1868_ _1867_ _1866_ VGND VGND VPWR VPWR _1870_ sky130_fd_sc_hd__a21bo_1
X_5408_ _3265_ _0724_ VGND VGND VPWR VPWR _0725_ sky130_fd_sc_hd__xor2_1
X_6388_ _1629_ net108 _1794_ _1793_ VGND VGND VPWR VPWR _1795_ sky130_fd_sc_hd__o211a_4
X_5339_ _0631_ _0632_ _0647_ VGND VGND VPWR VPWR _0650_ sky130_fd_sc_hd__nand3_2
X_7009_ _0105_ _0126_ _2307_ VGND VGND VPWR VPWR _2475_ sky130_fd_sc_hd__a21o_1
XFILLER_0_85_508 VPWR VGND VPWR VGND sky130_ef_sc_hd__decap_12
XTAP_TAPCELL_ROW_26_533 VGND VPWR sky130_fd_sc_hd__tapvpwrvgnd_1
XTAP_TAPCELL_ROW_54_853 VGND VPWR sky130_fd_sc_hd__tapvpwrvgnd_1
XFILLER_0_93_541 VGND VGND VPWR VPWR sky130_fd_sc_hd__fill_1
XFILLER_0_93_596 VPWR VGND VPWR VGND sky130_ef_sc_hd__decap_12
XFILLER_0_65_276 VGND VGND VPWR VPWR sky130_fd_sc_hd__decap_4
XFILLER_0_53_449 VGND VGND VPWR VPWR sky130_fd_sc_hd__decap_3
XFILLER_0_104_551 VGND VGND VPWR VPWR sky130_fd_sc_hd__decap_8
XFILLER_0_61_493 VGND VGND VPWR VPWR sky130_fd_sc_hd__decap_8
XFILLER_0_104_584 VGND VGND VPWR VPWR sky130_fd_sc_hd__decap_4
XTAP_TAPCELL_ROW_105_1439 VGND VPWR sky130_fd_sc_hd__tapvpwrvgnd_1
XFILLER_0_56_221 VGND VGND VPWR VPWR sky130_fd_sc_hd__fill_1
XFILLER_0_8_307 VGND VGND VPWR VPWR sky130_fd_sc_hd__fill_1
XFILLER_0_29_446 VGND VGND VPWR VPWR sky130_fd_sc_hd__fill_2
X_5690_ _1028_ _1032_ VGND VGND VPWR VPWR _1033_ sky130_fd_sc_hd__xnor2_2
X_4710_ _3414_ _1741_ VGND VGND VPWR VPWR _3814_ sky130_fd_sc_hd__nand2_1
X_4641_ _3742_ _3463_ _3745_ VGND VGND VPWR VPWR _3746_ sky130_fd_sc_hd__a21oi_1
XFILLER_0_25_641 VGND VGND VPWR VPWR sky130_fd_sc_hd__decap_8
X_7360_ _0377_ _0399_ VGND VGND VPWR VPWR _2858_ sky130_fd_sc_hd__nor2_1
X_4572_ _2725_ VGND VGND VPWR VPWR _3678_ sky130_fd_sc_hd__inv_2
XFILLER_0_12_302 VGND VGND VPWR VPWR sky130_fd_sc_hd__decap_6
XFILLER_0_4_557 VPWR VGND VPWR VGND sky130_ef_sc_hd__decap_12
XFILLER_0_24_162 VGND VGND VPWR VPWR sky130_fd_sc_hd__fill_1
X_7291_ _2779_ _2781_ _2782_ VGND VGND VPWR VPWR _2783_ sky130_fd_sc_hd__a21oi_1
XFILLER_0_12_324 VGND VGND VPWR VPWR sky130_fd_sc_hd__fill_2
X_6311_ _1709_ _1707_ _1706_ VGND VGND VPWR VPWR _1711_ sky130_fd_sc_hd__a21bo_1
XFILLER_0_97_89 VGND VGND VPWR VPWR sky130_fd_sc_hd__fill_1
X_6242_ _1529_ _1634_ _1635_ VGND VGND VPWR VPWR _1636_ sky130_fd_sc_hd__and3_4
X_6173_ _1545_ _1558_ _1559_ VGND VGND VPWR VPWR _1560_ sky130_fd_sc_hd__and3_1
X_5124_ _3316_ _0376_ _0414_ _0097_ VGND VGND VPWR VPWR _0415_ sky130_fd_sc_hd__o22a_1
X_5055_ _2955_ _0242_ net2 net31 VGND VGND VPWR VPWR _0340_ sky130_fd_sc_hd__and4_1
X_4006_ _1807_ VGND VGND VPWR VPWR _1818_ sky130_fd_sc_hd__clkbuf_4
XFILLER_0_27_3 VGND VGND VPWR VPWR sky130_fd_sc_hd__decap_4
XTAP_TAPCELL_ROW_84_1203 VGND VPWR sky130_fd_sc_hd__tapvpwrvgnd_1
XFILLER_0_1_51 VGND VGND VPWR VPWR sky130_fd_sc_hd__decap_4
X_5957_ _1320_ _1321_ _1322_ VGND VGND VPWR VPWR _1324_ sky130_fd_sc_hd__a21o_1
XTAP_TAPCELL_ROW_23_503 VGND VPWR sky130_fd_sc_hd__tapvpwrvgnd_1
XTAP_TAPCELL_ROW_51_823 VGND VPWR sky130_fd_sc_hd__tapvpwrvgnd_1
X_4908_ _3364_ _0177_ _0179_ VGND VGND VPWR VPWR _0180_ sky130_fd_sc_hd__and3_1
XFILLER_0_35_405 VGND VGND VPWR VPWR sky130_fd_sc_hd__decap_4
XFILLER_0_90_533 VGND VGND VPWR VPWR sky130_fd_sc_hd__decap_6
X_7627_ _3142_ _3149_ VGND VGND VPWR VPWR _3150_ sky130_fd_sc_hd__xnor2_1
XFILLER_0_62_202 VGND VGND VPWR VPWR sky130_fd_sc_hd__decap_4
XFILLER_0_35_427 VPWR VGND VPWR VGND sky130_ef_sc_hd__decap_12
X_5888_ _1119_ _1124_ VGND VGND VPWR VPWR _1248_ sky130_fd_sc_hd__or2b_1
X_4839_ _3426_ _3429_ _3459_ _3456_ _3322_ _3342_ VGND VGND VPWR VPWR _0106_ sky130_fd_sc_hd__mux4_1
XFILLER_0_90_566 VGND VGND VPWR VPWR sky130_fd_sc_hd__decap_8
XFILLER_0_35_449 VGND VGND VPWR VPWR sky130_fd_sc_hd__decap_8
X_7558_ _2996_ _3041_ _3073_ VGND VGND VPWR VPWR _3074_ sky130_fd_sc_hd__a21oi_1
XTAP_TAPCELL_ROW_31_591 VGND VPWR sky130_fd_sc_hd__tapvpwrvgnd_1
XFILLER_0_31_611 VGND VGND VPWR VPWR sky130_fd_sc_hd__decap_4
XFILLER_0_43_471 VGND VGND VPWR VPWR sky130_fd_sc_hd__decap_8
XFILLER_0_50_419 VGND VGND VPWR VPWR sky130_fd_sc_hd__fill_1
XTAP_TAPCELL_ROW_95_1332 VGND VPWR sky130_fd_sc_hd__tapvpwrvgnd_1
X_7489_ _3334_ net51 net50 _3336_ VGND VGND VPWR VPWR _3000_ sky130_fd_sc_hd__a22oi_1
X_6509_ _1772_ _1778_ _1771_ VGND VGND VPWR VPWR _1928_ sky130_fd_sc_hd__a21bo_1
XFILLER_0_30_121 VGND VGND VPWR VPWR sky130_fd_sc_hd__decap_3
XFILLER_0_43_482 VGND VGND VPWR VPWR sky130_fd_sc_hd__decap_6
XFILLER_0_3_590 VPWR VGND VPWR VGND sky130_ef_sc_hd__decap_12
XTAP_TAPCELL_ROW_59_912 VGND VPWR sky130_fd_sc_hd__tapvpwrvgnd_1
XTAP_TAPCELL_ROW_3_272 VGND VPWR sky130_fd_sc_hd__tapvpwrvgnd_1
XTAP_TAPCELL_ROW_39_680 VGND VPWR sky130_fd_sc_hd__tapvpwrvgnd_1
XFILLER_0_85_305 VPWR VGND VPWR VGND sky130_ef_sc_hd__decap_12
XFILLER_0_58_519 VPWR VGND VPWR VGND sky130_ef_sc_hd__decap_12
XFILLER_0_85_349 VGND VGND VPWR VPWR sky130_fd_sc_hd__decap_3
XFILLER_0_66_530 VGND VGND VPWR VPWR sky130_fd_sc_hd__fill_2
XFILLER_0_42_18 VGND VGND VPWR VPWR sky130_fd_sc_hd__decap_3
XFILLER_0_66_541 VGND VGND VPWR VPWR sky130_fd_sc_hd__decap_3
XFILLER_0_93_393 VGND VGND VPWR VPWR sky130_fd_sc_hd__decap_4
XFILLER_0_93_382 VGND VGND VPWR VPWR sky130_fd_sc_hd__decap_8
XFILLER_0_53_213 VGND VGND VPWR VPWR sky130_fd_sc_hd__fill_1
XFILLER_0_81_566 VGND VGND VPWR VPWR sky130_fd_sc_hd__decap_8
XFILLER_0_108_197 VGND VGND VPWR VPWR sky130_fd_sc_hd__decap_4
XFILLER_0_53_268 VGND VGND VPWR VPWR sky130_fd_sc_hd__decap_8
XFILLER_0_53_279 VGND VGND VPWR VPWR sky130_fd_sc_hd__fill_1
XANTENNA_6 _2846_ VGND VGND VPWR VPWR sky130_fd_sc_hd__diode_2
XFILLER_0_22_633 VGND VGND VPWR VPWR sky130_fd_sc_hd__decap_8
XFILLER_0_6_29 VPWR VGND VPWR VGND sky130_ef_sc_hd__decap_12
XFILLER_0_21_143 VGND VGND VPWR VPWR sky130_fd_sc_hd__fill_1
XFILLER_0_21_154 VGND VGND VPWR VPWR sky130_fd_sc_hd__decap_4
XFILLER_0_67_48 VGND VGND VPWR VPWR sky130_fd_sc_hd__decap_4
XFILLER_0_83_47 VGND VGND VPWR VPWR sky130_fd_sc_hd__fill_2
Xrebuffer18 _1189_ VGND VGND VPWR VPWR net136 sky130_fd_sc_hd__clkbuf_1
Xrebuffer29 net153 VGND VGND VPWR VPWR net147 sky130_fd_sc_hd__dlygate4sd1_1
X_6860_ _1986_ _2311_ _0842_ VGND VGND VPWR VPWR _2312_ sky130_fd_sc_hd__mux2_1
XFILLER_0_76_316 VPWR VGND VPWR VGND sky130_ef_sc_hd__decap_12
XFILLER_0_16_85 VPWR VGND VPWR VGND sky130_ef_sc_hd__decap_12
XFILLER_0_69_390 VGND VGND VPWR VPWR sky130_fd_sc_hd__fill_2
X_5811_ _1163_ _1164_ VGND VGND VPWR VPWR _1165_ sky130_fd_sc_hd__nor2_1
X_6791_ _2234_ _2235_ VGND VGND VPWR VPWR _2236_ sky130_fd_sc_hd__xnor2_1
X_5742_ _1184_ _0780_ _1089_ VGND VGND VPWR VPWR _1090_ sky130_fd_sc_hd__mux2_1
XFILLER_0_9_649 VGND VGND VPWR VPWR sky130_fd_sc_hd__decap_3
XFILLER_0_84_382 VGND VGND VPWR VPWR sky130_fd_sc_hd__decap_4
XFILLER_0_84_360 VGND VGND VPWR VPWR sky130_fd_sc_hd__decap_4
XFILLER_0_72_500 VPWR VGND VPWR VGND sky130_ef_sc_hd__decap_12
XFILLER_0_57_585 VGND VGND VPWR VPWR sky130_fd_sc_hd__decap_4
XFILLER_0_72_533 VGND VGND VPWR VPWR sky130_fd_sc_hd__fill_1
XFILLER_0_17_449 VPWR VGND VPWR VGND sky130_ef_sc_hd__decap_12
X_5673_ _0433_ net31 _0093_ _3267_ VGND VGND VPWR VPWR _1014_ sky130_fd_sc_hd__and4_1
X_7412_ _2899_ _2901_ _2914_ VGND VGND VPWR VPWR _2915_ sky130_fd_sc_hd__nor3_1
X_4624_ _3370_ _3728_ _3729_ _3304_ VGND VGND VPWR VPWR _3730_ sky130_fd_sc_hd__a22o_1
XPHY_EDGE_ROW_6_Right_6 VGND VGND VPWR VPWR sky130_fd_sc_hd__decap_3
XFILLER_0_25_460 VPWR VGND VPWR VGND sky130_ef_sc_hd__decap_12
X_4555_ _3304_ _3661_ VGND VGND VPWR VPWR _3662_ sky130_fd_sc_hd__nand2_1
X_7343_ _2837_ _2838_ _2633_ _2635_ VGND VGND VPWR VPWR _2840_ sky130_fd_sc_hd__o211a_1
XFILLER_0_40_463 VGND VGND VPWR VPWR sky130_fd_sc_hd__decap_8
X_4486_ _2780_ _3593_ VGND VGND VPWR VPWR _3594_ sky130_fd_sc_hd__nand2_1
X_7274_ _1850_ _1293_ _1206_ _1577_ VGND VGND VPWR VPWR _2764_ sky130_fd_sc_hd__a22oi_1
X_6225_ _1607_ _1615_ _1616_ VGND VGND VPWR VPWR _1617_ sky130_fd_sc_hd__nand3_2
XTAP_TAPCELL_ROW_90_1273 VGND VPWR sky130_fd_sc_hd__tapvpwrvgnd_1
X_6156_ _1539_ _1540_ VGND VGND VPWR VPWR _1541_ sky130_fd_sc_hd__xnor2_1
X_5107_ _3258_ _3751_ _0389_ _0393_ _0396_ VGND VGND VPWR VPWR _0397_ sky130_fd_sc_hd__o221a_1
XFILLER_0_57_81 VGND VGND VPWR VPWR sky130_fd_sc_hd__fill_2
X_6087_ _1464_ _1465_ VGND VGND VPWR VPWR _1466_ sky130_fd_sc_hd__xor2_1
XFILLER_0_79_132 VGND VGND VPWR VPWR sky130_fd_sc_hd__decap_4
XFILLER_0_79_110 VGND VGND VPWR VPWR sky130_fd_sc_hd__fill_2
XTAP_TAPCELL_ROW_0_220 VGND VPWR sky130_fd_sc_hd__tapvpwrvgnd_1
X_5038_ _0233_ _0254_ _0255_ VGND VGND VPWR VPWR _0321_ sky130_fd_sc_hd__nand3_1
XFILLER_0_79_165 VGND VGND VPWR VPWR sky130_fd_sc_hd__decap_3
XTAP_TAPCELL_ROW_0_231 VGND VPWR sky130_fd_sc_hd__tapvpwrvgnd_1
XTAP_TAPCELL_ROW_0_242 VGND VPWR sky130_fd_sc_hd__tapvpwrvgnd_1
XTAP_TAPCELL_ROW_64_970 VGND VPWR sky130_fd_sc_hd__tapvpwrvgnd_1
XTAP_TAPCELL_ROW_36_650 VGND VPWR sky130_fd_sc_hd__tapvpwrvgnd_1
X_6989_ _2449_ _2451_ VGND VGND VPWR VPWR _2453_ sky130_fd_sc_hd__xnor2_1
XFILLER_0_35_213 VGND VGND VPWR VPWR sky130_fd_sc_hd__decap_4
XFILLER_0_106_613 VPWR VGND VPWR VGND sky130_ef_sc_hd__decap_12
XFILLER_0_75_393 VPWR VGND VPWR VGND sky130_ef_sc_hd__decap_12
XFILLER_0_35_257 VGND VGND VPWR VPWR sky130_fd_sc_hd__fill_2
XFILLER_0_90_363 VGND VGND VPWR VPWR sky130_fd_sc_hd__fill_1
XFILLER_0_63_599 VGND VGND VPWR VPWR sky130_fd_sc_hd__fill_1
XFILLER_0_23_419 VGND VGND VPWR VPWR sky130_fd_sc_hd__decap_4
XFILLER_0_50_238 VGND VGND VPWR VPWR sky130_fd_sc_hd__fill_1
XFILLER_0_105_178 VPWR VGND VPWR VGND sky130_ef_sc_hd__decap_12
Xoutput76 net76 VGND VGND VPWR VPWR result[16] sky130_fd_sc_hd__buf_2
XTAP_TAPCELL_ROW_8_331 VGND VPWR sky130_fd_sc_hd__tapvpwrvgnd_1
Xoutput98 net98 VGND VGND VPWR VPWR result[7] sky130_fd_sc_hd__buf_2
Xoutput87 net87 VGND VGND VPWR VPWR result[26] sky130_fd_sc_hd__buf_2
XFILLER_0_86_625 VGND VGND VPWR VPWR sky130_fd_sc_hd__decap_3
XTAP_TAPCELL_ROW_102_1409 VGND VPWR sky130_fd_sc_hd__tapvpwrvgnd_1
XFILLER_0_85_113 VGND VGND VPWR VPWR sky130_fd_sc_hd__decap_4
XFILLER_0_26_213 VGND VGND VPWR VPWR sky130_fd_sc_hd__fill_1
XFILLER_0_93_190 VGND VGND VPWR VPWR sky130_fd_sc_hd__fill_2
XPHY_EDGE_ROW_59_Right_59 VGND VGND VPWR VPWR sky130_fd_sc_hd__decap_3
XFILLER_0_54_533 VPWR VGND VPWR VGND sky130_ef_sc_hd__decap_12
XTAP_TAPCELL_ROW_14_399 VGND VPWR sky130_fd_sc_hd__tapvpwrvgnd_1
XFILLER_0_26_268 VPWR VGND VPWR VGND sky130_ef_sc_hd__decap_12
XFILLER_0_22_452 VGND VGND VPWR VPWR sky130_fd_sc_hd__decap_6
X_4340_ _3345_ _3326_ _3450_ VGND VGND VPWR VPWR _3451_ sky130_fd_sc_hd__a21bo_1
X_4271_ _3378_ _3382_ _3322_ VGND VGND VPWR VPWR _3383_ sky130_fd_sc_hd__mux2_1
X_6010_ _1064_ _1376_ _1379_ _1382_ VGND VGND VPWR VPWR _1383_ sky130_fd_sc_hd__a31o_1
XFILLER_0_94_57 VGND VGND VPWR VPWR sky130_fd_sc_hd__fill_1
XPHY_EDGE_ROW_68_Right_68 VGND VGND VPWR VPWR sky130_fd_sc_hd__decap_3
XFILLER_0_27_40 VGND VGND VPWR VPWR sky130_fd_sc_hd__fill_1
XTAP_TAPCELL_ROW_68_1017 VGND VPWR sky130_fd_sc_hd__tapvpwrvgnd_1
X_6912_ _1468_ _1413_ _3256_ _2047_ VGND VGND VPWR VPWR _2368_ sky130_fd_sc_hd__a22oi_1
XFILLER_0_77_625 VGND VGND VPWR VPWR sky130_fd_sc_hd__fill_2
X_6843_ _2019_ _2158_ _2291_ _2292_ VGND VGND VPWR VPWR _2293_ sky130_fd_sc_hd__o211a_1
XFILLER_0_49_316 VGND VGND VPWR VPWR sky130_fd_sc_hd__decap_8
XTAP_TAPCELL_ROW_33_620 VGND VPWR sky130_fd_sc_hd__tapvpwrvgnd_1
XFILLER_0_43_83 VPWR VGND VPWR VGND sky130_ef_sc_hd__decap_12
XPHY_EDGE_ROW_77_Right_77 VGND VGND VPWR VPWR sky130_fd_sc_hd__decap_3
XTAP_TAPCELL_ROW_61_940 VGND VPWR sky130_fd_sc_hd__tapvpwrvgnd_1
X_3986_ net62 VGND VGND VPWR VPWR _1599_ sky130_fd_sc_hd__buf_4
X_6774_ _2082_ _2184_ _2215_ _2216_ VGND VGND VPWR VPWR _2217_ sky130_fd_sc_hd__a211oi_1
XFILLER_0_45_511 VGND VGND VPWR VPWR sky130_fd_sc_hd__fill_1
XFILLER_0_45_522 VPWR VGND VPWR VGND sky130_ef_sc_hd__decap_12
XFILLER_0_72_330 VPWR VGND VPWR VGND sky130_ef_sc_hd__decap_12
XFILLER_0_57_393 VGND VGND VPWR VPWR sky130_fd_sc_hd__decap_6
X_5725_ _1069_ _0978_ _1070_ VGND VGND VPWR VPWR _1071_ sky130_fd_sc_hd__and3_4
XFILLER_0_5_641 VGND VGND VPWR VPWR sky130_fd_sc_hd__decap_8
XFILLER_0_17_279 VGND VGND VPWR VPWR sky130_fd_sc_hd__fill_1
X_5656_ _0923_ _0928_ VGND VGND VPWR VPWR _0995_ sky130_fd_sc_hd__nand2_1
XTAP_TAPCELL_ROW_79_1146 VGND VPWR sky130_fd_sc_hd__tapvpwrvgnd_1
X_4607_ _3710_ _3711_ _3712_ VGND VGND VPWR VPWR _3713_ sky130_fd_sc_hd__and3_1
XFILLER_0_103_649 VGND VGND VPWR VPWR sky130_fd_sc_hd__decap_3
XFILLER_0_60_558 VGND VGND VPWR VPWR sky130_fd_sc_hd__decap_4
X_5587_ _0918_ _0917_ _0808_ _0859_ VGND VGND VPWR VPWR _0920_ sky130_fd_sc_hd__a211oi_4
X_4538_ _3642_ _3643_ _3644_ VGND VGND VPWR VPWR _3645_ sky130_fd_sc_hd__or3b_1
X_7326_ _2819_ _2820_ VGND VGND VPWR VPWR _2821_ sky130_fd_sc_hd__nor2_1
XFILLER_0_4_195 VGND VGND VPWR VPWR sky130_fd_sc_hd__fill_1
XFILLER_0_13_485 VPWR VGND VPWR VGND sky130_ef_sc_hd__decap_12
XFILLER_0_40_271 VPWR VGND VPWR VGND sky130_ef_sc_hd__decap_12
X_7257_ _2743_ _2744_ VGND VGND VPWR VPWR _2745_ sky130_fd_sc_hd__xnor2_1
X_4469_ _3574_ _3575_ _3576_ VGND VGND VPWR VPWR _3577_ sky130_fd_sc_hd__nand3_1
XPHY_EDGE_ROW_86_Right_86 VGND VGND VPWR VPWR sky130_fd_sc_hd__decap_3
X_6208_ _1595_ _1596_ _1592_ VGND VGND VPWR VPWR _1598_ sky130_fd_sc_hd__a21o_1
X_7188_ _0442_ _2669_ VGND VGND VPWR VPWR _2670_ sky130_fd_sc_hd__nand2_1
XFILLER_0_99_216 VGND VGND VPWR VPWR sky130_fd_sc_hd__decap_8
X_6139_ _3647_ _1503_ _1522_ VGND VGND VPWR VPWR net82 sky130_fd_sc_hd__o21ai_2
XFILLER_0_68_625 VPWR VGND VPWR VGND sky130_ef_sc_hd__decap_12
XFILLER_0_67_113 VPWR VGND VPWR VGND sky130_ef_sc_hd__decap_12
XPHY_EDGE_ROW_95_Right_95 VGND VGND VPWR VPWR sky130_fd_sc_hd__decap_3
XFILLER_0_95_466 VGND VGND VPWR VPWR sky130_fd_sc_hd__fill_1
XFILLER_0_83_617 VGND VGND VPWR VPWR sky130_fd_sc_hd__decap_6
XFILLER_0_67_146 VGND VGND VPWR VPWR sky130_fd_sc_hd__fill_1
XFILLER_0_48_360 VGND VGND VPWR VPWR sky130_fd_sc_hd__decap_4
XFILLER_0_106_421 VPWR VGND VPWR VGND sky130_ef_sc_hd__decap_12
XFILLER_0_23_205 VPWR VGND VPWR VGND sky130_ef_sc_hd__decap_12
XTAP_TAPCELL_ROW_11_358 VGND VPWR sky130_fd_sc_hd__tapvpwrvgnd_1
Xrebuffer9 net133 VGND VGND VPWR VPWR net127 sky130_fd_sc_hd__dlymetal6s4s_1
XFILLER_0_51_558 VGND VGND VPWR VPWR sky130_fd_sc_hd__fill_2
XFILLER_0_64_27 VGND VGND VPWR VPWR sky130_fd_sc_hd__fill_1
XFILLER_0_98_271 VPWR VGND VPWR VGND sky130_ef_sc_hd__decap_12
XTAP_TAPCELL_ROW_19_458 VGND VPWR sky130_fd_sc_hd__tapvpwrvgnd_1
XTAP_TAPCELL_ROW_47_778 VGND VPWR sky130_fd_sc_hd__tapvpwrvgnd_1
XFILLER_0_86_466 VGND VGND VPWR VPWR sky130_fd_sc_hd__decap_8
XFILLER_0_58_157 VPWR VGND VPWR VGND sky130_ef_sc_hd__decap_12
XFILLER_0_86_477 VGND VGND VPWR VPWR sky130_fd_sc_hd__fill_1
XFILLER_0_74_628 VGND VGND VPWR VPWR sky130_fd_sc_hd__decap_8
XFILLER_0_104_77 VGND VGND VPWR VPWR sky130_fd_sc_hd__decap_6
XFILLER_0_66_190 VGND VGND VPWR VPWR sky130_fd_sc_hd__decap_6
XFILLER_0_13_75 VGND VGND VPWR VPWR sky130_fd_sc_hd__fill_1
XFILLER_0_39_393 VGND VGND VPWR VPWR sky130_fd_sc_hd__fill_1
XFILLER_0_109_281 VGND VGND VPWR VPWR sky130_fd_sc_hd__fill_2
X_5510_ _3262_ _0414_ _0598_ _3263_ _3260_ VGND VGND VPWR VPWR _0837_ sky130_fd_sc_hd__o311a_1
XFILLER_0_54_363 VGND VGND VPWR VPWR sky130_fd_sc_hd__fill_1
X_6490_ _1903_ _1904_ _1887_ VGND VGND VPWR VPWR _1907_ sky130_fd_sc_hd__a21oi_1
X_5441_ net29 net28 _1785_ _0093_ VGND VGND VPWR VPWR _0761_ sky130_fd_sc_hd__and4_1
XFILLER_0_42_569 VGND VGND VPWR VPWR sky130_fd_sc_hd__decap_3
X_5372_ _0683_ _0684_ _0685_ VGND VGND VPWR VPWR _0686_ sky130_fd_sc_hd__nand3_4
X_4323_ _0137_ _0094_ _3306_ VGND VGND VPWR VPWR _3434_ sky130_fd_sc_hd__mux2_1
XFILLER_0_66_7 VGND VGND VPWR VPWR sky130_fd_sc_hd__fill_2
X_7111_ _2080_ _1391_ _1949_ _0704_ VGND VGND VPWR VPWR _2586_ sky130_fd_sc_hd__and4_1
XFILLER_0_10_433 VPWR VGND VPWR VGND sky130_ef_sc_hd__decap_12
X_7042_ _2508_ _2509_ VGND VGND VPWR VPWR _2510_ sky130_fd_sc_hd__nor2_1
XTAP_TAPCELL_ROW_74_1087 VGND VPWR sky130_fd_sc_hd__tapvpwrvgnd_1
XFILLER_0_10_477 VPWR VGND VPWR VGND sky130_ef_sc_hd__decap_12
X_4254_ _3364_ _3365_ _3355_ VGND VGND VPWR VPWR _3366_ sky130_fd_sc_hd__o21a_1
X_4185_ _2638_ VGND VGND VPWR VPWR _3297_ sky130_fd_sc_hd__inv_2
XFILLER_0_96_208 VGND VGND VPWR VPWR sky130_fd_sc_hd__decap_3
XFILLER_0_89_293 VGND VGND VPWR VPWR sky130_fd_sc_hd__fill_1
XFILLER_0_49_113 VPWR VGND VPWR VGND sky130_ef_sc_hd__decap_12
XFILLER_0_65_617 VPWR VGND VPWR VGND sky130_ef_sc_hd__decap_12
X_6826_ _2264_ _2273_ VGND VGND VPWR VPWR _2274_ sky130_fd_sc_hd__xnor2_1
XFILLER_0_107_218 VGND VGND VPWR VPWR sky130_fd_sc_hd__decap_6
X_6757_ _2196_ _2197_ VGND VGND VPWR VPWR _2198_ sky130_fd_sc_hd__xnor2_1
XFILLER_0_9_287 VGND VGND VPWR VPWR sky130_fd_sc_hd__fill_1
X_5708_ _0906_ _0897_ _0905_ VGND VGND VPWR VPWR _1052_ sky130_fd_sc_hd__a21bo_1
X_3969_ _1402_ VGND VGND VPWR VPWR _1413_ sky130_fd_sc_hd__clkbuf_4
XFILLER_0_60_300 VGND VGND VPWR VPWR sky130_fd_sc_hd__decap_4
XFILLER_0_18_599 VGND VGND VPWR VPWR sky130_fd_sc_hd__fill_2
X_6688_ _2061_ _2062_ _2120_ _2121_ VGND VGND VPWR VPWR _2123_ sky130_fd_sc_hd__a2bb2o_1
XFILLER_0_103_402 VPWR VGND VPWR VGND sky130_ef_sc_hd__decap_12
X_5639_ _3492_ VGND VGND VPWR VPWR _0977_ sky130_fd_sc_hd__clkbuf_4
XFILLER_0_20_219 VPWR VGND VPWR VGND sky130_ef_sc_hd__decap_12
X_7309_ _3329_ _3333_ net51 _0257_ VGND VGND VPWR VPWR _2803_ sky130_fd_sc_hd__and4_1
XTAP_TAPCELL_ROW_16_417 VGND VPWR sky130_fd_sc_hd__tapvpwrvgnd_1
XTAP_TAPCELL_ROW_44_737 VGND VPWR sky130_fd_sc_hd__tapvpwrvgnd_1
XTAP_TAPCELL_ROW_44_748 VGND VPWR sky130_fd_sc_hd__tapvpwrvgnd_1
XFILLER_0_68_477 VGND VGND VPWR VPWR sky130_fd_sc_hd__decap_8
XFILLER_0_50_29 VPWR VGND VPWR VGND sky130_ef_sc_hd__decap_12
XFILLER_0_83_469 VGND VGND VPWR VPWR sky130_fd_sc_hd__fill_2
XFILLER_0_36_352 VPWR VGND VPWR VGND sky130_ef_sc_hd__decap_12
XFILLER_0_51_311 VGND VGND VPWR VPWR sky130_fd_sc_hd__decap_4
XFILLER_0_51_333 VGND VGND VPWR VPWR sky130_fd_sc_hd__decap_3
XFILLER_0_59_27 VPWR VGND VPWR VGND sky130_ef_sc_hd__decap_12
X_5990_ _1009_ _1360_ _0378_ _1042_ VGND VGND VPWR VPWR _1361_ sky130_fd_sc_hd__o22ai_1
X_4941_ _0123_ _0214_ VGND VGND VPWR VPWR _0216_ sky130_fd_sc_hd__nor2_1
X_7660_ _3184_ _3186_ VGND VGND VPWR VPWR _3187_ sky130_fd_sc_hd__xnor2_1
XFILLER_0_59_477 VGND VGND VPWR VPWR sky130_fd_sc_hd__decap_8
XFILLER_0_24_63 VGND VGND VPWR VPWR sky130_fd_sc_hd__fill_1
XFILLER_0_24_85 VPWR VGND VPWR VGND sky130_ef_sc_hd__decap_12
X_4872_ _0139_ _0140_ VGND VGND VPWR VPWR _0141_ sky130_fd_sc_hd__and2b_1
XFILLER_0_46_127 VPWR VGND VPWR VGND sky130_ef_sc_hd__decap_12
X_6611_ _2034_ _2035_ _2037_ VGND VGND VPWR VPWR _2039_ sky130_fd_sc_hd__a21o_1
X_7591_ _2899_ _2915_ VGND VGND VPWR VPWR _3111_ sky130_fd_sc_hd__nor2_1
XFILLER_0_6_224 VPWR VGND VPWR VGND sky130_ef_sc_hd__decap_12
XFILLER_0_27_385 VGND VGND VPWR VPWR sky130_fd_sc_hd__decap_6
XFILLER_0_42_322 VGND VGND VPWR VPWR sky130_fd_sc_hd__fill_1
X_6542_ _1961_ _1962_ _1805_ VGND VGND VPWR VPWR _1964_ sky130_fd_sc_hd__o21ai_1
XTAP_TAPCELL_ROW_76_1105 VGND VPWR sky130_fd_sc_hd__tapvpwrvgnd_1
X_6473_ _1413_ _1938_ _3254_ _1566_ VGND VGND VPWR VPWR _1888_ sky130_fd_sc_hd__nand4_1
XTAP_TAPCELL_ROW_76_1116 VGND VPWR sky130_fd_sc_hd__tapvpwrvgnd_1
X_5424_ _0737_ _0741_ VGND VGND VPWR VPWR _0742_ sky130_fd_sc_hd__xnor2_1
XFILLER_0_42_377 VPWR VGND VPWR VGND sky130_ef_sc_hd__decap_12
XFILLER_0_23_591 VGND VGND VPWR VPWR sky130_fd_sc_hd__fill_1
XFILLER_0_57_3 VGND VGND VPWR VPWR sky130_fd_sc_hd__decap_4
X_5355_ _0665_ _0666_ VGND VGND VPWR VPWR _0667_ sky130_fd_sc_hd__nor2_1
X_4306_ net65 _0039_ _3356_ VGND VGND VPWR VPWR _3417_ sky130_fd_sc_hd__or3_4
X_5286_ _0511_ _0590_ VGND VGND VPWR VPWR _0592_ sky130_fd_sc_hd__nor2_1
XFILLER_0_49_93 VPWR VGND VPWR VGND sky130_ef_sc_hd__decap_12
X_4237_ _3346_ _3348_ VGND VGND VPWR VPWR _3349_ sky130_fd_sc_hd__nor2_1
X_7025_ _1963_ _2137_ _2136_ VGND VGND VPWR VPWR _2491_ sky130_fd_sc_hd__o21ba_1
XTAP_TAPCELL_ROW_87_1234 VGND VPWR sky130_fd_sc_hd__tapvpwrvgnd_1
X_4168_ _3273_ _3274_ _3277_ _3279_ VGND VGND VPWR VPWR _3280_ sky130_fd_sc_hd__and4_1
XFILLER_0_65_81 VPWR VGND VPWR VGND sky130_ef_sc_hd__decap_12
X_4099_ _2780_ _2824_ VGND VGND VPWR VPWR _2835_ sky130_fd_sc_hd__and2_1
XFILLER_0_65_447 VGND VGND VPWR VPWR sky130_fd_sc_hd__fill_1
XTAP_TAPCELL_ROW_41_707 VGND VPWR sky130_fd_sc_hd__tapvpwrvgnd_1
X_6809_ _2386_ _1293_ _1206_ _3269_ VGND VGND VPWR VPWR _2256_ sky130_fd_sc_hd__a22oi_1
XFILLER_0_92_277 VGND VGND VPWR VPWR sky130_fd_sc_hd__fill_2
XFILLER_0_92_266 VGND VGND VPWR VPWR sky130_fd_sc_hd__decap_8
XFILLER_0_53_609 VGND VGND VPWR VPWR sky130_fd_sc_hd__decap_6
XFILLER_0_18_396 VPWR VGND VPWR VGND sky130_ef_sc_hd__decap_12
XFILLER_0_45_160 VGND VGND VPWR VPWR sky130_fd_sc_hd__decap_8
XTAP_TAPCELL_ROW_98_1363 VGND VPWR sky130_fd_sc_hd__tapvpwrvgnd_1
XFILLER_0_60_141 VGND VGND VPWR VPWR sky130_fd_sc_hd__decap_8
XTAP_TAPCELL_ROW_21_475 VGND VPWR sky130_fd_sc_hd__tapvpwrvgnd_1
XFILLER_0_103_232 VGND VGND VPWR VPWR sky130_fd_sc_hd__fill_2
XFILLER_0_60_174 VPWR VGND VPWR VGND sky130_ef_sc_hd__decap_12
XFILLER_0_103_287 VGND VGND VPWR VPWR sky130_fd_sc_hd__fill_1
XFILLER_0_88_528 VGND VGND VPWR VPWR sky130_fd_sc_hd__decap_4
XTAP_TAPCELL_ROW_107_1470 VGND VPWR sky130_fd_sc_hd__tapvpwrvgnd_1
XTAP_TAPCELL_ROW_57_895 VGND VPWR sky130_fd_sc_hd__tapvpwrvgnd_1
XPHY_EDGE_ROW_14_Left_124 VGND VGND VPWR VPWR sky130_fd_sc_hd__decap_3
XTAP_TAPCELL_ROW_29_575 VGND VPWR sky130_fd_sc_hd__tapvpwrvgnd_1
XFILLER_0_96_561 VPWR VGND VPWR VGND sky130_ef_sc_hd__decap_12
XFILLER_0_29_617 VPWR VGND VPWR VGND sky130_ef_sc_hd__decap_12
XFILLER_0_68_285 VPWR VGND VPWR VGND sky130_ef_sc_hd__decap_12
XFILLER_0_43_108 VGND VGND VPWR VPWR sky130_fd_sc_hd__decap_4
XFILLER_0_83_277 VGND VGND VPWR VPWR sky130_fd_sc_hd__decap_3
XFILLER_0_24_300 VGND VGND VPWR VPWR sky130_fd_sc_hd__decap_8
XFILLER_0_3_205 VGND VGND VPWR VPWR sky130_fd_sc_hd__decap_8
XFILLER_0_24_344 VPWR VGND VPWR VGND sky130_ef_sc_hd__decap_12
XFILLER_0_3_249 VPWR VGND VPWR VGND sky130_ef_sc_hd__decap_12
XFILLER_0_10_65 VGND VGND VPWR VPWR sky130_fd_sc_hd__fill_1
XPHY_EDGE_ROW_23_Left_133 VGND VGND VPWR VPWR sky130_fd_sc_hd__decap_3
X_5140_ B[10] VGND VGND VPWR VPWR _0433_ sky130_fd_sc_hd__buf_2
XTAP_TAPCELL_ROW_71_1057 VGND VPWR sky130_fd_sc_hd__tapvpwrvgnd_1
X_5071_ _0320_ _0356_ _0357_ VGND VGND VPWR VPWR _0358_ sky130_fd_sc_hd__nor3_2
X_4022_ _1424_ _1391_ VGND VGND VPWR VPWR _1993_ sky130_fd_sc_hd__and2b_1
XFILLER_0_79_517 VPWR VGND VPWR VGND sky130_ef_sc_hd__decap_12
XPHY_EDGE_ROW_32_Left_142 VGND VGND VPWR VPWR sky130_fd_sc_hd__decap_3
X_5973_ _1201_ net139 VGND VGND VPWR VPWR _1342_ sky130_fd_sc_hd__and2b_1
X_7712_ _3239_ _3240_ _3212_ _3241_ _0953_ VGND VGND VPWR VPWR _3242_ sky130_fd_sc_hd__a41o_1
X_4924_ _3483_ _0197_ VGND VGND VPWR VPWR _0198_ sky130_fd_sc_hd__nor2_1
XFILLER_0_87_550 VGND VGND VPWR VPWR sky130_fd_sc_hd__fill_1
XFILLER_0_59_241 VGND VGND VPWR VPWR sky130_fd_sc_hd__fill_2
XFILLER_0_19_105 VGND VGND VPWR VPWR sky130_fd_sc_hd__decap_6
XFILLER_0_74_222 VPWR VGND VPWR VGND sky130_ef_sc_hd__decap_12
X_7643_ _3333_ _3335_ net54 _0311_ VGND VGND VPWR VPWR _3168_ sky130_fd_sc_hd__nand4_1
XTAP_TAPCELL_ROW_82_1175 VGND VPWR sky130_fd_sc_hd__tapvpwrvgnd_1
XFILLER_0_47_469 VPWR VGND VPWR VGND sky130_ef_sc_hd__decap_12
X_4855_ _3328_ _1818_ _1632_ _3332_ VGND VGND VPWR VPWR _0122_ sky130_fd_sc_hd__a22oi_2
X_7574_ _3088_ _3089_ _3090_ _3091_ VGND VGND VPWR VPWR _3092_ sky130_fd_sc_hd__o211a_1
XFILLER_0_74_288 VGND VGND VPWR VPWR sky130_fd_sc_hd__decap_4
X_4786_ _2703_ _2572_ VGND VGND VPWR VPWR _0047_ sky130_fd_sc_hd__nand2_1
X_6525_ _1908_ _1909_ _1943_ _1944_ VGND VGND VPWR VPWR _1945_ sky130_fd_sc_hd__or4bb_4
XFILLER_0_27_193 VPWR VGND VPWR VGND sky130_ef_sc_hd__decap_12
XFILLER_0_30_303 VGND VGND VPWR VPWR sky130_fd_sc_hd__decap_4
XPHY_EDGE_ROW_41_Left_151 VGND VGND VPWR VPWR sky130_fd_sc_hd__decap_3
XFILLER_0_42_163 VGND VGND VPWR VPWR sky130_fd_sc_hd__decap_4
XFILLER_0_30_325 VGND VGND VPWR VPWR sky130_fd_sc_hd__fill_1
XFILLER_0_30_347 VGND VGND VPWR VPWR sky130_fd_sc_hd__decap_6
X_6456_ _1866_ _1867_ _1868_ VGND VGND VPWR VPWR _1869_ sky130_fd_sc_hd__nand3b_1
XFILLER_0_100_224 VGND VGND VPWR VPWR sky130_fd_sc_hd__decap_3
X_5407_ _1479_ _1512_ _0593_ VGND VGND VPWR VPWR _0724_ sky130_fd_sc_hd__a21o_1
XFILLER_0_11_561 VGND VGND VPWR VPWR sky130_fd_sc_hd__decap_8
XFILLER_0_2_260 VPWR VGND VPWR VGND sky130_ef_sc_hd__decap_12
X_6387_ _1723_ _1724_ _1791_ _1792_ VGND VGND VPWR VPWR _1794_ sky130_fd_sc_hd__a2bb2o_1
X_5338_ _0631_ _0632_ _0647_ VGND VGND VPWR VPWR _0648_ sky130_fd_sc_hd__a21o_1
X_7008_ _2323_ _2301_ _2471_ VGND VGND VPWR VPWR _2473_ sky130_fd_sc_hd__a21o_1
X_5269_ _0570_ _0571_ _0477_ _0539_ VGND VGND VPWR VPWR _0574_ sky130_fd_sc_hd__o211ai_2
XPHY_EDGE_ROW_50_Left_160 VGND VGND VPWR VPWR sky130_fd_sc_hd__decap_3
XTAP_TAPCELL_ROW_26_534 VGND VPWR sky130_fd_sc_hd__tapvpwrvgnd_1
XTAP_TAPCELL_ROW_54_854 VGND VPWR sky130_fd_sc_hd__tapvpwrvgnd_1
XFILLER_0_78_583 VGND VGND VPWR VPWR sky130_fd_sc_hd__decap_4
XFILLER_0_65_200 VGND VGND VPWR VPWR sky130_fd_sc_hd__fill_2
XFILLER_0_93_564 VPWR VGND VPWR VGND sky130_ef_sc_hd__decap_12
XFILLER_0_108_357 VGND VGND VPWR VPWR sky130_fd_sc_hd__decap_6
Xwire102 _3236_ VGND VGND VPWR VPWR net102 sky130_fd_sc_hd__clkbuf_2
XFILLER_0_25_108 VGND VGND VPWR VPWR sky130_fd_sc_hd__decap_4
XFILLER_0_34_642 VGND VGND VPWR VPWR sky130_fd_sc_hd__fill_2
XFILLER_0_104_530 VGND VGND VPWR VPWR sky130_fd_sc_hd__fill_2
XFILLER_0_76_509 VGND VGND VPWR VPWR sky130_fd_sc_hd__decap_3
XFILLER_0_72_27 VGND VGND VPWR VPWR sky130_fd_sc_hd__fill_1
XFILLER_0_29_403 VGND VGND VPWR VPWR sky130_fd_sc_hd__decap_4
XFILLER_0_84_531 VGND VGND VPWR VPWR sky130_fd_sc_hd__fill_1
X_4640_ _3743_ _3533_ _3744_ _3343_ VGND VGND VPWR VPWR _3745_ sky130_fd_sc_hd__o211a_1
XFILLER_0_84_597 VPWR VGND VPWR VGND sky130_ef_sc_hd__decap_12
XFILLER_0_71_225 VGND VGND VPWR VPWR sky130_fd_sc_hd__decap_6
XFILLER_0_4_514 VPWR VGND VPWR VGND sky130_ef_sc_hd__decap_12
XFILLER_0_37_491 VGND VGND VPWR VPWR sky130_fd_sc_hd__fill_1
XFILLER_0_107_390 VGND VGND VPWR VPWR sky130_fd_sc_hd__fill_2
X_4571_ _2539_ _2747_ _3676_ VGND VGND VPWR VPWR _3677_ sky130_fd_sc_hd__or3_1
XFILLER_0_24_141 VGND VGND VPWR VPWR sky130_fd_sc_hd__fill_2
X_6310_ _1706_ _1707_ _1709_ VGND VGND VPWR VPWR _1710_ sky130_fd_sc_hd__nand3b_1
X_7290_ _1949_ _0802_ VGND VGND VPWR VPWR _2782_ sky130_fd_sc_hd__and2_1
XFILLER_0_12_336 VPWR VGND VPWR VGND sky130_ef_sc_hd__decap_12
XFILLER_0_4_569 VPWR VGND VPWR VGND sky130_ef_sc_hd__decap_12
XFILLER_0_24_174 VGND VGND VPWR VPWR sky130_fd_sc_hd__fill_1
XFILLER_0_40_645 VGND VGND VPWR VPWR sky130_fd_sc_hd__decap_6
X_6241_ _1631_ _1633_ _1488_ _1530_ VGND VGND VPWR VPWR _1635_ sky130_fd_sc_hd__o211ai_1
X_6172_ _1546_ _1547_ _1557_ VGND VGND VPWR VPWR _1559_ sky130_fd_sc_hd__nand3_1
X_5123_ _3316_ _1424_ VGND VGND VPWR VPWR _0414_ sky130_fd_sc_hd__nor2_1
X_5054_ _3021_ _1555_ VGND VGND VPWR VPWR _0339_ sky130_fd_sc_hd__nand2_1
XFILLER_0_46_61 VGND VGND VPWR VPWR sky130_fd_sc_hd__fill_1
X_4005_ _1796_ VGND VGND VPWR VPWR _1807_ sky130_fd_sc_hd__buf_4
XTAP_TAPCELL_ROW_84_1204 VGND VPWR sky130_fd_sc_hd__tapvpwrvgnd_1
XFILLER_0_94_306 VGND VGND VPWR VPWR sky130_fd_sc_hd__fill_2
X_5956_ _1320_ _1321_ _1322_ VGND VGND VPWR VPWR _1323_ sky130_fd_sc_hd__nand3_2
XTAP_TAPCELL_ROW_23_504 VGND VPWR sky130_fd_sc_hd__tapvpwrvgnd_1
XFILLER_0_47_200 VPWR VGND VPWR VGND sky130_ef_sc_hd__decap_12
X_4907_ _1697_ _0007_ _0090_ _0178_ _1763_ VGND VGND VPWR VPWR _0179_ sky130_fd_sc_hd__a311o_1
X_5887_ _1245_ _1246_ VGND VGND VPWR VPWR _1247_ sky130_fd_sc_hd__or2_1
XTAP_TAPCELL_ROW_51_824 VGND VPWR sky130_fd_sc_hd__tapvpwrvgnd_1
X_4838_ _3370_ _3374_ VGND VGND VPWR VPWR _0104_ sky130_fd_sc_hd__nand2_1
X_7626_ _3143_ _3148_ VGND VGND VPWR VPWR _3149_ sky130_fd_sc_hd__xnor2_1
XFILLER_0_35_439 VGND VGND VPWR VPWR sky130_fd_sc_hd__decap_4
XFILLER_0_105_305 VPWR VGND VPWR VGND sky130_ef_sc_hd__decap_12
XFILLER_0_7_374 VPWR VGND VPWR VGND sky130_ef_sc_hd__decap_12
XFILLER_0_90_589 VGND VGND VPWR VPWR sky130_fd_sc_hd__fill_1
X_4769_ _3492_ _0002_ _0005_ _0029_ VGND VGND VPWR VPWR net99 sky130_fd_sc_hd__a31o_1
X_7557_ _2993_ _2995_ VGND VGND VPWR VPWR _3073_ sky130_fd_sc_hd__and2b_1
XFILLER_0_15_141 VGND VGND VPWR VPWR sky130_fd_sc_hd__fill_1
XTAP_TAPCELL_ROW_31_592 VGND VPWR sky130_fd_sc_hd__tapvpwrvgnd_1
XTAP_TAPCELL_ROW_95_1333 VGND VPWR sky130_fd_sc_hd__tapvpwrvgnd_1
X_7488_ _2794_ _2796_ VGND VGND VPWR VPWR _2998_ sky130_fd_sc_hd__nor2_1
X_6508_ _1918_ _1919_ _1924_ VGND VGND VPWR VPWR _1926_ sky130_fd_sc_hd__a21o_1
X_6439_ _1846_ _1847_ _1848_ VGND VGND VPWR VPWR _1851_ sky130_fd_sc_hd__o21ai_1
XTAP_TAPCELL_ROW_59_913 VGND VPWR sky130_fd_sc_hd__tapvpwrvgnd_1
XFILLER_0_98_645 VGND VGND VPWR VPWR sky130_fd_sc_hd__decap_6
XFILLER_0_97_133 VGND VGND VPWR VPWR sky130_fd_sc_hd__fill_2
XTAP_TAPCELL_ROW_3_273 VGND VPWR sky130_fd_sc_hd__tapvpwrvgnd_1
XFILLER_0_97_166 VGND VGND VPWR VPWR sky130_fd_sc_hd__fill_2
XFILLER_0_85_317 VPWR VGND VPWR VGND sky130_ef_sc_hd__decap_12
XTAP_TAPCELL_ROW_39_681 VGND VPWR sky130_fd_sc_hd__tapvpwrvgnd_1
XFILLER_0_66_520 VGND VGND VPWR VPWR sky130_fd_sc_hd__decap_4
XFILLER_0_38_277 VGND VGND VPWR VPWR sky130_fd_sc_hd__fill_1
XANTENNA_7 _2846_ VGND VGND VPWR VPWR sky130_fd_sc_hd__diode_2
XFILLER_0_21_111 VGND VGND VPWR VPWR sky130_fd_sc_hd__fill_1
XFILLER_0_22_645 VGND VGND VPWR VPWR sky130_fd_sc_hd__decap_6
XFILLER_0_21_177 VGND VGND VPWR VPWR sky130_fd_sc_hd__fill_1
XFILLER_0_89_601 VPWR VGND VPWR VGND sky130_ef_sc_hd__decap_12
XFILLER_0_107_55 VGND VGND VPWR VPWR sky130_fd_sc_hd__fill_1
Xrebuffer19 _0883_ VGND VGND VPWR VPWR net137 sky130_fd_sc_hd__dlymetal6s2s_1
XFILLER_0_16_42 VPWR VGND VPWR VGND sky130_ef_sc_hd__decap_12
XFILLER_0_76_328 VGND VGND VPWR VPWR sky130_fd_sc_hd__decap_4
XFILLER_0_9_617 VPWR VGND VPWR VGND sky130_ef_sc_hd__decap_12
X_5810_ net60 net59 net4 net3 VGND VGND VPWR VPWR _1164_ sky130_fd_sc_hd__and4_1
XFILLER_0_16_97 VGND VGND VPWR VPWR sky130_fd_sc_hd__decap_8
X_6790_ _2105_ _2107_ VGND VGND VPWR VPWR _2235_ sky130_fd_sc_hd__nor2_1
XFILLER_0_29_222 VGND VGND VPWR VPWR sky130_fd_sc_hd__fill_2
X_5741_ _3360_ VGND VGND VPWR VPWR _1089_ sky130_fd_sc_hd__clkbuf_4
XFILLER_0_84_372 VGND VGND VPWR VPWR sky130_fd_sc_hd__fill_2
XFILLER_0_72_512 VGND VGND VPWR VPWR sky130_fd_sc_hd__decap_8
XFILLER_0_8_149 VGND VGND VPWR VPWR sky130_fd_sc_hd__fill_2
XFILLER_0_32_41 VPWR VGND VPWR VGND sky130_ef_sc_hd__decap_12
XFILLER_0_32_74 VGND VGND VPWR VPWR sky130_fd_sc_hd__decap_8
X_7411_ _2902_ _2913_ VGND VGND VPWR VPWR _2914_ sky130_fd_sc_hd__xnor2_1
XFILLER_0_96_7 VPWR VGND VPWR VGND sky130_ef_sc_hd__decap_12
XFILLER_0_17_439 VGND VGND VPWR VPWR sky130_fd_sc_hd__decap_8
X_5672_ _1643_ _1599_ net129 _0433_ VGND VGND VPWR VPWR _1013_ sky130_fd_sc_hd__a22oi_1
XFILLER_0_32_85 VPWR VGND VPWR VGND sky130_ef_sc_hd__decap_12
X_4623_ _3468_ _3485_ _3487_ _3476_ _3342_ _3340_ VGND VGND VPWR VPWR _3729_ sky130_fd_sc_hd__mux4_1
XFILLER_0_72_589 VPWR VGND VPWR VGND sky130_ef_sc_hd__decap_12
XFILLER_0_72_578 VGND VGND VPWR VPWR sky130_fd_sc_hd__decap_8
XFILLER_0_72_567 VGND VGND VPWR VPWR sky130_fd_sc_hd__decap_4
X_4554_ _3426_ _3459_ _3456_ _3452_ _3342_ _3339_ VGND VGND VPWR VPWR _3661_ sky130_fd_sc_hd__mux4_1
X_7342_ _2633_ _2635_ _2837_ _2838_ VGND VGND VPWR VPWR _2839_ sky130_fd_sc_hd__a211oi_2
XFILLER_0_25_472 VGND VGND VPWR VPWR sky130_fd_sc_hd__decap_8
X_7273_ _2761_ _2762_ VGND VGND VPWR VPWR _2763_ sky130_fd_sc_hd__xnor2_1
X_4485_ _3141_ _3569_ _3559_ VGND VGND VPWR VPWR _3593_ sky130_fd_sc_hd__a21oi_1
X_6224_ _1613_ _1612_ _1614_ VGND VGND VPWR VPWR _1616_ sky130_fd_sc_hd__a21o_1
XFILLER_0_0_561 VGND VGND VPWR VPWR sky130_fd_sc_hd__fill_2
XTAP_TAPCELL_ROW_90_1274 VGND VPWR sky130_fd_sc_hd__tapvpwrvgnd_1
X_6155_ _3524_ _1020_ VGND VGND VPWR VPWR _1540_ sky130_fd_sc_hd__nand2_1
X_5106_ _3255_ _3257_ _0394_ _0395_ _3606_ VGND VGND VPWR VPWR _0396_ sky130_fd_sc_hd__a311o_1
X_6086_ _0332_ _0660_ VGND VGND VPWR VPWR _1465_ sky130_fd_sc_hd__nand2_1
X_5037_ _0215_ _0319_ VGND VGND VPWR VPWR _0320_ sky130_fd_sc_hd__xnor2_1
XTAP_TAPCELL_ROW_0_221 VGND VPWR sky130_fd_sc_hd__tapvpwrvgnd_1
XFILLER_0_95_615 VGND VGND VPWR VPWR sky130_fd_sc_hd__fill_1
XTAP_TAPCELL_ROW_0_232 VGND VPWR sky130_fd_sc_hd__tapvpwrvgnd_1
XFILLER_0_67_317 VGND VGND VPWR VPWR sky130_fd_sc_hd__decap_4
XTAP_TAPCELL_ROW_64_971 VGND VPWR sky130_fd_sc_hd__tapvpwrvgnd_1
XTAP_TAPCELL_ROW_36_651 VGND VPWR sky130_fd_sc_hd__tapvpwrvgnd_1
XFILLER_0_82_309 VPWR VGND VPWR VGND sky130_ef_sc_hd__decap_12
X_6988_ _2012_ _2176_ _2450_ VGND VGND VPWR VPWR _2451_ sky130_fd_sc_hd__a21oi_1
XFILLER_0_48_531 VGND VGND VPWR VPWR sky130_fd_sc_hd__fill_1
XFILLER_0_75_361 VPWR VGND VPWR VGND sky130_ef_sc_hd__decap_12
X_5939_ _1296_ _1303_ VGND VGND VPWR VPWR _1305_ sky130_fd_sc_hd__xnor2_1
XFILLER_0_48_597 VGND VGND VPWR VPWR sky130_fd_sc_hd__decap_3
XFILLER_0_35_225 VPWR VGND VPWR VGND sky130_ef_sc_hd__decap_12
XFILLER_0_106_625 VPWR VGND VPWR VGND sky130_ef_sc_hd__decap_12
XFILLER_0_105_113 VPWR VGND VPWR VGND sky130_ef_sc_hd__decap_12
X_7609_ _3128_ _3129_ VGND VGND VPWR VPWR _3131_ sky130_fd_sc_hd__xor2_1
XFILLER_0_90_375 VGND VGND VPWR VPWR sky130_fd_sc_hd__decap_4
XFILLER_0_7_182 VGND VGND VPWR VPWR sky130_fd_sc_hd__decap_4
XFILLER_0_16_450 VPWR VGND VPWR VGND sky130_ef_sc_hd__decap_12
XFILLER_0_35_269 VGND VGND VPWR VPWR sky130_fd_sc_hd__decap_8
XFILLER_0_90_397 VGND VGND VPWR VPWR sky130_fd_sc_hd__fill_2
XFILLER_0_31_420 VPWR VGND VPWR VGND sky130_ef_sc_hd__decap_12
XFILLER_0_31_453 VPWR VGND VPWR VGND sky130_ef_sc_hd__decap_12
XFILLER_0_101_330 VGND VGND VPWR VPWR sky130_fd_sc_hd__decap_6
XFILLER_0_9_3 VPWR VGND VPWR VGND sky130_ef_sc_hd__decap_12
XTAP_TAPCELL_ROW_8_332 VGND VPWR sky130_fd_sc_hd__tapvpwrvgnd_1
XFILLER_0_101_385 VGND VGND VPWR VPWR sky130_fd_sc_hd__decap_6
Xoutput99 net99 VGND VGND VPWR VPWR result[8] sky130_fd_sc_hd__buf_2
Xoutput88 net88 VGND VGND VPWR VPWR result[27] sky130_fd_sc_hd__buf_2
Xoutput77 net77 VGND VGND VPWR VPWR result[17] sky130_fd_sc_hd__buf_2
XFILLER_0_58_306 VGND VGND VPWR VPWR sky130_fd_sc_hd__fill_2
XFILLER_0_98_497 VGND VGND VPWR VPWR sky130_fd_sc_hd__decap_3
XFILLER_0_86_637 VGND VGND VPWR VPWR sky130_fd_sc_hd__decap_6
XFILLER_0_85_158 VGND VGND VPWR VPWR sky130_fd_sc_hd__fill_1
XFILLER_0_66_372 VGND VGND VPWR VPWR sky130_fd_sc_hd__decap_8
XFILLER_0_54_501 VPWR VGND VPWR VGND sky130_ef_sc_hd__decap_12
XFILLER_0_54_545 VPWR VGND VPWR VGND sky130_ef_sc_hd__decap_12
XFILLER_0_54_589 VPWR VGND VPWR VGND sky130_ef_sc_hd__decap_12
X_4270_ _3380_ _3381_ _3311_ VGND VGND VPWR VPWR _3382_ sky130_fd_sc_hd__mux2_4
XFILLER_0_89_431 VPWR VGND VPWR VGND sky130_ef_sc_hd__decap_12
XTAP_TAPCELL_ROW_68_1018 VGND VPWR sky130_fd_sc_hd__tapvpwrvgnd_1
XPHY_EDGE_ROW_6_Left_116 VGND VGND VPWR VPWR sky130_fd_sc_hd__decap_3
XFILLER_0_27_85 VPWR VGND VPWR VGND sky130_ef_sc_hd__decap_12
XFILLER_0_77_615 VGND VGND VPWR VPWR sky130_fd_sc_hd__fill_1
X_6911_ _2205_ _2213_ VGND VGND VPWR VPWR _2367_ sky130_fd_sc_hd__or2b_1
XFILLER_0_77_648 VGND VGND VPWR VPWR sky130_fd_sc_hd__decap_4
XFILLER_0_76_125 VGND VGND VPWR VPWR sky130_fd_sc_hd__decap_4
X_6842_ _2289_ _2290_ _2125_ _2159_ VGND VGND VPWR VPWR _2292_ sky130_fd_sc_hd__a211o_1
XFILLER_0_49_328 VGND VGND VPWR VPWR sky130_fd_sc_hd__decap_8
XTAP_TAPCELL_ROW_33_621 VGND VPWR sky130_fd_sc_hd__tapvpwrvgnd_1
XFILLER_0_43_51 VGND VGND VPWR VPWR sky130_fd_sc_hd__decap_4
XFILLER_0_91_106 VGND VGND VPWR VPWR sky130_fd_sc_hd__decap_6
X_3985_ _1544_ _1577_ VGND VGND VPWR VPWR _1588_ sky130_fd_sc_hd__or2b_1
XTAP_TAPCELL_ROW_61_941 VGND VPWR sky130_fd_sc_hd__tapvpwrvgnd_1
XFILLER_0_43_95 VGND VGND VPWR VPWR sky130_fd_sc_hd__decap_3
X_6773_ _2203_ _2204_ _2214_ VGND VGND VPWR VPWR _2216_ sky130_fd_sc_hd__a21oi_1
XFILLER_0_9_469 VPWR VGND VPWR VGND sky130_ef_sc_hd__decap_12
X_5724_ _1067_ _1068_ _0980_ VGND VGND VPWR VPWR _1070_ sky130_fd_sc_hd__o21ai_1
XFILLER_0_45_534 VGND VGND VPWR VPWR sky130_fd_sc_hd__decap_6
XFILLER_0_72_342 VPWR VGND VPWR VGND sky130_ef_sc_hd__decap_12
X_5655_ _0985_ _0993_ VGND VGND VPWR VPWR _0994_ sky130_fd_sc_hd__xnor2_1
XFILLER_0_45_589 VGND VGND VPWR VPWR sky130_fd_sc_hd__decap_8
X_4606_ _3643_ _3646_ _3709_ _3491_ VGND VGND VPWR VPWR _3712_ sky130_fd_sc_hd__o31a_1
XTAP_TAPCELL_ROW_79_1147 VGND VPWR sky130_fd_sc_hd__tapvpwrvgnd_1
XFILLER_0_60_526 VGND VGND VPWR VPWR sky130_fd_sc_hd__decap_6
XFILLER_0_4_141 VGND VGND VPWR VPWR sky130_fd_sc_hd__fill_2
XFILLER_0_32_228 VPWR VGND VPWR VGND sky130_ef_sc_hd__decap_12
XFILLER_0_103_617 VPWR VGND VPWR VGND sky130_ef_sc_hd__decap_12
X_7325_ _2681_ _2583_ net48 net47 VGND VGND VPWR VPWR _2820_ sky130_fd_sc_hd__and4_1
X_5586_ _0808_ _0859_ _0917_ _0918_ VGND VGND VPWR VPWR _0919_ sky130_fd_sc_hd__o211a_4
XFILLER_0_13_420 VPWR VGND VPWR VGND sky130_ef_sc_hd__decap_12
X_4537_ _3585_ _3641_ _3587_ VGND VGND VPWR VPWR _3644_ sky130_fd_sc_hd__or3b_4
XFILLER_0_7_51 VGND VGND VPWR VPWR sky130_fd_sc_hd__decap_4
X_7256_ _2543_ _2546_ _2544_ VGND VGND VPWR VPWR _2744_ sky130_fd_sc_hd__o21ba_1
X_4468_ _3185_ _2867_ _3508_ _2977_ VGND VGND VPWR VPWR _3576_ sky130_fd_sc_hd__nand4_1
XFILLER_0_13_497 VGND VGND VPWR VPWR sky130_fd_sc_hd__decap_6
XFILLER_0_40_283 VGND VGND VPWR VPWR sky130_fd_sc_hd__fill_1
X_7187_ _0268_ _2475_ _0290_ VGND VGND VPWR VPWR _2669_ sky130_fd_sc_hd__a21oi_1
X_6207_ _1592_ _1595_ _1596_ VGND VGND VPWR VPWR _1597_ sky130_fd_sc_hd__nand3_1
X_6138_ _1504_ _1505_ _1518_ _1521_ VGND VGND VPWR VPWR _1522_ sky130_fd_sc_hd__o211a_1
X_4399_ _3508_ _2977_ VGND VGND VPWR VPWR _3509_ sky130_fd_sc_hd__and2_1
X_6069_ _1430_ _1431_ _1445_ VGND VGND VPWR VPWR _1447_ sky130_fd_sc_hd__a21o_2
XFILLER_0_68_637 VGND VGND VPWR VPWR sky130_fd_sc_hd__decap_6
XFILLER_0_67_125 VGND VGND VPWR VPWR sky130_fd_sc_hd__fill_2
XFILLER_0_82_106 VGND VGND VPWR VPWR sky130_fd_sc_hd__decap_8
XFILLER_0_36_501 VPWR VGND VPWR VGND sky130_ef_sc_hd__decap_12
XFILLER_0_82_128 VPWR VGND VPWR VGND sky130_ef_sc_hd__decap_12
XFILLER_0_63_331 VGND VGND VPWR VPWR sky130_fd_sc_hd__decap_4
XFILLER_0_106_433 VPWR VGND VPWR VGND sky130_ef_sc_hd__decap_12
XFILLER_0_63_364 VPWR VGND VPWR VGND sky130_ef_sc_hd__decap_12
XFILLER_0_36_589 VGND VGND VPWR VPWR sky130_fd_sc_hd__decap_8
XFILLER_0_90_172 VPWR VGND VPWR VGND sky130_ef_sc_hd__decap_12
XTAP_TAPCELL_ROW_11_359 VGND VPWR sky130_fd_sc_hd__tapvpwrvgnd_1
XFILLER_0_23_217 VGND VGND VPWR VPWR sky130_fd_sc_hd__decap_6
XFILLER_0_106_477 VGND VGND VPWR VPWR sky130_fd_sc_hd__decap_8
XPHY_EDGE_ROW_79_Left_189 VGND VGND VPWR VPWR sky130_fd_sc_hd__decap_3
XFILLER_0_98_283 VPWR VGND VPWR VGND sky130_ef_sc_hd__decap_12
XFILLER_0_86_412 VGND VGND VPWR VPWR sky130_fd_sc_hd__fill_1
XTAP_TAPCELL_ROW_19_459 VGND VPWR sky130_fd_sc_hd__tapvpwrvgnd_1
XTAP_TAPCELL_ROW_47_779 VGND VPWR sky130_fd_sc_hd__tapvpwrvgnd_1
XFILLER_0_86_434 VGND VGND VPWR VPWR sky130_fd_sc_hd__decap_8
XFILLER_0_80_38 VPWR VGND VPWR VGND sky130_ef_sc_hd__decap_12
XFILLER_0_58_125 VPWR VGND VPWR VGND sky130_ef_sc_hd__decap_12
XFILLER_0_86_489 VGND VGND VPWR VPWR sky130_fd_sc_hd__fill_1
XFILLER_0_58_169 VGND VGND VPWR VPWR sky130_fd_sc_hd__fill_1
XFILLER_0_39_361 VPWR VGND VPWR VGND sky130_ef_sc_hd__decap_12
XFILLER_0_46_309 VPWR VGND VPWR VGND sky130_ef_sc_hd__decap_12
XPHY_EDGE_ROW_88_Left_198 VGND VGND VPWR VPWR sky130_fd_sc_hd__decap_3
XFILLER_0_82_651 VGND VGND VPWR VPWR sky130_fd_sc_hd__fill_1
XFILLER_0_81_150 VGND VGND VPWR VPWR sky130_fd_sc_hd__decap_6
X_5440_ _2660_ net33 VGND VGND VPWR VPWR _0760_ sky130_fd_sc_hd__nand2_1
XFILLER_0_14_239 VPWR VGND VPWR VGND sky130_ef_sc_hd__decap_12
XFILLER_0_2_601 VPWR VGND VPWR VGND sky130_ef_sc_hd__decap_12
X_5371_ _0555_ _0564_ _0563_ VGND VGND VPWR VPWR _0685_ sky130_fd_sc_hd__a21bo_1
XFILLER_0_1_111 VGND VGND VPWR VPWR sky130_fd_sc_hd__fill_1
XFILLER_0_2_645 VGND VGND VPWR VPWR sky130_fd_sc_hd__decap_6
X_4322_ net24 _3432_ _3407_ VGND VGND VPWR VPWR _3433_ sky130_fd_sc_hd__mux2_2
X_7110_ _2080_ _1391_ _1949_ _0704_ VGND VGND VPWR VPWR _2585_ sky130_fd_sc_hd__a22oi_1
XFILLER_0_10_445 VGND VGND VPWR VPWR sky130_fd_sc_hd__decap_8
X_4253_ net63 net64 net66 VGND VGND VPWR VPWR _3365_ sky130_fd_sc_hd__nor3_2
X_7041_ _3306_ _2627_ net20 _0181_ VGND VGND VPWR VPWR _2509_ sky130_fd_sc_hd__and4_1
XTAP_TAPCELL_ROW_74_1088 VGND VPWR sky130_fd_sc_hd__tapvpwrvgnd_1
XFILLER_0_10_489 VPWR VGND VPWR VGND sky130_ef_sc_hd__decap_12
X_4184_ _0039_ _3285_ _3295_ VGND VGND VPWR VPWR _3296_ sky130_fd_sc_hd__and3_1
XFILLER_0_89_261 VPWR VGND VPWR VGND sky130_ef_sc_hd__decap_12
XFILLER_0_77_423 VGND VGND VPWR VPWR sky130_fd_sc_hd__decap_6
XFILLER_0_54_83 VGND VGND VPWR VPWR sky130_fd_sc_hd__fill_1
XFILLER_0_49_125 VPWR VGND VPWR VGND sky130_ef_sc_hd__decap_12
XFILLER_0_54_94 VPWR VGND VPWR VGND sky130_ef_sc_hd__decap_12
XFILLER_0_65_629 VPWR VGND VPWR VGND sky130_ef_sc_hd__decap_12
X_6825_ _2267_ _2272_ VGND VGND VPWR VPWR _2273_ sky130_fd_sc_hd__xor2_1
X_6756_ _2703_ _1107_ VGND VGND VPWR VPWR _2197_ sky130_fd_sc_hd__nand2_1
X_3968_ net35 VGND VGND VPWR VPWR _1402_ sky130_fd_sc_hd__buf_2
X_5707_ _1048_ _1049_ _1040_ VGND VGND VPWR VPWR _1051_ sky130_fd_sc_hd__a21o_1
X_3899_ _0486_ _0518_ _0562_ _0638_ VGND VGND VPWR VPWR _0649_ sky130_fd_sc_hd__nor4_1
X_6687_ _2061_ _2062_ _2120_ _2121_ VGND VGND VPWR VPWR _2122_ sky130_fd_sc_hd__or4bb_4
X_5638_ _3492_ _0950_ _0951_ _0975_ VGND VGND VPWR VPWR net77 sky130_fd_sc_hd__a31o_1
XFILLER_0_103_447 VGND VGND VPWR VPWR sky130_fd_sc_hd__fill_1
XFILLER_0_79_80 VGND VGND VPWR VPWR sky130_fd_sc_hd__fill_2
XFILLER_0_60_389 VGND VGND VPWR VPWR sky130_fd_sc_hd__decap_3
XFILLER_0_13_261 VPWR VGND VPWR VGND sky130_ef_sc_hd__decap_12
X_5569_ _3520_ _2025_ _1446_ _0242_ VGND VGND VPWR VPWR _0901_ sky130_fd_sc_hd__a22oi_2
XFILLER_0_20_209 VGND VGND VPWR VPWR sky130_fd_sc_hd__decap_4
X_7308_ _2799_ _2800_ VGND VGND VPWR VPWR _2801_ sky130_fd_sc_hd__xnor2_1
X_7239_ _2715_ _2724_ VGND VGND VPWR VPWR _2726_ sky130_fd_sc_hd__xnor2_1
XFILLER_0_95_231 VPWR VGND VPWR VGND sky130_ef_sc_hd__decap_12
XFILLER_0_95_220 VGND VGND VPWR VPWR sky130_fd_sc_hd__decap_4
XFILLER_0_68_456 VGND VGND VPWR VPWR sky130_fd_sc_hd__fill_1
XTAP_TAPCELL_ROW_16_418 VGND VPWR sky130_fd_sc_hd__tapvpwrvgnd_1
XTAP_TAPCELL_ROW_44_738 VGND VPWR sky130_fd_sc_hd__tapvpwrvgnd_1
XFILLER_0_28_309 VGND VGND VPWR VPWR sky130_fd_sc_hd__decap_6
XFILLER_0_64_651 VGND VGND VPWR VPWR sky130_fd_sc_hd__fill_1
XFILLER_0_59_39 VGND VGND VPWR VPWR sky130_fd_sc_hd__fill_2
XFILLER_0_51_389 VGND VGND VPWR VPWR sky130_fd_sc_hd__decap_3
XFILLER_0_32_581 VGND VGND VPWR VPWR sky130_fd_sc_hd__decap_6
XFILLER_0_91_15 VPWR VGND VPWR VGND sky130_ef_sc_hd__decap_12
X_4940_ _0123_ _0214_ VGND VGND VPWR VPWR _0215_ sky130_fd_sc_hd__and2_1
XPHY_EDGE_ROW_96_Left_206 VGND VGND VPWR VPWR sky130_fd_sc_hd__decap_3
XFILLER_0_86_253 VPWR VGND VPWR VGND sky130_ef_sc_hd__decap_12
XFILLER_0_59_467 VGND VGND VPWR VPWR sky130_fd_sc_hd__decap_3
X_4871_ _2474_ _3623_ _1839_ _3449_ VGND VGND VPWR VPWR _0140_ sky130_fd_sc_hd__a22o_1
X_7590_ _3107_ _3109_ VGND VGND VPWR VPWR _3110_ sky130_fd_sc_hd__xnor2_1
XFILLER_0_74_426 VGND VGND VPWR VPWR sky130_fd_sc_hd__decap_6
XFILLER_0_24_97 VPWR VGND VPWR VGND sky130_ef_sc_hd__decap_12
XFILLER_0_27_320 VPWR VGND VPWR VGND sky130_ef_sc_hd__decap_12
XFILLER_0_46_139 VGND VGND VPWR VPWR sky130_fd_sc_hd__fill_1
X_6610_ _2034_ _2035_ _2037_ VGND VGND VPWR VPWR _2038_ sky130_fd_sc_hd__and3_1
XFILLER_0_61_109 VGND VGND VPWR VPWR sky130_fd_sc_hd__decap_3
XFILLER_0_39_191 VPWR VGND VPWR VGND sky130_ef_sc_hd__decap_12
X_6541_ _1805_ _1961_ _1962_ VGND VGND VPWR VPWR _1963_ sky130_fd_sc_hd__or3_1
XFILLER_0_6_236 VPWR VGND VPWR VGND sky130_ef_sc_hd__decap_12
XFILLER_0_54_150 VGND VGND VPWR VPWR sky130_fd_sc_hd__fill_2
XTAP_TAPCELL_ROW_76_1106 VGND VPWR sky130_fd_sc_hd__tapvpwrvgnd_1
X_6472_ _1753_ _1761_ _1760_ VGND VGND VPWR VPWR _1887_ sky130_fd_sc_hd__a21o_1
XFILLER_0_15_559 VGND VGND VPWR VPWR sky130_fd_sc_hd__fill_1
XFILLER_0_40_85 VPWR VGND VPWR VGND sky130_ef_sc_hd__decap_12
XFILLER_0_30_507 VGND VGND VPWR VPWR sky130_fd_sc_hd__fill_2
X_5423_ _0738_ _0740_ VGND VGND VPWR VPWR _0741_ sky130_fd_sc_hd__nand2_1
XFILLER_0_42_389 VGND VGND VPWR VPWR sky130_fd_sc_hd__decap_4
XFILLER_0_100_417 VGND VGND VPWR VPWR sky130_fd_sc_hd__decap_3
X_5354_ _0663_ _0664_ _0655_ VGND VGND VPWR VPWR _0666_ sky130_fd_sc_hd__a21oi_1
XFILLER_0_100_428 VPWR VGND VPWR VGND sky130_ef_sc_hd__decap_12
X_4305_ _3345_ _3406_ _3407_ _3415_ VGND VGND VPWR VPWR _3416_ sky130_fd_sc_hd__o22a_1
X_5285_ _0511_ _0590_ VGND VGND VPWR VPWR _0591_ sky130_fd_sc_hd__and2_1
X_4236_ _3347_ VGND VGND VPWR VPWR _3348_ sky130_fd_sc_hd__buf_2
X_7024_ _0977_ _2472_ _2473_ _2490_ VGND VGND VPWR VPWR net88 sky130_fd_sc_hd__a31o_1
XFILLER_0_4_41 VPWR VGND VPWR VGND sky130_ef_sc_hd__decap_12
X_4167_ _3278_ _1905_ VGND VGND VPWR VPWR _3279_ sky130_fd_sc_hd__nor2_2
XFILLER_0_4_85 VGND VGND VPWR VPWR sky130_fd_sc_hd__decap_8
XFILLER_0_97_518 VPWR VGND VPWR VGND sky130_ef_sc_hd__decap_12
XTAP_TAPCELL_ROW_87_1235 VGND VPWR sky130_fd_sc_hd__tapvpwrvgnd_1
XFILLER_0_65_93 VPWR VGND VPWR VGND sky130_ef_sc_hd__decap_12
X_4098_ _2791_ _2813_ VGND VGND VPWR VPWR _2824_ sky130_fd_sc_hd__nand2_2
XFILLER_0_92_234 VGND VGND VPWR VPWR sky130_fd_sc_hd__decap_8
XFILLER_0_81_92 VGND VGND VPWR VPWR sky130_fd_sc_hd__decap_6
XFILLER_0_77_297 VGND VGND VPWR VPWR sky130_fd_sc_hd__fill_2
XTAP_TAPCELL_ROW_41_708 VGND VPWR sky130_fd_sc_hd__tapvpwrvgnd_1
X_6808_ _2386_ _3268_ _1282_ _1195_ VGND VGND VPWR VPWR _2254_ sky130_fd_sc_hd__and4_1
XFILLER_0_80_429 VGND VGND VPWR VPWR sky130_fd_sc_hd__fill_1
X_6739_ _2162_ _2163_ _2177_ VGND VGND VPWR VPWR _2179_ sky130_fd_sc_hd__a21o_1
XTAP_TAPCELL_ROW_98_1364 VGND VPWR sky130_fd_sc_hd__tapvpwrvgnd_1
XTAP_TAPCELL_ROW_21_476 VGND VPWR sky130_fd_sc_hd__tapvpwrvgnd_1
XFILLER_0_60_197 VPWR VGND VPWR VGND sky130_ef_sc_hd__decap_12
XFILLER_0_60_186 VGND VGND VPWR VPWR sky130_fd_sc_hd__decap_8
XFILLER_0_96_540 VGND VGND VPWR VPWR sky130_fd_sc_hd__fill_2
XTAP_TAPCELL_ROW_57_896 VGND VPWR sky130_fd_sc_hd__tapvpwrvgnd_1
XTAP_TAPCELL_ROW_29_565 VGND VPWR sky130_fd_sc_hd__tapvpwrvgnd_1
XTAP_TAPCELL_ROW_107_1471 VGND VPWR sky130_fd_sc_hd__tapvpwrvgnd_1
XFILLER_0_96_573 VPWR VGND VPWR VGND sky130_ef_sc_hd__decap_12
XFILLER_0_68_253 VGND VGND VPWR VPWR sky130_fd_sc_hd__decap_4
XFILLER_0_29_629 VPWR VGND VPWR VGND sky130_ef_sc_hd__decap_12
XFILLER_0_68_297 VGND VGND VPWR VPWR sky130_fd_sc_hd__decap_8
XFILLER_0_83_245 VGND VGND VPWR VPWR sky130_fd_sc_hd__decap_3
XFILLER_0_56_459 VGND VGND VPWR VPWR sky130_fd_sc_hd__decap_4
XFILLER_0_37_651 VGND VGND VPWR VPWR sky130_fd_sc_hd__fill_1
XFILLER_0_83_289 VGND VGND VPWR VPWR sky130_fd_sc_hd__decap_6
XFILLER_0_71_418 VGND VGND VPWR VPWR sky130_fd_sc_hd__decap_8
XFILLER_0_107_561 VPWR VGND VPWR VGND sky130_ef_sc_hd__decap_12
XFILLER_0_52_643 VGND VGND VPWR VPWR sky130_fd_sc_hd__fill_1
XFILLER_0_101_57 VPWR VGND VPWR VGND sky130_ef_sc_hd__decap_12
XFILLER_0_12_518 VGND VGND VPWR VPWR sky130_fd_sc_hd__decap_3
XFILLER_0_24_356 VGND VGND VPWR VPWR sky130_fd_sc_hd__decap_8
XTAP_TAPCELL_ROW_71_1058 VGND VPWR sky130_fd_sc_hd__tapvpwrvgnd_1
X_5070_ _0353_ _0354_ _0254_ _0321_ VGND VGND VPWR VPWR _0357_ sky130_fd_sc_hd__o211a_1
X_4021_ _1588_ _1916_ _1960_ _1971_ VGND VGND VPWR VPWR _1982_ sky130_fd_sc_hd__o2bb2a_1
XFILLER_0_79_529 VPWR VGND VPWR VGND sky130_ef_sc_hd__decap_12
X_5972_ _1339_ _1340_ VGND VGND VPWR VPWR _1341_ sky130_fd_sc_hd__nor2_1
X_4923_ _3396_ _3351_ VGND VGND VPWR VPWR _0197_ sky130_fd_sc_hd__nand2_1
X_7711_ _0977_ _3209_ _3210_ _3222_ VGND VGND VPWR VPWR _3241_ sky130_fd_sc_hd__a31oi_2
X_7642_ _3333_ net54 _0311_ _3335_ VGND VGND VPWR VPWR _3167_ sky130_fd_sc_hd__a22o_1
XTAP_TAPCELL_ROW_82_1176 VGND VPWR sky130_fd_sc_hd__tapvpwrvgnd_1
XFILLER_0_28_651 VGND VGND VPWR VPWR sky130_fd_sc_hd__fill_1
X_4854_ _0036_ _0045_ VGND VGND VPWR VPWR _0121_ sky130_fd_sc_hd__or2b_1
XFILLER_0_47_459 VGND VGND VPWR VPWR sky130_fd_sc_hd__decap_3
X_7573_ _3394_ _3321_ _0322_ _0072_ VGND VGND VPWR VPWR _3091_ sky130_fd_sc_hd__nand4_1
XFILLER_0_62_429 VGND VGND VPWR VPWR sky130_fd_sc_hd__fill_2
XFILLER_0_7_545 VPWR VGND VPWR VGND sky130_ef_sc_hd__decap_12
XFILLER_0_27_161 VGND VGND VPWR VPWR sky130_fd_sc_hd__decap_6
X_4785_ _0036_ _0045_ VGND VGND VPWR VPWR _0046_ sky130_fd_sc_hd__xnor2_1
XFILLER_0_55_492 VGND VGND VPWR VPWR sky130_fd_sc_hd__fill_2
X_6524_ _1941_ _1942_ _1782_ _1910_ VGND VGND VPWR VPWR _1944_ sky130_fd_sc_hd__o211ai_2
X_6455_ _2080_ _1665_ _3268_ _0704_ VGND VGND VPWR VPWR _1868_ sky130_fd_sc_hd__nand4_1
XFILLER_0_42_197 VGND VGND VPWR VPWR sky130_fd_sc_hd__fill_1
X_5406_ _3304_ _0716_ _0722_ VGND VGND VPWR VPWR _0723_ sky130_fd_sc_hd__a21o_1
XFILLER_0_2_272 VGND VGND VPWR VPWR sky130_fd_sc_hd__decap_8
X_6386_ _1723_ _1724_ _1792_ _1791_ VGND VGND VPWR VPWR _1793_ sky130_fd_sc_hd__or4bb_4
X_5337_ _0639_ _0646_ VGND VGND VPWR VPWR _0647_ sky130_fd_sc_hd__xnor2_1
X_5268_ _0477_ _0539_ _0570_ _0571_ VGND VGND VPWR VPWR _0572_ sky130_fd_sc_hd__a211o_2
X_7007_ _2323_ _2301_ _2471_ VGND VGND VPWR VPWR _2472_ sky130_fd_sc_hd__nand3_1
X_4219_ _3196_ VGND VGND VPWR VPWR _3331_ sky130_fd_sc_hd__buf_4
X_5199_ _0494_ _0496_ VGND VGND VPWR VPWR _0498_ sky130_fd_sc_hd__xnor2_2
XFILLER_0_97_337 VPWR VGND VPWR VGND sky130_ef_sc_hd__decap_12
XFILLER_0_78_540 VPWR VGND VPWR VGND sky130_ef_sc_hd__decap_12
XTAP_TAPCELL_ROW_26_535 VGND VPWR sky130_fd_sc_hd__tapvpwrvgnd_1
XTAP_TAPCELL_ROW_54_855 VGND VPWR sky130_fd_sc_hd__tapvpwrvgnd_1
XFILLER_0_78_595 VGND VGND VPWR VPWR sky130_fd_sc_hd__fill_1
XFILLER_0_65_223 VGND VGND VPWR VPWR sky130_fd_sc_hd__fill_1
XFILLER_0_65_245 VGND VGND VPWR VPWR sky130_fd_sc_hd__fill_1
XFILLER_0_38_448 VGND VGND VPWR VPWR sky130_fd_sc_hd__fill_2
XFILLER_0_93_576 VPWR VGND VPWR VGND sky130_ef_sc_hd__decap_12
XFILLER_0_65_289 VGND VGND VPWR VPWR sky130_fd_sc_hd__fill_1
XFILLER_0_53_418 VPWR VGND VPWR VGND sky130_ef_sc_hd__decap_12
XFILLER_0_80_259 VGND VGND VPWR VPWR sky130_fd_sc_hd__decap_4
XFILLER_0_34_621 VGND VGND VPWR VPWR sky130_fd_sc_hd__decap_6
XFILLER_0_33_131 VPWR VGND VPWR VGND sky130_ef_sc_hd__decap_12
XFILLER_0_21_337 VPWR VGND VPWR VGND sky130_ef_sc_hd__decap_12
XFILLER_0_33_175 VGND VGND VPWR VPWR sky130_fd_sc_hd__decap_3
XFILLER_0_56_29 VGND VGND VPWR VPWR sky130_fd_sc_hd__decap_8
XTAP_TAPCELL_ROW_109_1500 VGND VPWR sky130_fd_sc_hd__tapvpwrvgnd_1
XFILLER_0_72_39 VGND VGND VPWR VPWR sky130_fd_sc_hd__decap_6
XFILLER_0_96_392 VGND VGND VPWR VPWR sky130_fd_sc_hd__fill_1
XFILLER_0_8_309 VGND VGND VPWR VPWR sky130_fd_sc_hd__decap_8
XFILLER_0_56_234 VGND VGND VPWR VPWR sky130_fd_sc_hd__fill_2
XFILLER_0_71_215 VGND VGND VPWR VPWR sky130_fd_sc_hd__decap_6
X_4570_ _2725_ _3654_ VGND VGND VPWR VPWR _3676_ sky130_fd_sc_hd__nor2_1
XFILLER_0_108_3 VPWR VGND VPWR VGND sky130_ef_sc_hd__decap_12
XFILLER_0_4_526 VGND VGND VPWR VPWR sky130_fd_sc_hd__decap_6
XFILLER_0_24_131 VGND VGND VPWR VPWR sky130_fd_sc_hd__fill_2
XFILLER_0_52_440 VPWR VGND VPWR VGND sky130_ef_sc_hd__decap_12
XFILLER_0_24_197 VGND VGND VPWR VPWR sky130_fd_sc_hd__fill_2
XFILLER_0_12_348 VGND VGND VPWR VPWR sky130_fd_sc_hd__fill_1
X_6240_ _1530_ _1488_ _1631_ _1633_ VGND VGND VPWR VPWR _1634_ sky130_fd_sc_hd__a211o_1
X_6171_ _1546_ _1547_ _1557_ VGND VGND VPWR VPWR _1558_ sky130_fd_sc_hd__a21o_1
X_5122_ _1381_ _1402_ VGND VGND VPWR VPWR _0413_ sky130_fd_sc_hd__nand2_2
XFILLER_0_41_7 VGND VGND VPWR VPWR sky130_fd_sc_hd__fill_1
X_5053_ _0334_ _0337_ VGND VGND VPWR VPWR _0338_ sky130_fd_sc_hd__xnor2_2
X_4004_ _1785_ VGND VGND VPWR VPWR _1796_ sky130_fd_sc_hd__clkbuf_4
XTAP_TAPCELL_ROW_84_1205 VGND VPWR sky130_fd_sc_hd__tapvpwrvgnd_1
XFILLER_0_79_337 VGND VGND VPWR VPWR sky130_fd_sc_hd__decap_4
X_5955_ _1175_ _1183_ _1182_ VGND VGND VPWR VPWR _1322_ sky130_fd_sc_hd__a21bo_1
XTAP_TAPCELL_ROW_23_505 VGND VPWR sky130_fd_sc_hd__tapvpwrvgnd_1
XFILLER_0_47_212 VPWR VGND VPWR VGND sky130_ef_sc_hd__decap_12
X_4906_ _3275_ _3276_ VGND VGND VPWR VPWR _0178_ sky130_fd_sc_hd__and2_1
X_5886_ _1239_ _1244_ VGND VGND VPWR VPWR _1246_ sky130_fd_sc_hd__nor2_1
XFILLER_0_47_256 VPWR VGND VPWR VGND sky130_ef_sc_hd__decap_12
XTAP_TAPCELL_ROW_51_825 VGND VPWR sky130_fd_sc_hd__tapvpwrvgnd_1
X_4837_ _3445_ _0102_ VGND VGND VPWR VPWR _0103_ sky130_fd_sc_hd__nand2_1
X_7625_ _3144_ _3147_ VGND VGND VPWR VPWR _3148_ sky130_fd_sc_hd__xnor2_1
XFILLER_0_62_215 VGND VGND VPWR VPWR sky130_fd_sc_hd__fill_2
XFILLER_0_47_289 VGND VGND VPWR VPWR sky130_fd_sc_hd__fill_2
XFILLER_0_105_317 VGND VGND VPWR VPWR sky130_fd_sc_hd__decap_8
XFILLER_0_16_643 VGND VGND VPWR VPWR sky130_fd_sc_hd__fill_1
X_4768_ _0007_ _0009_ _0025_ _0028_ VGND VGND VPWR VPWR _0029_ sky130_fd_sc_hd__a211o_1
X_7556_ _3070_ _3071_ VGND VGND VPWR VPWR _3072_ sky130_fd_sc_hd__or2_1
XFILLER_0_7_386 VGND VGND VPWR VPWR sky130_fd_sc_hd__decap_6
XTAP_TAPCELL_ROW_31_593 VGND VPWR sky130_fd_sc_hd__tapvpwrvgnd_1
XTAP_TAPCELL_ROW_95_1334 VGND VPWR sky130_fd_sc_hd__tapvpwrvgnd_1
X_4699_ _3802_ _3803_ VGND VGND VPWR VPWR _3804_ sky130_fd_sc_hd__nand2_1
X_7487_ _2832_ _2834_ VGND VGND VPWR VPWR _2997_ sky130_fd_sc_hd__and2b_1
XFILLER_0_15_164 VGND VGND VPWR VPWR sky130_fd_sc_hd__decap_4
X_6507_ _1918_ _1919_ _1924_ VGND VGND VPWR VPWR _1925_ sky130_fd_sc_hd__nand3_1
XFILLER_0_43_495 VGND VGND VPWR VPWR sky130_fd_sc_hd__decap_8
XFILLER_0_101_501 VGND VGND VPWR VPWR sky130_fd_sc_hd__decap_3
X_6438_ _1846_ _1847_ _1848_ VGND VGND VPWR VPWR _1849_ sky130_fd_sc_hd__or3_1
XFILLER_0_101_545 VPWR VGND VPWR VGND sky130_ef_sc_hd__decap_12
X_6369_ net155 _3622_ net15 net10 VGND VGND VPWR VPWR _1775_ sky130_fd_sc_hd__and4_1
XTAP_TAPCELL_ROW_59_914 VGND VPWR sky130_fd_sc_hd__tapvpwrvgnd_1
XTAP_TAPCELL_ROW_3_274 VGND VPWR sky130_fd_sc_hd__tapvpwrvgnd_1
XTAP_TAPCELL_ROW_39_682 VGND VPWR sky130_fd_sc_hd__tapvpwrvgnd_1
XTAP_TAPCELL_ROW_104_1430 VGND VPWR sky130_fd_sc_hd__tapvpwrvgnd_1
XFILLER_0_97_178 VGND VGND VPWR VPWR sky130_fd_sc_hd__fill_1
XFILLER_0_85_329 VGND VGND VPWR VPWR sky130_fd_sc_hd__decap_6
XFILLER_0_66_510 VGND VGND VPWR VPWR sky130_fd_sc_hd__decap_4
XFILLER_0_109_601 VPWR VGND VPWR VGND sky130_ef_sc_hd__decap_12
XFILLER_0_38_234 VGND VGND VPWR VPWR sky130_fd_sc_hd__decap_8
XFILLER_0_109_645 VGND VGND VPWR VPWR sky130_fd_sc_hd__decap_6
XFILLER_0_81_502 VGND VGND VPWR VPWR sky130_fd_sc_hd__fill_2
XFILLER_0_66_587 VGND VGND VPWR VPWR sky130_fd_sc_hd__fill_1
XFILLER_0_81_557 VGND VGND VPWR VPWR sky130_fd_sc_hd__decap_3
XANTENNA_8 _2846_ VGND VGND VPWR VPWR sky130_fd_sc_hd__diode_2
XFILLER_0_61_281 VGND VGND VPWR VPWR sky130_fd_sc_hd__decap_8
XFILLER_0_34_484 VGND VGND VPWR VPWR sky130_fd_sc_hd__decap_8
XFILLER_0_104_350 VPWR VGND VPWR VGND sky130_ef_sc_hd__decap_12
XFILLER_0_89_613 VGND VGND VPWR VPWR sky130_fd_sc_hd__decap_3
XFILLER_0_16_54 VPWR VGND VPWR VGND sky130_ef_sc_hd__decap_12
X_5740_ _0386_ VGND VGND VPWR VPWR _1088_ sky130_fd_sc_hd__clkbuf_4
XFILLER_0_9_629 VPWR VGND VPWR VGND sky130_ef_sc_hd__decap_12
XFILLER_0_8_139 VGND VGND VPWR VPWR sky130_fd_sc_hd__fill_1
XFILLER_0_32_53 VPWR VGND VPWR VGND sky130_ef_sc_hd__decap_12
X_7410_ _2910_ _2912_ VGND VGND VPWR VPWR _2913_ sky130_fd_sc_hd__nor2_1
X_5671_ _3772_ _1523_ VGND VGND VPWR VPWR _1012_ sky130_fd_sc_hd__nand2_1
XFILLER_0_32_97 VPWR VGND VPWR VGND sky130_ef_sc_hd__decap_12
X_4622_ net118 _3726_ _3727_ _3302_ VGND VGND VPWR VPWR _3728_ sky130_fd_sc_hd__a22o_1
XFILLER_0_4_301 VGND VGND VPWR VPWR sky130_fd_sc_hd__decap_6
XFILLER_0_102_309 VPWR VGND VPWR VGND sky130_ef_sc_hd__decap_12
X_4553_ _3314_ _3340_ _3422_ _3659_ VGND VGND VPWR VPWR _3660_ sky130_fd_sc_hd__o31a_2
X_7341_ _2834_ _2836_ _2598_ _2600_ VGND VGND VPWR VPWR _2838_ sky130_fd_sc_hd__a211oi_1
XFILLER_0_40_421 VPWR VGND VPWR VGND sky130_ef_sc_hd__decap_12
X_4484_ _3315_ _3327_ _3378_ _3318_ _3339_ _3395_ VGND VGND VPWR VPWR _3592_ sky130_fd_sc_hd__mux4_1
X_7272_ _3325_ _0944_ VGND VGND VPWR VPWR _2762_ sky130_fd_sc_hd__nand2_1
X_6223_ _1612_ _1613_ _1614_ VGND VGND VPWR VPWR _1615_ sky130_fd_sc_hd__nand3_1
XTAP_TAPCELL_ROW_90_1275 VGND VPWR sky130_fd_sc_hd__tapvpwrvgnd_1
X_6154_ _1537_ _1538_ VGND VGND VPWR VPWR _1539_ sky130_fd_sc_hd__nor2_1
X_5105_ _0394_ _3258_ VGND VGND VPWR VPWR _0395_ sky130_fd_sc_hd__and2b_1
X_6085_ _0758_ _1462_ _1463_ VGND VGND VPWR VPWR _1464_ sky130_fd_sc_hd__a21bo_1
XFILLER_0_32_3 VGND VGND VPWR VPWR sky130_fd_sc_hd__fill_1
X_5036_ _0308_ _0318_ VGND VGND VPWR VPWR _0319_ sky130_fd_sc_hd__xnor2_1
XFILLER_0_79_145 VPWR VGND VPWR VGND sky130_ef_sc_hd__decap_12
XTAP_TAPCELL_ROW_0_222 VGND VPWR sky130_fd_sc_hd__tapvpwrvgnd_1
XTAP_TAPCELL_ROW_0_233 VGND VPWR sky130_fd_sc_hd__tapvpwrvgnd_1
XFILLER_0_95_649 VGND VGND VPWR VPWR sky130_fd_sc_hd__decap_3
XFILLER_0_94_104 VPWR VGND VPWR VGND sky130_ef_sc_hd__decap_12
XFILLER_0_79_189 VGND VGND VPWR VPWR sky130_fd_sc_hd__fill_2
XTAP_TAPCELL_ROW_64_972 VGND VPWR sky130_fd_sc_hd__tapvpwrvgnd_1
XTAP_TAPCELL_ROW_36_652 VGND VPWR sky130_fd_sc_hd__tapvpwrvgnd_1
X_6987_ _2164_ _2175_ VGND VGND VPWR VPWR _2450_ sky130_fd_sc_hd__nor2_1
X_5938_ _1302_ _1297_ VGND VGND VPWR VPWR _1303_ sky130_fd_sc_hd__xnor2_2
XFILLER_0_75_373 VGND VGND VPWR VPWR sky130_fd_sc_hd__fill_2
XFILLER_0_90_321 VPWR VGND VPWR VGND sky130_ef_sc_hd__decap_12
X_5869_ _3376_ _1304_ _1096_ VGND VGND VPWR VPWR _1229_ sky130_fd_sc_hd__o21ai_1
XFILLER_0_8_651 VGND VGND VPWR VPWR sky130_fd_sc_hd__fill_1
XFILLER_0_35_237 VPWR VGND VPWR VGND sky130_ef_sc_hd__decap_12
XFILLER_0_106_637 VGND VGND VPWR VPWR sky130_fd_sc_hd__decap_6
XFILLER_0_105_125 VGND VGND VPWR VPWR sky130_fd_sc_hd__fill_2
X_7608_ _1752_ _0933_ VGND VGND VPWR VPWR _3129_ sky130_fd_sc_hd__nand2_1
XFILLER_0_90_365 VGND VGND VPWR VPWR sky130_fd_sc_hd__decap_4
XFILLER_0_63_579 VPWR VGND VPWR VGND sky130_ef_sc_hd__decap_12
XFILLER_0_105_136 VGND VGND VPWR VPWR sky130_fd_sc_hd__fill_2
X_7539_ _2876_ _2854_ _2855_ _3053_ VGND VGND VPWR VPWR _3055_ sky130_fd_sc_hd__o31ai_2
XFILLER_0_16_462 VPWR VGND VPWR VGND sky130_ef_sc_hd__decap_12
XFILLER_0_31_432 VGND VGND VPWR VPWR sky130_fd_sc_hd__fill_1
XFILLER_0_43_281 VPWR VGND VPWR VGND sky130_ef_sc_hd__decap_12
XFILLER_0_31_465 VGND VGND VPWR VPWR sky130_fd_sc_hd__decap_3
Xoutput67 net67 VGND VGND VPWR VPWR carry sky130_fd_sc_hd__clkbuf_4
XTAP_TAPCELL_ROW_8_333 VGND VPWR sky130_fd_sc_hd__tapvpwrvgnd_1
Xoutput78 net78 VGND VGND VPWR VPWR result[18] sky130_fd_sc_hd__clkbuf_4
Xoutput89 net89 VGND VGND VPWR VPWR result[28] sky130_fd_sc_hd__buf_2
XFILLER_0_98_421 VGND VGND VPWR VPWR sky130_fd_sc_hd__fill_2
XFILLER_0_98_465 VGND VGND VPWR VPWR sky130_fd_sc_hd__fill_2
XFILLER_0_58_329 VGND VGND VPWR VPWR sky130_fd_sc_hd__decap_4
XFILLER_0_66_351 VPWR VGND VPWR VGND sky130_ef_sc_hd__decap_12
XFILLER_0_54_513 VPWR VGND VPWR VGND sky130_ef_sc_hd__decap_12
XFILLER_0_54_557 VPWR VGND VPWR VGND sky130_ef_sc_hd__decap_12
XFILLER_0_78_27 VGND VGND VPWR VPWR sky130_fd_sc_hd__fill_1
XFILLER_0_78_16 VGND VGND VPWR VPWR sky130_fd_sc_hd__decap_4
XFILLER_0_22_421 VGND VGND VPWR VPWR sky130_fd_sc_hd__fill_1
XFILLER_0_22_465 VGND VGND VPWR VPWR sky130_fd_sc_hd__decap_8
XTAP_TAPCELL_ROW_68_1019 VGND VPWR sky130_fd_sc_hd__tapvpwrvgnd_1
XFILLER_0_89_443 VGND VGND VPWR VPWR sky130_fd_sc_hd__decap_4
X_6910_ _2206_ _2212_ VGND VGND VPWR VPWR _2366_ sky130_fd_sc_hd__or2b_1
X_6841_ _2125_ net104 _2289_ _2290_ VGND VGND VPWR VPWR _2291_ sky130_fd_sc_hd__o211ai_4
XFILLER_0_76_137 VGND VGND VPWR VPWR sky130_fd_sc_hd__decap_3
XTAP_TAPCELL_ROW_33_611 VGND VPWR sky130_fd_sc_hd__tapvpwrvgnd_1
XFILLER_0_92_619 VPWR VGND VPWR VGND sky130_ef_sc_hd__decap_12
XTAP_TAPCELL_ROW_61_942 VGND VPWR sky130_fd_sc_hd__tapvpwrvgnd_1
XFILLER_0_57_340 VPWR VGND VPWR VGND sky130_ef_sc_hd__decap_12
X_3984_ _1566_ VGND VGND VPWR VPWR _1577_ sky130_fd_sc_hd__clkbuf_4
X_6772_ _2203_ _2204_ _2214_ VGND VGND VPWR VPWR _2215_ sky130_fd_sc_hd__and3_1
XFILLER_0_45_502 VGND VGND VPWR VPWR sky130_fd_sc_hd__fill_2
XFILLER_0_72_321 VGND VGND VPWR VPWR sky130_fd_sc_hd__fill_1
X_5723_ _0980_ _1067_ _1068_ VGND VGND VPWR VPWR _1069_ sky130_fd_sc_hd__or3_4
XFILLER_0_84_192 VGND VGND VPWR VPWR sky130_fd_sc_hd__decap_4
XFILLER_0_72_365 VPWR VGND VPWR VGND sky130_ef_sc_hd__decap_12
XFILLER_0_72_354 VGND VGND VPWR VPWR sky130_fd_sc_hd__decap_8
X_5654_ _0986_ _0992_ VGND VGND VPWR VPWR _0993_ sky130_fd_sc_hd__xnor2_1
XFILLER_0_45_568 VPWR VGND VPWR VGND sky130_ef_sc_hd__decap_12
X_4605_ _3646_ _3708_ VGND VGND VPWR VPWR _3711_ sky130_fd_sc_hd__nand2_2
XTAP_TAPCELL_ROW_79_1148 VGND VPWR sky130_fd_sc_hd__tapvpwrvgnd_1
XTAP_TAPCELL_ROW_13_390 VGND VPWR sky130_fd_sc_hd__tapvpwrvgnd_1
XPHY_EDGE_ROW_107_Left_217 VGND VGND VPWR VPWR sky130_fd_sc_hd__decap_3
XFILLER_0_103_629 VPWR VGND VPWR VGND sky130_ef_sc_hd__decap_12
X_7324_ _2583_ net48 net47 _2681_ VGND VGND VPWR VPWR _2819_ sky130_fd_sc_hd__a22oi_1
X_5585_ _0880_ _0881_ _0915_ _0916_ VGND VGND VPWR VPWR _0918_ sky130_fd_sc_hd__o22ai_1
XFILLER_0_4_164 VGND VGND VPWR VPWR sky130_fd_sc_hd__decap_4
XFILLER_0_13_432 VGND VGND VPWR VPWR sky130_fd_sc_hd__decap_4
XFILLER_0_13_443 VGND VGND VPWR VPWR sky130_fd_sc_hd__decap_4
XFILLER_0_25_281 VPWR VGND VPWR VGND sky130_ef_sc_hd__decap_12
X_4536_ _3590_ _3641_ VGND VGND VPWR VPWR _3643_ sky130_fd_sc_hd__nor2_1
XFILLER_0_4_197 VGND VGND VPWR VPWR sky130_fd_sc_hd__decap_8
XFILLER_0_40_251 VGND VGND VPWR VPWR sky130_fd_sc_hd__fill_1
X_7255_ _2741_ _2742_ VGND VGND VPWR VPWR _2743_ sky130_fd_sc_hd__xnor2_1
X_4467_ _3185_ _3518_ _3152_ _3521_ VGND VGND VPWR VPWR _3575_ sky130_fd_sc_hd__a22o_1
X_7186_ _0506_ _2656_ _2667_ VGND VGND VPWR VPWR _2668_ sky130_fd_sc_hd__a21o_1
X_6206_ _1457_ _1719_ _1593_ _1594_ VGND VGND VPWR VPWR _1596_ sky130_fd_sc_hd__nand4_1
X_4398_ _2889_ VGND VGND VPWR VPWR _3508_ sky130_fd_sc_hd__clkbuf_4
X_6137_ _1140_ _1519_ _1520_ VGND VGND VPWR VPWR _1521_ sky130_fd_sc_hd__o21ai_1
XFILLER_0_99_229 VPWR VGND VPWR VGND sky130_ef_sc_hd__decap_12
X_6068_ _1437_ _1444_ VGND VGND VPWR VPWR _1445_ sky130_fd_sc_hd__xnor2_1
X_5019_ _3275_ _0183_ _0292_ _0187_ VGND VGND VPWR VPWR _0301_ sky130_fd_sc_hd__a211o_1
XFILLER_0_95_402 VGND VGND VPWR VPWR sky130_fd_sc_hd__fill_2
XFILLER_0_95_435 VGND VGND VPWR VPWR sky130_fd_sc_hd__fill_1
XTAP_TAPCELL_ROW_101_1400 VGND VPWR sky130_fd_sc_hd__tapvpwrvgnd_1
XFILLER_0_48_340 VGND VGND VPWR VPWR sky130_fd_sc_hd__fill_1
XFILLER_0_75_181 VPWR VGND VPWR VGND sky130_ef_sc_hd__decap_12
XFILLER_0_36_513 VGND VGND VPWR VPWR sky130_fd_sc_hd__fill_2
XFILLER_0_91_641 VGND VGND VPWR VPWR sky130_fd_sc_hd__decap_8
XFILLER_0_51_505 VPWR VGND VPWR VGND sky130_ef_sc_hd__decap_12
XFILLER_0_106_445 VPWR VGND VPWR VGND sky130_ef_sc_hd__decap_12
XFILLER_0_90_184 VPWR VGND VPWR VGND sky130_ef_sc_hd__decap_12
XFILLER_0_90_162 VGND VGND VPWR VPWR sky130_fd_sc_hd__decap_3
XFILLER_0_63_376 VPWR VGND VPWR VGND sky130_ef_sc_hd__decap_12
XFILLER_0_102_651 VGND VGND VPWR VPWR sky130_fd_sc_hd__fill_1
XFILLER_0_64_29 VGND VGND VPWR VPWR sky130_fd_sc_hd__decap_8
XFILLER_0_98_251 VGND VGND VPWR VPWR sky130_fd_sc_hd__fill_1
XFILLER_0_86_402 VGND VGND VPWR VPWR sky130_fd_sc_hd__fill_2
XFILLER_0_59_638 VGND VGND VPWR VPWR sky130_fd_sc_hd__decap_8
XFILLER_0_98_295 VPWR VGND VPWR VGND sky130_ef_sc_hd__decap_12
XFILLER_0_58_137 VGND VGND VPWR VPWR sky130_fd_sc_hd__decap_3
XFILLER_0_27_502 VGND VGND VPWR VPWR sky130_fd_sc_hd__fill_2
XFILLER_0_13_55 VGND VGND VPWR VPWR sky130_fd_sc_hd__fill_1
XFILLER_0_39_373 VPWR VGND VPWR VGND sky130_ef_sc_hd__decap_12
XFILLER_0_6_418 VGND VGND VPWR VPWR sky130_fd_sc_hd__fill_2
XFILLER_0_42_505 VGND VGND VPWR VPWR sky130_fd_sc_hd__fill_1
XFILLER_0_54_365 VPWR VGND VPWR VGND sky130_ef_sc_hd__decap_12
XFILLER_0_2_613 VPWR VGND VPWR VGND sky130_ef_sc_hd__decap_12
X_5370_ _0680_ _0681_ _0673_ VGND VGND VPWR VPWR _0684_ sky130_fd_sc_hd__a21o_1
X_4321_ _3345_ _0322_ _3431_ VGND VGND VPWR VPWR _3432_ sky130_fd_sc_hd__a21o_1
XFILLER_0_1_167 VGND VGND VPWR VPWR sky130_fd_sc_hd__fill_1
XFILLER_0_22_273 VPWR VGND VPWR VGND sky130_ef_sc_hd__decap_12
X_4252_ _3363_ VGND VGND VPWR VPWR _3364_ sky130_fd_sc_hd__clkbuf_4
X_7040_ _3306_ net20 _0181_ _2627_ VGND VGND VPWR VPWR _2508_ sky130_fd_sc_hd__a22oi_1
XTAP_TAPCELL_ROW_74_1089 VGND VPWR sky130_fd_sc_hd__tapvpwrvgnd_1
XFILLER_0_38_63 VGND VGND VPWR VPWR sky130_fd_sc_hd__fill_1
X_4183_ _3293_ _3294_ VGND VGND VPWR VPWR _3295_ sky130_fd_sc_hd__nor2_1
XFILLER_0_38_74 VGND VGND VPWR VPWR sky130_fd_sc_hd__decap_8
XFILLER_0_38_85 VPWR VGND VPWR VGND sky130_ef_sc_hd__decap_12
XFILLER_0_89_273 VGND VGND VPWR VPWR sky130_fd_sc_hd__decap_6
XFILLER_0_49_137 VGND VGND VPWR VPWR sky130_fd_sc_hd__decap_3
XFILLER_0_77_468 VGND VGND VPWR VPWR sky130_fd_sc_hd__fill_2
X_6824_ _2270_ _2271_ VGND VGND VPWR VPWR _2272_ sky130_fd_sc_hd__xnor2_1
X_6755_ _2194_ _2195_ VGND VGND VPWR VPWR _2196_ sky130_fd_sc_hd__nor2_1
X_3967_ _1381_ VGND VGND VPWR VPWR _1391_ sky130_fd_sc_hd__buf_2
X_5706_ _1040_ _1048_ _1049_ VGND VGND VPWR VPWR _1050_ sky130_fd_sc_hd__nand3_2
XFILLER_0_18_568 VPWR VGND VPWR VGND sky130_ef_sc_hd__decap_12
X_3898_ _0595_ _0627_ VGND VGND VPWR VPWR _0638_ sky130_fd_sc_hd__nand2_1
X_6686_ _2118_ _2119_ _1943_ _1945_ VGND VGND VPWR VPWR _2121_ sky130_fd_sc_hd__o211ai_2
XFILLER_0_33_505 VPWR VGND VPWR VGND sky130_ef_sc_hd__decap_12
X_5637_ _0952_ _0954_ _0974_ VGND VGND VPWR VPWR _0975_ sky130_fd_sc_hd__o21ai_1
XFILLER_0_72_195 VGND VGND VPWR VPWR sky130_fd_sc_hd__fill_1
X_5568_ _0463_ _2955_ _2025_ net5 VGND VGND VPWR VPWR _0899_ sky130_fd_sc_hd__and4_1
X_4519_ _3097_ _2692_ VGND VGND VPWR VPWR _3626_ sky130_fd_sc_hd__nand2_1
XFILLER_0_13_273 VGND VGND VPWR VPWR sky130_fd_sc_hd__decap_6
X_7307_ _2562_ _2602_ VGND VGND VPWR VPWR _2800_ sky130_fd_sc_hd__or2b_1
X_7238_ _2722_ _2723_ VGND VGND VPWR VPWR _2724_ sky130_fd_sc_hd__and2_1
X_5499_ _0705_ _0823_ VGND VGND VPWR VPWR _0825_ sky130_fd_sc_hd__xnor2_1
X_7169_ _2647_ _2648_ VGND VGND VPWR VPWR _2650_ sky130_fd_sc_hd__xnor2_1
XTAP_TAPCELL_ROW_16_419 VGND VPWR sky130_fd_sc_hd__tapvpwrvgnd_1
XTAP_TAPCELL_ROW_44_739 VGND VPWR sky130_fd_sc_hd__tapvpwrvgnd_1
XFILLER_0_95_243 VGND VGND VPWR VPWR sky130_fd_sc_hd__fill_2
XFILLER_0_68_468 VGND VGND VPWR VPWR sky130_fd_sc_hd__decap_8
XFILLER_0_95_298 VPWR VGND VPWR VGND sky130_ef_sc_hd__decap_12
XFILLER_0_36_321 VGND VGND VPWR VPWR sky130_fd_sc_hd__decap_6
XFILLER_0_106_231 VGND VGND VPWR VPWR sky130_fd_sc_hd__fill_2
XFILLER_0_106_220 VGND VGND VPWR VPWR sky130_fd_sc_hd__fill_2
XFILLER_0_36_365 VPWR VGND VPWR VGND sky130_ef_sc_hd__decap_12
XFILLER_0_106_253 VPWR VGND VPWR VGND sky130_ef_sc_hd__decap_12
XFILLER_0_24_549 VGND VGND VPWR VPWR sky130_fd_sc_hd__decap_3
XFILLER_0_91_27 VGND VGND VPWR VPWR sky130_fd_sc_hd__fill_1
XFILLER_0_59_413 VPWR VGND VPWR VGND sky130_ef_sc_hd__decap_12
XFILLER_0_24_21 VGND VGND VPWR VPWR sky130_fd_sc_hd__fill_1
XFILLER_0_86_265 VGND VGND VPWR VPWR sky130_fd_sc_hd__decap_8
XFILLER_0_74_416 VGND VGND VPWR VPWR sky130_fd_sc_hd__fill_1
X_4870_ net152 _3777_ _3623_ _1839_ VGND VGND VPWR VPWR _0139_ sky130_fd_sc_hd__and4_1
XFILLER_0_27_332 VGND VGND VPWR VPWR sky130_fd_sc_hd__decap_4
X_6540_ _1958_ _1959_ _1800_ _1802_ VGND VGND VPWR VPWR _1962_ sky130_fd_sc_hd__o211a_1
XFILLER_0_40_20 VGND VGND VPWR VPWR sky130_fd_sc_hd__decap_8
XFILLER_0_39_181 VGND VGND VPWR VPWR sky130_fd_sc_hd__decap_3
XFILLER_0_6_248 VGND VGND VPWR VPWR sky130_fd_sc_hd__decap_4
XFILLER_0_15_505 VGND VGND VPWR VPWR sky130_fd_sc_hd__decap_8
X_6471_ _1750_ _1787_ _1788_ VGND VGND VPWR VPWR _1886_ sky130_fd_sc_hd__nor3_1
XTAP_TAPCELL_ROW_76_1107 VGND VPWR sky130_fd_sc_hd__tapvpwrvgnd_1
XFILLER_0_71_7 VGND VGND VPWR VPWR sky130_fd_sc_hd__fill_2
XFILLER_0_2_421 VGND VGND VPWR VPWR sky130_fd_sc_hd__fill_2
XFILLER_0_40_97 VPWR VGND VPWR VGND sky130_ef_sc_hd__decap_12
X_5422_ _3406_ _0739_ _0622_ VGND VGND VPWR VPWR _0740_ sky130_fd_sc_hd__or3_1
X_5353_ _0655_ _0663_ _0664_ VGND VGND VPWR VPWR _0665_ sky130_fd_sc_hd__and3_1
XFILLER_0_2_443 VGND VGND VPWR VPWR sky130_fd_sc_hd__fill_2
X_4304_ _3414_ VGND VGND VPWR VPWR _3415_ sky130_fd_sc_hd__inv_2
X_5284_ _0587_ _0588_ _0589_ VGND VGND VPWR VPWR _0590_ sky130_fd_sc_hd__and3_1
XFILLER_0_10_276 VPWR VGND VPWR VGND sky130_ef_sc_hd__decap_12
X_4235_ _3311_ _3319_ VGND VGND VPWR VPWR _3347_ sky130_fd_sc_hd__or2_1
X_7023_ _1214_ _2476_ _2486_ _2489_ VGND VGND VPWR VPWR _2490_ sky130_fd_sc_hd__a211o_1
X_4166_ _1588_ VGND VGND VPWR VPWR _3278_ sky130_fd_sc_hd__inv_2
XFILLER_0_4_53 VPWR VGND VPWR VGND sky130_ef_sc_hd__decap_12
XTAP_TAPCELL_ROW_87_1236 VGND VPWR sky130_fd_sc_hd__tapvpwrvgnd_1
X_4097_ _2802_ _2714_ VGND VGND VPWR VPWR _2813_ sky130_fd_sc_hd__or2_1
XFILLER_0_77_221 VGND VGND VPWR VPWR sky130_fd_sc_hd__decap_3
XFILLER_0_77_243 VGND VGND VPWR VPWR sky130_fd_sc_hd__fill_1
XFILLER_0_65_449 VGND VGND VPWR VPWR sky130_fd_sc_hd__decap_8
XTAP_TAPCELL_ROW_41_709 VGND VPWR sky130_fd_sc_hd__tapvpwrvgnd_1
X_6807_ _2251_ _2252_ VGND VGND VPWR VPWR _2253_ sky130_fd_sc_hd__xnor2_2
X_4999_ _3395_ _3322_ _3463_ VGND VGND VPWR VPWR _0280_ sky130_fd_sc_hd__o21ai_1
XFILLER_0_92_257 VGND VGND VPWR VPWR sky130_fd_sc_hd__fill_1
XFILLER_0_18_332 VPWR VGND VPWR VGND sky130_ef_sc_hd__decap_12
XFILLER_0_80_419 VGND VGND VPWR VPWR sky130_fd_sc_hd__fill_1
XFILLER_0_61_600 VPWR VGND VPWR VGND sky130_ef_sc_hd__decap_12
X_6738_ _2012_ _2176_ VGND VGND VPWR VPWR _2177_ sky130_fd_sc_hd__xnor2_1
XTAP_TAPCELL_ROW_21_477 VGND VPWR sky130_fd_sc_hd__tapvpwrvgnd_1
XFILLER_0_33_335 VGND VGND VPWR VPWR sky130_fd_sc_hd__fill_1
XFILLER_0_45_184 VGND VGND VPWR VPWR sky130_fd_sc_hd__decap_8
X_6669_ _1490_ _1577_ VGND VGND VPWR VPWR _2103_ sky130_fd_sc_hd__nand2_2
XFILLER_0_103_223 VGND VGND VPWR VPWR sky130_fd_sc_hd__fill_1
XTAP_TAPCELL_ROW_98_1365 VGND VPWR sky130_fd_sc_hd__tapvpwrvgnd_1
XFILLER_0_103_267 VGND VGND VPWR VPWR sky130_fd_sc_hd__decap_8
XTAP_TAPCELL_ROW_57_897 VGND VPWR sky130_fd_sc_hd__tapvpwrvgnd_1
XTAP_TAPCELL_ROW_29_566 VGND VPWR sky130_fd_sc_hd__tapvpwrvgnd_1
XTAP_TAPCELL_ROW_107_1472 VGND VPWR sky130_fd_sc_hd__tapvpwrvgnd_1
XFILLER_0_96_585 VGND VGND VPWR VPWR sky130_fd_sc_hd__decap_3
XFILLER_0_64_460 VPWR VGND VPWR VGND sky130_ef_sc_hd__decap_12
XFILLER_0_52_611 VPWR VGND VPWR VGND sky130_ef_sc_hd__decap_12
XFILLER_0_107_573 VPWR VGND VPWR VGND sky130_ef_sc_hd__decap_12
XFILLER_0_64_493 VPWR VGND VPWR VGND sky130_ef_sc_hd__decap_12
XFILLER_0_64_482 VGND VGND VPWR VPWR sky130_fd_sc_hd__decap_4
XFILLER_0_36_195 VGND VGND VPWR VPWR sky130_fd_sc_hd__fill_1
XFILLER_0_101_69 VGND VGND VPWR VPWR sky130_fd_sc_hd__decap_8
XFILLER_0_20_530 VGND VGND VPWR VPWR sky130_fd_sc_hd__fill_2
XTAP_TAPCELL_ROW_71_1048 VGND VPWR sky130_fd_sc_hd__tapvpwrvgnd_1
XFILLER_0_19_87 VGND VGND VPWR VPWR sky130_fd_sc_hd__fill_1
X_4020_ net34 VGND VGND VPWR VPWR _1971_ sky130_fd_sc_hd__inv_2
XFILLER_0_35_31 VPWR VGND VPWR VGND sky130_ef_sc_hd__decap_12
XFILLER_0_59_221 VGND VGND VPWR VPWR sky130_fd_sc_hd__decap_3
X_5971_ _1336_ _1338_ _1236_ VGND VGND VPWR VPWR _1340_ sky130_fd_sc_hd__o21a_1
X_7710_ _0953_ _3065_ VGND VGND VPWR VPWR _3240_ sky130_fd_sc_hd__or2_1
X_4922_ _3715_ _0195_ _3743_ VGND VGND VPWR VPWR _0196_ sky130_fd_sc_hd__mux2_1
XFILLER_0_59_254 VGND VGND VPWR VPWR sky130_fd_sc_hd__fill_2
XFILLER_0_59_232 VGND VGND VPWR VPWR sky130_fd_sc_hd__decap_4
X_7641_ _3333_ _0311_ _3002_ _3001_ VGND VGND VPWR VPWR _3166_ sky130_fd_sc_hd__a31o_1
XFILLER_0_47_416 VPWR VGND VPWR VGND sky130_ef_sc_hd__decap_12
XTAP_TAPCELL_ROW_82_1177 VGND VPWR sky130_fd_sc_hd__tapvpwrvgnd_1
X_4853_ _0038_ _0044_ VGND VGND VPWR VPWR _0120_ sky130_fd_sc_hd__nand2_1
X_7572_ _3320_ _0322_ _0072_ _3394_ VGND VGND VPWR VPWR _3090_ sky130_fd_sc_hd__a22o_1
XFILLER_0_62_419 VGND VGND VPWR VPWR sky130_fd_sc_hd__fill_1
XFILLER_0_7_557 VGND VGND VPWR VPWR sky130_fd_sc_hd__decap_3
X_4784_ _0038_ _0044_ VGND VGND VPWR VPWR _0045_ sky130_fd_sc_hd__xor2_1
X_6523_ _1782_ _1910_ _1941_ _1942_ VGND VGND VPWR VPWR _1943_ sky130_fd_sc_hd__a211o_1
XFILLER_0_42_121 VPWR VGND VPWR VGND sky130_ef_sc_hd__decap_12
XFILLER_0_15_346 VGND VGND VPWR VPWR sky130_fd_sc_hd__fill_2
X_6454_ _2069_ _1654_ _3268_ _0693_ VGND VGND VPWR VPWR _1867_ sky130_fd_sc_hd__a22o_1
X_5405_ _0386_ _3721_ _3443_ _0102_ _0721_ VGND VGND VPWR VPWR _0722_ sky130_fd_sc_hd__a41o_1
XFILLER_0_70_485 VPWR VGND VPWR VGND sky130_ef_sc_hd__decap_12
XFILLER_0_62_3 VPWR VGND VPWR VGND sky130_ef_sc_hd__decap_12
XFILLER_0_2_251 VGND VGND VPWR VPWR sky130_fd_sc_hd__fill_1
X_6385_ _1789_ _1790_ _1625_ _1725_ VGND VGND VPWR VPWR _1792_ sky130_fd_sc_hd__a211o_1
XFILLER_0_100_248 VGND VGND VPWR VPWR sky130_fd_sc_hd__decap_4
X_5336_ _0644_ _0645_ VGND VGND VPWR VPWR _0646_ sky130_fd_sc_hd__xnor2_1
X_5267_ _0568_ _0569_ _0549_ VGND VGND VPWR VPWR _0571_ sky130_fd_sc_hd__a21oi_1
X_4218_ _3329_ VGND VGND VPWR VPWR _3330_ sky130_fd_sc_hd__buf_4
X_7006_ _2469_ _2470_ VGND VGND VPWR VPWR _2471_ sky130_fd_sc_hd__or2_1
X_5198_ _0168_ _0270_ _0368_ _0495_ VGND VGND VPWR VPWR _0496_ sky130_fd_sc_hd__a31o_1
XFILLER_0_97_305 VGND VGND VPWR VPWR sky130_fd_sc_hd__decap_8
X_4149_ _1479_ _1501_ VGND VGND VPWR VPWR _3261_ sky130_fd_sc_hd__or2_1
XFILLER_0_97_349 VGND VGND VPWR VPWR sky130_fd_sc_hd__decap_8
XFILLER_0_78_530 VGND VGND VPWR VPWR sky130_fd_sc_hd__fill_2
XFILLER_0_78_552 VGND VGND VPWR VPWR sky130_fd_sc_hd__fill_2
XTAP_TAPCELL_ROW_26_536 VGND VPWR sky130_fd_sc_hd__tapvpwrvgnd_1
XTAP_TAPCELL_ROW_54_856 VGND VPWR sky130_fd_sc_hd__tapvpwrvgnd_1
XFILLER_0_19_641 VGND VGND VPWR VPWR sky130_fd_sc_hd__decap_8
XFILLER_0_93_588 VGND VGND VPWR VPWR sky130_fd_sc_hd__fill_1
XFILLER_0_80_216 VGND VGND VPWR VPWR sky130_fd_sc_hd__decap_4
XFILLER_0_80_227 VPWR VGND VPWR VGND sky130_ef_sc_hd__decap_12
XFILLER_0_18_195 VGND VGND VPWR VPWR sky130_fd_sc_hd__fill_1
Xwire115 _1420_ VGND VGND VPWR VPWR net115 sky130_fd_sc_hd__buf_1
XFILLER_0_33_143 VGND VGND VPWR VPWR sky130_fd_sc_hd__fill_1
XFILLER_0_14_390 VGND VGND VPWR VPWR sky130_fd_sc_hd__decap_3
XFILLER_0_21_349 VPWR VGND VPWR VGND sky130_ef_sc_hd__decap_12
XTAP_TAPCELL_ROW_109_1501 VGND VPWR sky130_fd_sc_hd__tapvpwrvgnd_1
XFILLER_0_84_522 VGND VGND VPWR VPWR sky130_fd_sc_hd__fill_1
XFILLER_0_69_596 VPWR VGND VPWR VGND sky130_ef_sc_hd__decap_12
XFILLER_0_84_533 VGND VGND VPWR VPWR sky130_fd_sc_hd__decap_4
XFILLER_0_25_600 VPWR VGND VPWR VGND sky130_ef_sc_hd__decap_12
XFILLER_0_44_408 VGND VGND VPWR VPWR sky130_fd_sc_hd__fill_1
XFILLER_0_44_419 VGND VGND VPWR VPWR sky130_fd_sc_hd__fill_1
XFILLER_0_71_249 VPWR VGND VPWR VGND sky130_ef_sc_hd__decap_12
XFILLER_0_21_55 VGND VGND VPWR VPWR sky130_fd_sc_hd__fill_1
XFILLER_0_52_430 VGND VGND VPWR VPWR sky130_fd_sc_hd__fill_1
XFILLER_0_52_452 VPWR VGND VPWR VGND sky130_ef_sc_hd__decap_12
XFILLER_0_20_360 VGND VGND VPWR VPWR sky130_fd_sc_hd__decap_4
X_6170_ _1548_ _1556_ VGND VGND VPWR VPWR _1557_ sky130_fd_sc_hd__xnor2_1
X_5121_ _3299_ _0411_ VGND VGND VPWR VPWR _0412_ sky130_fd_sc_hd__nand2_1
X_5052_ _0335_ _0336_ VGND VGND VPWR VPWR _0337_ sky130_fd_sc_hd__nor2_1
XFILLER_0_46_41 VPWR VGND VPWR VGND sky130_ef_sc_hd__decap_12
X_4003_ B[10] VGND VGND VPWR VPWR _1785_ sky130_fd_sc_hd__buf_2
XTAP_TAPCELL_ROW_84_1206 VGND VPWR sky130_fd_sc_hd__tapvpwrvgnd_1
X_5954_ _1318_ _1319_ _1310_ VGND VGND VPWR VPWR _1321_ sky130_fd_sc_hd__a21o_1
X_4905_ _1686_ _3277_ _0176_ VGND VGND VPWR VPWR _0177_ sky130_fd_sc_hd__or3_1
XTAP_TAPCELL_ROW_23_506 VGND VPWR sky130_fd_sc_hd__tapvpwrvgnd_1
X_5885_ _1239_ _1244_ VGND VGND VPWR VPWR _1245_ sky130_fd_sc_hd__and2_1
XTAP_TAPCELL_ROW_51_826 VGND VPWR sky130_fd_sc_hd__tapvpwrvgnd_1
X_4836_ _3396_ _3373_ VGND VGND VPWR VPWR _0102_ sky130_fd_sc_hd__nor2_1
X_7624_ _3145_ _3146_ VGND VGND VPWR VPWR _3147_ sky130_fd_sc_hd__xor2_1
XFILLER_0_47_268 VPWR VGND VPWR VGND sky130_ef_sc_hd__decap_12
X_7555_ _2997_ _3040_ VGND VGND VPWR VPWR _3071_ sky130_fd_sc_hd__and2b_1
XFILLER_0_7_365 VGND VGND VPWR VPWR sky130_fd_sc_hd__fill_2
X_4767_ _0026_ _0027_ VGND VGND VPWR VPWR _0028_ sky130_fd_sc_hd__nor2_1
X_6506_ _1922_ _1923_ VGND VGND VPWR VPWR _1924_ sky130_fd_sc_hd__xnor2_1
XTAP_TAPCELL_ROW_31_594 VGND VPWR sky130_fd_sc_hd__tapvpwrvgnd_1
XFILLER_0_31_603 VGND VGND VPWR VPWR sky130_fd_sc_hd__fill_2
XFILLER_0_43_441 VGND VGND VPWR VPWR sky130_fd_sc_hd__decap_6
XTAP_TAPCELL_ROW_95_1324 VGND VPWR sky130_fd_sc_hd__tapvpwrvgnd_1
X_4698_ _3643_ _3709_ _3797_ _3798_ _3801_ VGND VGND VPWR VPWR _3803_ sky130_fd_sc_hd__a221o_1
X_7486_ _2993_ _2995_ VGND VGND VPWR VPWR _2996_ sky130_fd_sc_hd__xnor2_1
X_6437_ _2572_ _1020_ VGND VGND VPWR VPWR _1848_ sky130_fd_sc_hd__nand2_1
X_6368_ _3448_ net15 _1260_ _3622_ VGND VGND VPWR VPWR _1773_ sky130_fd_sc_hd__a22oi_1
XFILLER_0_101_568 VGND VGND VPWR VPWR sky130_fd_sc_hd__fill_2
XFILLER_0_87_81 VPWR VGND VPWR VGND sky130_ef_sc_hd__decap_12
X_5319_ _0537_ _0538_ _0572_ _0574_ VGND VGND VPWR VPWR _0628_ sky130_fd_sc_hd__nand4_2
X_6299_ _1695_ _1696_ VGND VGND VPWR VPWR _1698_ sky130_fd_sc_hd__xor2_1
XTAP_TAPCELL_ROW_59_915 VGND VPWR sky130_fd_sc_hd__tapvpwrvgnd_1
XTAP_TAPCELL_ROW_3_275 VGND VPWR sky130_fd_sc_hd__tapvpwrvgnd_1
XFILLER_0_97_146 VGND VGND VPWR VPWR sky130_fd_sc_hd__fill_1
XTAP_TAPCELL_ROW_39_683 VGND VPWR sky130_fd_sc_hd__tapvpwrvgnd_1
XTAP_TAPCELL_ROW_104_1431 VGND VPWR sky130_fd_sc_hd__tapvpwrvgnd_1
XFILLER_0_109_613 VGND VGND VPWR VPWR sky130_fd_sc_hd__decap_3
XFILLER_0_66_533 VGND VGND VPWR VPWR sky130_fd_sc_hd__decap_8
XFILLER_0_26_419 VGND VGND VPWR VPWR sky130_fd_sc_hd__fill_1
XFILLER_0_108_178 VGND VGND VPWR VPWR sky130_fd_sc_hd__decap_4
XANTENNA_9 _3449_ VGND VGND VPWR VPWR sky130_fd_sc_hd__diode_2
XFILLER_0_104_373 VGND VGND VPWR VPWR sky130_fd_sc_hd__decap_3
XFILLER_0_104_362 VGND VGND VPWR VPWR sky130_fd_sc_hd__fill_2
XFILLER_0_107_57 VPWR VGND VPWR VGND sky130_ef_sc_hd__decap_12
XFILLER_0_88_102 VGND VGND VPWR VPWR sky130_fd_sc_hd__decap_4
XFILLER_0_16_66 VGND VGND VPWR VPWR sky130_fd_sc_hd__decap_8
XFILLER_0_69_393 VPWR VGND VPWR VGND sky130_ef_sc_hd__decap_12
XFILLER_0_8_107 VPWR VGND VPWR VGND sky130_ef_sc_hd__decap_12
XFILLER_0_84_341 VGND VGND VPWR VPWR sky130_fd_sc_hd__decap_6
XFILLER_0_32_65 VGND VGND VPWR VPWR sky130_fd_sc_hd__decap_4
X_5670_ _1006_ _1010_ VGND VGND VPWR VPWR _1011_ sky130_fd_sc_hd__xnor2_2
X_4621_ _3395_ _3722_ _3725_ VGND VGND VPWR VPWR _3727_ sky130_fd_sc_hd__a21o_1
XFILLER_0_84_396 VGND VGND VPWR VPWR sky130_fd_sc_hd__decap_8
XFILLER_0_72_547 VGND VGND VPWR VPWR sky130_fd_sc_hd__fill_2
X_4552_ _3340_ _3658_ VGND VGND VPWR VPWR _3659_ sky130_fd_sc_hd__nand2_1
X_7340_ _2598_ _2600_ _2834_ _2836_ VGND VGND VPWR VPWR _2837_ sky130_fd_sc_hd__o211a_1
X_4483_ _3529_ _3531_ _3588_ _3492_ VGND VGND VPWR VPWR _3591_ sky130_fd_sc_hd__o31a_1
X_7271_ _2759_ _2760_ VGND VGND VPWR VPWR _2761_ sky130_fd_sc_hd__nor2_1
X_6222_ _1467_ _1470_ _1469_ VGND VGND VPWR VPWR _1614_ sky130_fd_sc_hd__o21bai_1
XFILLER_0_40_477 VPWR VGND VPWR VGND sky130_ef_sc_hd__decap_12
XTAP_TAPCELL_ROW_90_1276 VGND VPWR sky130_fd_sc_hd__tapvpwrvgnd_1
X_6153_ net25 _2550_ net41 net40 VGND VGND VPWR VPWR _1538_ sky130_fd_sc_hd__and4_1
X_5104_ _1588_ _1861_ _0179_ _1905_ VGND VGND VPWR VPWR _0394_ sky130_fd_sc_hd__a31o_1
XFILLER_0_57_95 VGND VGND VPWR VPWR sky130_fd_sc_hd__decap_8
X_6084_ net32 net13 net8 net57 VGND VGND VPWR VPWR _1463_ sky130_fd_sc_hd__a22o_1
X_5035_ _0309_ _0317_ VGND VGND VPWR VPWR _0318_ sky130_fd_sc_hd__xnor2_1
XFILLER_0_79_113 VGND VGND VPWR VPWR sky130_fd_sc_hd__fill_2
XFILLER_0_25_3 VPWR VGND VPWR VGND sky130_ef_sc_hd__decap_12
XFILLER_0_79_157 VGND VGND VPWR VPWR sky130_fd_sc_hd__decap_8
XTAP_TAPCELL_ROW_0_223 VGND VPWR sky130_fd_sc_hd__tapvpwrvgnd_1
XTAP_TAPCELL_ROW_0_234 VGND VPWR sky130_fd_sc_hd__tapvpwrvgnd_1
XFILLER_0_95_617 VPWR VGND VPWR VGND sky130_ef_sc_hd__decap_12
XTAP_TAPCELL_ROW_36_653 VGND VPWR sky130_fd_sc_hd__tapvpwrvgnd_1
X_6986_ _2447_ _2448_ VGND VGND VPWR VPWR _2449_ sky130_fd_sc_hd__xnor2_1
XFILLER_0_94_127 VPWR VGND VPWR VGND sky130_ef_sc_hd__decap_12
XTAP_TAPCELL_ROW_64_973 VGND VPWR sky130_fd_sc_hd__tapvpwrvgnd_1
X_5937_ _1301_ _1300_ VGND VGND VPWR VPWR _1302_ sky130_fd_sc_hd__xnor2_2
XFILLER_0_48_533 VGND VGND VPWR VPWR sky130_fd_sc_hd__decap_3
XFILLER_0_63_503 VGND VGND VPWR VPWR sky130_fd_sc_hd__fill_1
X_7607_ _2895_ _2896_ _2893_ VGND VGND VPWR VPWR _3128_ sky130_fd_sc_hd__o21ai_1
XFILLER_0_90_333 VGND VGND VPWR VPWR sky130_fd_sc_hd__decap_6
X_5868_ _0011_ _1226_ VGND VGND VPWR VPWR _1227_ sky130_fd_sc_hd__nand2_1
XFILLER_0_63_536 VPWR VGND VPWR VGND sky130_ef_sc_hd__decap_12
X_4819_ _0002_ _0003_ _0080_ _0081_ VGND VGND VPWR VPWR _0084_ sky130_fd_sc_hd__a211o_4
XFILLER_0_7_162 VGND VGND VPWR VPWR sky130_fd_sc_hd__decap_3
X_5799_ _1012_ _1013_ _1014_ VGND VGND VPWR VPWR _1152_ sky130_fd_sc_hd__o21ba_1
XFILLER_0_35_249 VGND VGND VPWR VPWR sky130_fd_sc_hd__decap_8
X_7538_ _2877_ _3052_ VGND VGND VPWR VPWR _3053_ sky130_fd_sc_hd__xor2_1
XFILLER_0_16_474 VGND VGND VPWR VPWR sky130_fd_sc_hd__fill_2
X_7469_ _2975_ _2976_ VGND VGND VPWR VPWR _2978_ sky130_fd_sc_hd__xnor2_1
XFILLER_0_43_293 VGND VGND VPWR VPWR sky130_fd_sc_hd__decap_8
XFILLER_0_3_390 VGND VGND VPWR VPWR sky130_fd_sc_hd__fill_2
XFILLER_0_31_488 VPWR VGND VPWR VGND sky130_ef_sc_hd__decap_12
XTAP_TAPCELL_ROW_8_334 VGND VPWR sky130_fd_sc_hd__tapvpwrvgnd_1
XTAP_TAPCELL_ROW_8_323 VGND VPWR sky130_fd_sc_hd__tapvpwrvgnd_1
Xoutput68 net68 VGND VGND VPWR VPWR overflow sky130_fd_sc_hd__clkbuf_4
Xoutput79 net79 VGND VGND VPWR VPWR result[19] sky130_fd_sc_hd__clkbuf_4
XFILLER_0_98_400 VGND VGND VPWR VPWR sky130_fd_sc_hd__fill_1
XFILLER_0_98_477 VPWR VGND VPWR VGND sky130_ef_sc_hd__decap_12
XPHY_EDGE_ROW_19_Right_19 VGND VGND VPWR VPWR sky130_fd_sc_hd__decap_3
XFILLER_0_78_190 VGND VGND VPWR VPWR sky130_fd_sc_hd__decap_6
XFILLER_0_39_522 VGND VGND VPWR VPWR sky130_fd_sc_hd__decap_6
XFILLER_0_109_421 VGND VGND VPWR VPWR sky130_fd_sc_hd__decap_3
XFILLER_0_66_363 VGND VGND VPWR VPWR sky130_fd_sc_hd__fill_1
XFILLER_0_109_443 VGND VGND VPWR VPWR sky130_fd_sc_hd__decap_4
XFILLER_0_54_525 VGND VGND VPWR VPWR sky130_fd_sc_hd__decap_6
XFILLER_0_54_569 VPWR VGND VPWR VGND sky130_ef_sc_hd__decap_12
XFILLER_0_22_477 VGND VGND VPWR VPWR sky130_fd_sc_hd__decap_4
XPHY_EDGE_ROW_28_Right_28 VGND VGND VPWR VPWR sky130_fd_sc_hd__decap_3
XFILLER_0_94_27 VGND VGND VPWR VPWR sky130_fd_sc_hd__fill_1
XFILLER_0_89_422 VGND VGND VPWR VPWR sky130_fd_sc_hd__decap_4
XFILLER_0_89_466 VGND VGND VPWR VPWR sky130_fd_sc_hd__decap_4
XPHY_EDGE_ROW_37_Right_37 VGND VGND VPWR VPWR sky130_fd_sc_hd__decap_3
XFILLER_0_77_617 VGND VGND VPWR VPWR sky130_fd_sc_hd__decap_8
X_6840_ _2286_ _2287_ _2183_ VGND VGND VPWR VPWR _2290_ sky130_fd_sc_hd__o21ai_2
XFILLER_0_76_149 VGND VGND VPWR VPWR sky130_fd_sc_hd__decap_3
XFILLER_0_69_190 VPWR VGND VPWR VGND sky130_ef_sc_hd__decap_12
XTAP_TAPCELL_ROW_33_612 VGND VPWR sky130_fd_sc_hd__tapvpwrvgnd_1
X_6771_ _2205_ _2213_ VGND VGND VPWR VPWR _2214_ sky130_fd_sc_hd__xnor2_1
XFILLER_0_92_609 VGND VGND VPWR VPWR sky130_fd_sc_hd__fill_1
XTAP_TAPCELL_ROW_61_943 VGND VPWR sky130_fd_sc_hd__tapvpwrvgnd_1
X_3983_ _1555_ VGND VGND VPWR VPWR _1566_ sky130_fd_sc_hd__buf_4
X_5722_ _1065_ _1066_ _0919_ _0935_ VGND VGND VPWR VPWR _1068_ sky130_fd_sc_hd__a211oi_2
XFILLER_0_84_171 VGND VGND VPWR VPWR sky130_fd_sc_hd__fill_1
XFILLER_0_17_249 VPWR VGND VPWR VGND sky130_ef_sc_hd__decap_12
X_5653_ _0988_ _0991_ VGND VGND VPWR VPWR _0992_ sky130_fd_sc_hd__xnor2_1
XTAP_TAPCELL_ROW_79_1149 VGND VPWR sky130_fd_sc_hd__tapvpwrvgnd_1
X_4604_ _3643_ _3709_ VGND VGND VPWR VPWR _3710_ sky130_fd_sc_hd__nand2_1
XFILLER_0_72_377 VPWR VGND VPWR VGND sky130_ef_sc_hd__decap_12
X_5584_ _0880_ _0881_ _0915_ _0916_ VGND VGND VPWR VPWR _0917_ sky130_fd_sc_hd__or4_4
XTAP_TAPCELL_ROW_13_391 VGND VPWR sky130_fd_sc_hd__tapvpwrvgnd_1
XPHY_EDGE_ROW_46_Right_46 VGND VGND VPWR VPWR sky130_fd_sc_hd__decap_3
XFILLER_0_102_107 VGND VGND VPWR VPWR sky130_fd_sc_hd__decap_4
X_4535_ _3618_ _3590_ _3641_ VGND VGND VPWR VPWR _3642_ sky130_fd_sc_hd__and3b_1
X_7323_ _2564_ _2567_ _2565_ VGND VGND VPWR VPWR _2818_ sky130_fd_sc_hd__o21ba_1
XFILLER_0_25_293 VPWR VGND VPWR VGND sky130_ef_sc_hd__decap_12
XFILLER_0_40_241 VGND VGND VPWR VPWR sky130_fd_sc_hd__decap_4
X_7254_ _1544_ _1173_ VGND VGND VPWR VPWR _2742_ sky130_fd_sc_hd__nand2_1
X_4466_ _3032_ _2911_ VGND VGND VPWR VPWR _3574_ sky130_fd_sc_hd__and2_1
X_7185_ _3597_ _2148_ _2663_ _2666_ VGND VGND VPWR VPWR _2667_ sky130_fd_sc_hd__a211o_1
X_4397_ _3501_ _3505_ VGND VGND VPWR VPWR _3507_ sky130_fd_sc_hd__or2_1
XFILLER_0_68_83 VGND VGND VPWR VPWR sky130_fd_sc_hd__fill_1
X_6205_ _1457_ _1719_ _1593_ _1594_ VGND VGND VPWR VPWR _1595_ sky130_fd_sc_hd__a22o_1
X_6136_ _1140_ _1519_ _0596_ VGND VGND VPWR VPWR _1520_ sky130_fd_sc_hd__a21oi_1
XFILLER_0_0_393 VGND VGND VPWR VPWR sky130_fd_sc_hd__decap_3
XPHY_EDGE_ROW_55_Right_55 VGND VGND VPWR VPWR sky130_fd_sc_hd__decap_3
X_6067_ _1442_ _1443_ VGND VGND VPWR VPWR _1444_ sky130_fd_sc_hd__xnor2_1
X_5018_ _3737_ _3749_ _0298_ _3274_ _3273_ VGND VGND VPWR VPWR _0299_ sky130_fd_sc_hd__a2111o_1
XFILLER_0_95_414 VPWR VGND VPWR VGND sky130_ef_sc_hd__decap_12
XFILLER_0_95_447 VGND VGND VPWR VPWR sky130_fd_sc_hd__fill_1
XTAP_TAPCELL_ROW_101_1401 VGND VPWR sky130_fd_sc_hd__tapvpwrvgnd_1
X_6969_ _2427_ _2428_ _2391_ _2392_ VGND VGND VPWR VPWR _2431_ sky130_fd_sc_hd__o211a_1
XFILLER_0_75_193 VPWR VGND VPWR VGND sky130_ef_sc_hd__decap_12
XPHY_EDGE_ROW_64_Right_64 VGND VGND VPWR VPWR sky130_fd_sc_hd__decap_3
XFILLER_0_63_344 VPWR VGND VPWR VGND sky130_ef_sc_hd__decap_12
XFILLER_0_63_388 VGND VGND VPWR VPWR sky130_fd_sc_hd__decap_4
XFILLER_0_51_517 VPWR VGND VPWR VGND sky130_ef_sc_hd__decap_12
XFILLER_0_16_282 VGND VGND VPWR VPWR sky130_fd_sc_hd__fill_1
XFILLER_0_101_173 VGND VGND VPWR VPWR sky130_fd_sc_hd__fill_1
XPHY_EDGE_ROW_73_Right_73 VGND VGND VPWR VPWR sky130_fd_sc_hd__decap_3
XFILLER_0_59_617 VPWR VGND VPWR VGND sky130_ef_sc_hd__decap_12
XPHY_EDGE_ROW_82_Right_82 VGND VGND VPWR VPWR sky130_fd_sc_hd__decap_3
XFILLER_0_39_385 VGND VGND VPWR VPWR sky130_fd_sc_hd__decap_6
XFILLER_0_27_547 VGND VGND VPWR VPWR sky130_fd_sc_hd__fill_1
XFILLER_0_54_377 VPWR VGND VPWR VGND sky130_ef_sc_hd__decap_12
XFILLER_0_81_185 VGND VGND VPWR VPWR sky130_fd_sc_hd__decap_6
XTAP_TAPCELL_ROW_10_350 VGND VPWR sky130_fd_sc_hd__tapvpwrvgnd_1
XFILLER_0_54_399 VPWR VGND VPWR VGND sky130_ef_sc_hd__decap_12
XFILLER_0_1_113 VPWR VGND VPWR VGND sky130_ef_sc_hd__decap_12
XFILLER_0_2_625 VPWR VGND VPWR VGND sky130_ef_sc_hd__decap_12
X_4320_ _3306_ net23 VGND VGND VPWR VPWR _3431_ sky130_fd_sc_hd__and2_1
XFILLER_0_22_285 VPWR VGND VPWR VGND sky130_ef_sc_hd__decap_12
XFILLER_0_50_572 VPWR VGND VPWR VGND sky130_ef_sc_hd__decap_12
X_4251_ _3354_ _0039_ _3294_ VGND VGND VPWR VPWR _3363_ sky130_fd_sc_hd__nor3_1
XPHY_EDGE_ROW_91_Right_91 VGND VGND VPWR VPWR sky130_fd_sc_hd__decap_3
X_4182_ net64 net63 VGND VGND VPWR VPWR _3294_ sky130_fd_sc_hd__or2b_1
XFILLER_0_38_97 VPWR VGND VPWR VGND sky130_ef_sc_hd__decap_12
XFILLER_0_49_105 VGND VGND VPWR VPWR sky130_fd_sc_hd__decap_6
XTAP_TAPCELL_ROW_46_770 VGND VPWR sky130_fd_sc_hd__tapvpwrvgnd_1
X_6823_ _1675_ _0802_ VGND VGND VPWR VPWR _2271_ sky130_fd_sc_hd__nand2_1
XFILLER_0_70_62 VGND VGND VPWR VPWR sky130_fd_sc_hd__fill_1
X_6754_ _3449_ _3623_ net18 net14 VGND VGND VPWR VPWR _2195_ sky130_fd_sc_hd__and4_1
X_3966_ net4 VGND VGND VPWR VPWR _1381_ sky130_fd_sc_hd__buf_4
XFILLER_0_9_279 VGND VGND VPWR VPWR sky130_fd_sc_hd__fill_1
X_5705_ _1046_ _1045_ _1047_ VGND VGND VPWR VPWR _1049_ sky130_fd_sc_hd__a21o_1
X_6685_ _1943_ _1945_ _2118_ _2119_ VGND VGND VPWR VPWR _2120_ sky130_fd_sc_hd__a211o_4
X_3897_ _0606_ _0617_ VGND VGND VPWR VPWR _0627_ sky130_fd_sc_hd__nand2_1
X_5636_ _0958_ _0959_ _0973_ VGND VGND VPWR VPWR _0974_ sky130_fd_sc_hd__o21a_1
XFILLER_0_72_141 VPWR VGND VPWR VGND sky130_ef_sc_hd__decap_12
XFILLER_0_33_517 VGND VGND VPWR VPWR sky130_fd_sc_hd__fill_1
XFILLER_0_60_336 VGND VGND VPWR VPWR sky130_fd_sc_hd__fill_1
XFILLER_0_103_449 VPWR VGND VPWR VGND sky130_ef_sc_hd__decap_12
X_5567_ _3021_ _0660_ VGND VGND VPWR VPWR _0898_ sky130_fd_sc_hd__nand2_1
X_7306_ _2756_ _2798_ VGND VGND VPWR VPWR _2799_ sky130_fd_sc_hd__xnor2_1
X_4518_ _3620_ _3624_ VGND VGND VPWR VPWR _3625_ sky130_fd_sc_hd__or2_4
X_5498_ _0821_ _0822_ VGND VGND VPWR VPWR _0823_ sky130_fd_sc_hd__and2b_1
X_4449_ _3405_ VGND VGND VPWR VPWR _3558_ sky130_fd_sc_hd__inv_2
X_7237_ _2509_ _2716_ _2721_ VGND VGND VPWR VPWR _2723_ sky130_fd_sc_hd__or3_1
X_7168_ _2456_ _2459_ VGND VGND VPWR VPWR _2648_ sky130_fd_sc_hd__or2b_1
X_7099_ _3269_ _1031_ VGND VGND VPWR VPWR _2573_ sky130_fd_sc_hd__nand2_1
X_6119_ _1386_ _1500_ VGND VGND VPWR VPWR _1502_ sky130_fd_sc_hd__xor2_1
XFILLER_0_64_631 VPWR VGND VPWR VGND sky130_ef_sc_hd__decap_12
XFILLER_0_91_461 VPWR VGND VPWR VGND sky130_ef_sc_hd__decap_12
XFILLER_0_36_377 VGND VGND VPWR VPWR sky130_fd_sc_hd__fill_1
XFILLER_0_36_388 VPWR VGND VPWR VGND sky130_ef_sc_hd__decap_12
XFILLER_0_106_265 VGND VGND VPWR VPWR sky130_fd_sc_hd__fill_1
XFILLER_0_32_561 VGND VGND VPWR VPWR sky130_fd_sc_hd__fill_2
XFILLER_0_51_369 VGND VGND VPWR VPWR sky130_fd_sc_hd__fill_1
XFILLER_0_102_460 VPWR VGND VPWR VGND sky130_ef_sc_hd__decap_12
XFILLER_0_99_561 VPWR VGND VPWR VGND sky130_ef_sc_hd__decap_12
XFILLER_0_86_200 VGND VGND VPWR VPWR sky130_fd_sc_hd__decap_8
XFILLER_0_59_447 VGND VGND VPWR VPWR sky130_fd_sc_hd__fill_1
XFILLER_0_59_425 VPWR VGND VPWR VGND sky130_ef_sc_hd__decap_12
XFILLER_0_55_620 VPWR VGND VPWR VGND sky130_ef_sc_hd__decap_12
XFILLER_0_67_491 VPWR VGND VPWR VGND sky130_ef_sc_hd__decap_12
XFILLER_0_40_54 VPWR VGND VPWR VGND sky130_ef_sc_hd__decap_12
XFILLER_0_54_141 VGND VGND VPWR VPWR sky130_fd_sc_hd__decap_4
XFILLER_0_54_163 VPWR VGND VPWR VGND sky130_ef_sc_hd__decap_12
XFILLER_0_70_645 VGND VGND VPWR VPWR sky130_fd_sc_hd__decap_6
X_6470_ _1881_ _1882_ _1844_ _1845_ VGND VGND VPWR VPWR _1885_ sky130_fd_sc_hd__o211a_1
XTAP_TAPCELL_ROW_76_1108 VGND VPWR sky130_fd_sc_hd__tapvpwrvgnd_1
X_5421_ _0704_ VGND VGND VPWR VPWR _0739_ sky130_fd_sc_hd__inv_2
X_5352_ _0661_ _0662_ _0656_ VGND VGND VPWR VPWR _0664_ sky130_fd_sc_hd__a21o_1
XFILLER_0_23_561 VPWR VGND VPWR VGND sky130_ef_sc_hd__decap_12
XFILLER_0_10_233 VGND VGND VPWR VPWR sky130_fd_sc_hd__decap_3
X_4303_ _3097_ VGND VGND VPWR VPWR _3414_ sky130_fd_sc_hd__buf_4
X_7022_ _0518_ _2487_ _2488_ VGND VGND VPWR VPWR _2489_ sky130_fd_sc_hd__o21a_1
X_5283_ _0492_ _0586_ VGND VGND VPWR VPWR _0589_ sky130_fd_sc_hd__nand2_1
X_4234_ _3330_ _3345_ VGND VGND VPWR VPWR _3346_ sky130_fd_sc_hd__nand2_1
XFILLER_0_10_288 VPWR VGND VPWR VGND sky130_ef_sc_hd__decap_12
X_4165_ _3275_ _3276_ VGND VGND VPWR VPWR _3277_ sky130_fd_sc_hd__nand2_2
XFILLER_0_4_65 VPWR VGND VPWR VGND sky130_ef_sc_hd__decap_12
XTAP_TAPCELL_ROW_87_1237 VGND VPWR sky130_fd_sc_hd__tapvpwrvgnd_1
X_4096_ _2681_ VGND VGND VPWR VPWR _2802_ sky130_fd_sc_hd__clkbuf_4
XFILLER_0_81_50 VGND VGND VPWR VPWR sky130_fd_sc_hd__decap_6
XFILLER_0_65_428 VGND VGND VPWR VPWR sky130_fd_sc_hd__fill_1
X_6806_ _2933_ net46 VGND VGND VPWR VPWR _2252_ sky130_fd_sc_hd__nand2_1
XFILLER_0_18_344 VPWR VGND VPWR VGND sky130_ef_sc_hd__decap_12
X_4998_ _1566_ _1523_ VGND VGND VPWR VPWR _0278_ sky130_fd_sc_hd__nand2_4
XFILLER_0_61_612 VGND VGND VPWR VPWR sky130_fd_sc_hd__decap_4
X_6737_ _2164_ _2175_ VGND VGND VPWR VPWR _2176_ sky130_fd_sc_hd__xor2_1
X_3949_ net40 VGND VGND VPWR VPWR _1195_ sky130_fd_sc_hd__buf_2
XTAP_TAPCELL_ROW_21_478 VGND VPWR sky130_fd_sc_hd__tapvpwrvgnd_1
X_6668_ _3255_ _0413_ _2100_ VGND VGND VPWR VPWR _2101_ sky130_fd_sc_hd__o21a_1
XTAP_TAPCELL_ROW_98_1366 VGND VPWR sky130_fd_sc_hd__tapvpwrvgnd_1
X_5619_ _2135_ _0593_ _0747_ _2113_ VGND VGND VPWR VPWR _0956_ sky130_fd_sc_hd__o211a_1
X_6599_ _2922_ _2572_ net45 net44 VGND VGND VPWR VPWR _2026_ sky130_fd_sc_hd__and4_1
XFILLER_0_5_293 VPWR VGND VPWR VGND sky130_ef_sc_hd__decap_12
XTAP_TAPCELL_ROW_57_887 VGND VPWR sky130_fd_sc_hd__tapvpwrvgnd_1
XTAP_TAPCELL_ROW_29_567 VGND VPWR sky130_fd_sc_hd__tapvpwrvgnd_1
XTAP_TAPCELL_ROW_107_1462 VGND VPWR sky130_fd_sc_hd__tapvpwrvgnd_1
XFILLER_0_68_233 VGND VGND VPWR VPWR sky130_fd_sc_hd__decap_4
XFILLER_0_96_597 VGND VGND VPWR VPWR sky130_fd_sc_hd__fill_2
XFILLER_0_83_225 VGND VGND VPWR VPWR sky130_fd_sc_hd__decap_4
XFILLER_0_28_108 VPWR VGND VPWR VGND sky130_ef_sc_hd__decap_12
XFILLER_0_49_491 VPWR VGND VPWR VGND sky130_ef_sc_hd__decap_12
XFILLER_0_64_472 VGND VGND VPWR VPWR sky130_fd_sc_hd__decap_4
XFILLER_0_36_141 VGND VGND VPWR VPWR sky130_fd_sc_hd__decap_4
XFILLER_0_101_15 VPWR VGND VPWR VGND sky130_ef_sc_hd__decap_12
XFILLER_0_51_111 VGND VGND VPWR VPWR sky130_fd_sc_hd__fill_1
XFILLER_0_52_623 VPWR VGND VPWR VGND sky130_ef_sc_hd__decap_12
XFILLER_0_52_645 VGND VGND VPWR VPWR sky130_fd_sc_hd__decap_6
XFILLER_0_107_585 VPWR VGND VPWR VGND sky130_ef_sc_hd__decap_12
XPHY_EDGE_ROW_108_Right_108 VGND VGND VPWR VPWR sky130_fd_sc_hd__decap_3
XFILLER_0_51_166 VGND VGND VPWR VPWR sky130_fd_sc_hd__fill_2
XTAP_TAPCELL_ROW_71_1049 VGND VPWR sky130_fd_sc_hd__tapvpwrvgnd_1
XFILLER_0_35_43 VPWR VGND VPWR VGND sky130_ef_sc_hd__decap_12
X_5970_ _1236_ _1336_ _1338_ VGND VGND VPWR VPWR _1339_ sky130_fd_sc_hd__nor3_1
X_4921_ _0012_ _0194_ _3482_ VGND VGND VPWR VPWR _0195_ sky130_fd_sc_hd__mux2_1
XFILLER_0_87_542 VGND VGND VPWR VPWR sky130_fd_sc_hd__decap_8
X_7640_ _2951_ _2991_ _2989_ VGND VGND VPWR VPWR _3165_ sky130_fd_sc_hd__o21a_1
XFILLER_0_47_428 VPWR VGND VPWR VGND sky130_ef_sc_hd__decap_12
X_4852_ _0035_ _0069_ _0070_ VGND VGND VPWR VPWR _0119_ sky130_fd_sc_hd__and3_1
XTAP_TAPCELL_ROW_82_1178 VGND VPWR sky130_fd_sc_hd__tapvpwrvgnd_1
XFILLER_0_74_258 VGND VGND VPWR VPWR sky130_fd_sc_hd__fill_1
XFILLER_0_7_503 VGND VGND VPWR VPWR sky130_fd_sc_hd__fill_1
X_7571_ _2364_ _2517_ _0148_ _0192_ VGND VGND VPWR VPWR _3089_ sky130_fd_sc_hd__and4_1
XFILLER_0_74_269 VGND VGND VPWR VPWR sky130_fd_sc_hd__fill_2
XFILLER_0_55_461 VGND VGND VPWR VPWR sky130_fd_sc_hd__decap_8
XFILLER_0_27_130 VGND VGND VPWR VPWR sky130_fd_sc_hd__decap_4
X_4783_ _0042_ _0043_ VGND VGND VPWR VPWR _0044_ sky130_fd_sc_hd__xnor2_1
XFILLER_0_43_612 VGND VGND VPWR VPWR sky130_fd_sc_hd__decap_4
XFILLER_0_55_472 VPWR VGND VPWR VGND sky130_ef_sc_hd__decap_12
X_6522_ _1930_ _1929_ _1940_ VGND VGND VPWR VPWR _1942_ sky130_fd_sc_hd__a21oi_2
XFILLER_0_70_464 VPWR VGND VPWR VGND sky130_ef_sc_hd__decap_12
XFILLER_0_15_358 VGND VGND VPWR VPWR sky130_fd_sc_hd__decap_6
X_6453_ _2386_ _0791_ VGND VGND VPWR VPWR _1866_ sky130_fd_sc_hd__nand2_1
XFILLER_0_42_133 VGND VGND VPWR VPWR sky130_fd_sc_hd__decap_6
X_5404_ _0717_ _0720_ VGND VGND VPWR VPWR _0721_ sky130_fd_sc_hd__nand2_1
XFILLER_0_70_497 VPWR VGND VPWR VGND sky130_ef_sc_hd__decap_12
X_6384_ net123 net114 _1789_ _1790_ VGND VGND VPWR VPWR _1791_ sky130_fd_sc_hd__o211ai_4
XPHY_EDGE_ROW_10_Left_120 VGND VGND VPWR VPWR sky130_fd_sc_hd__decap_3
X_5335_ _0526_ _0528_ _0527_ VGND VGND VPWR VPWR _0645_ sky130_fd_sc_hd__o21ba_1
XFILLER_0_11_586 VGND VGND VPWR VPWR sky130_fd_sc_hd__fill_1
X_5266_ _0549_ _0568_ _0569_ VGND VGND VPWR VPWR _0570_ sky130_fd_sc_hd__and3_1
X_7005_ _2295_ _2467_ _2468_ VGND VGND VPWR VPWR _2470_ sky130_fd_sc_hd__nor3_1
X_4217_ _3328_ VGND VGND VPWR VPWR _3329_ sky130_fd_sc_hd__clkbuf_4
X_5197_ _0267_ _0364_ _0365_ VGND VGND VPWR VPWR _0495_ sky130_fd_sc_hd__and3b_1
X_4148_ _1468_ _1501_ VGND VGND VPWR VPWR _3260_ sky130_fd_sc_hd__nand2_4
X_4079_ _2605_ VGND VGND VPWR VPWR _2616_ sky130_fd_sc_hd__buf_6
XTAP_TAPCELL_ROW_26_537 VGND VPWR sky130_fd_sc_hd__tapvpwrvgnd_1
XTAP_TAPCELL_ROW_54_857 VGND VPWR sky130_fd_sc_hd__tapvpwrvgnd_1
XFILLER_0_18_141 VPWR VGND VPWR VGND sky130_ef_sc_hd__decap_12
Xwire116 net151 VGND VGND VPWR VPWR net116 sky130_fd_sc_hd__buf_1
XFILLER_0_80_239 VPWR VGND VPWR VGND sky130_ef_sc_hd__decap_12
XFILLER_0_33_111 VGND VGND VPWR VPWR sky130_fd_sc_hd__fill_1
XFILLER_0_34_634 VGND VGND VPWR VPWR sky130_fd_sc_hd__decap_8
XFILLER_0_34_645 VGND VGND VPWR VPWR sky130_fd_sc_hd__decap_6
XFILLER_0_61_431 VGND VGND VPWR VPWR sky130_fd_sc_hd__decap_8
XFILLER_0_104_533 VGND VGND VPWR VPWR sky130_fd_sc_hd__decap_3
XTAP_TAPCELL_ROW_109_1502 VGND VPWR sky130_fd_sc_hd__tapvpwrvgnd_1
XFILLER_0_88_306 VGND VGND VPWR VPWR sky130_fd_sc_hd__fill_2
XFILLER_0_72_19 VGND VGND VPWR VPWR sky130_fd_sc_hd__decap_8
XFILLER_0_84_501 VGND VGND VPWR VPWR sky130_fd_sc_hd__decap_8
XFILLER_0_29_428 VGND VGND VPWR VPWR sky130_fd_sc_hd__fill_1
XFILLER_0_29_439 VGND VGND VPWR VPWR sky130_fd_sc_hd__decap_3
XFILLER_0_84_589 VGND VGND VPWR VPWR sky130_fd_sc_hd__fill_2
XFILLER_0_37_461 VPWR VGND VPWR VGND sky130_ef_sc_hd__decap_12
XFILLER_0_25_612 VGND VGND VPWR VPWR sky130_fd_sc_hd__decap_4
XFILLER_0_107_371 VGND VGND VPWR VPWR sky130_fd_sc_hd__decap_8
XFILLER_0_21_67 VPWR VGND VPWR VGND sky130_ef_sc_hd__decap_12
XFILLER_0_107_393 VGND VGND VPWR VPWR sky130_fd_sc_hd__decap_4
XFILLER_0_52_464 VPWR VGND VPWR VGND sky130_ef_sc_hd__decap_12
X_5120_ _0390_ _0402_ _3433_ _0410_ VGND VGND VPWR VPWR _0411_ sky130_fd_sc_hd__a31o_1
X_5051_ net152 _1938_ net129 _2616_ VGND VGND VPWR VPWR _0336_ sky130_fd_sc_hd__a22oi_2
X_4002_ _1708_ _1752_ _1763_ VGND VGND VPWR VPWR _1774_ sky130_fd_sc_hd__a21o_1
XFILLER_0_46_20 VGND VGND VPWR VPWR sky130_fd_sc_hd__decap_8
XFILLER_0_46_53 VGND VGND VPWR VPWR sky130_fd_sc_hd__decap_8
XFILLER_0_46_75 VGND VGND VPWR VPWR sky130_fd_sc_hd__decap_6
XTAP_TAPCELL_ROW_84_1207 VGND VPWR sky130_fd_sc_hd__tapvpwrvgnd_1
XFILLER_0_94_309 VGND VGND VPWR VPWR sky130_fd_sc_hd__decap_6
XFILLER_0_1_55 VGND VGND VPWR VPWR sky130_fd_sc_hd__fill_1
XFILLER_0_62_41 VPWR VGND VPWR VGND sky130_ef_sc_hd__decap_12
X_5953_ _1310_ _1318_ _1319_ VGND VGND VPWR VPWR _1320_ sky130_fd_sc_hd__nand3_1
X_4904_ _1763_ _0091_ VGND VGND VPWR VPWR _0176_ sky130_fd_sc_hd__nor2_1
XFILLER_0_62_85 VPWR VGND VPWR VGND sky130_ef_sc_hd__decap_12
X_5884_ _1242_ _1243_ VGND VGND VPWR VPWR _1244_ sky130_fd_sc_hd__xnor2_1
XFILLER_0_47_225 VGND VGND VPWR VPWR sky130_fd_sc_hd__fill_2
XTAP_TAPCELL_ROW_51_827 VGND VPWR sky130_fd_sc_hd__tapvpwrvgnd_1
X_4835_ _3299_ _0100_ VGND VGND VPWR VPWR _0101_ sky130_fd_sc_hd__nand2_1
X_7623_ _2091_ _0682_ VGND VGND VPWR VPWR _3146_ sky130_fd_sc_hd__nand2_1
XFILLER_0_16_601 VPWR VGND VPWR VGND sky130_ef_sc_hd__decap_12
X_4766_ _3273_ _3737_ _3749_ _3651_ VGND VGND VPWR VPWR _0027_ sky130_fd_sc_hd__a31o_1
X_7554_ _2998_ _3039_ VGND VGND VPWR VPWR _3070_ sky130_fd_sc_hd__and2b_1
XFILLER_0_62_239 VGND VGND VPWR VPWR sky130_fd_sc_hd__fill_2
XFILLER_0_15_133 VGND VGND VPWR VPWR sky130_fd_sc_hd__decap_8
XFILLER_0_16_645 VGND VGND VPWR VPWR sky130_fd_sc_hd__decap_3
X_6505_ _2692_ _1260_ VGND VGND VPWR VPWR _1923_ sky130_fd_sc_hd__nand2_1
XTAP_TAPCELL_ROW_31_595 VGND VPWR sky130_fd_sc_hd__tapvpwrvgnd_1
XTAP_TAPCELL_ROW_95_1325 VGND VPWR sky130_fd_sc_hd__tapvpwrvgnd_1
X_4697_ _3801_ _3797_ _3798_ VGND VGND VPWR VPWR _3802_ sky130_fd_sc_hd__nand3_1
X_7485_ _2756_ _2798_ _2994_ VGND VGND VPWR VPWR _2995_ sky130_fd_sc_hd__o21ai_1
XFILLER_0_31_615 VGND VGND VPWR VPWR sky130_fd_sc_hd__fill_1
XFILLER_0_30_114 VGND VGND VPWR VPWR sky130_fd_sc_hd__fill_1
X_6436_ _2671_ _1293_ _1206_ _2485_ VGND VGND VPWR VPWR _1847_ sky130_fd_sc_hd__a22oi_2
X_6367_ _1769_ _1768_ _1770_ VGND VGND VPWR VPWR _1772_ sky130_fd_sc_hd__a21o_1
XFILLER_0_11_350 VGND VGND VPWR VPWR sky130_fd_sc_hd__fill_1
XFILLER_0_87_93 VPWR VGND VPWR VGND sky130_ef_sc_hd__decap_12
XFILLER_0_11_361 VGND VGND VPWR VPWR sky130_fd_sc_hd__decap_8
X_5318_ _0624_ _0625_ VGND VGND VPWR VPWR _0626_ sky130_fd_sc_hd__nor2_1
X_6298_ _3163_ _1020_ _1539_ _1538_ VGND VGND VPWR VPWR _1696_ sky130_fd_sc_hd__a31o_1
XTAP_TAPCELL_ROW_59_916 VGND VPWR sky130_fd_sc_hd__tapvpwrvgnd_1
X_5249_ net155 net142 net5 VGND VGND VPWR VPWR _0552_ sky130_fd_sc_hd__and3_1
XFILLER_0_98_604 VPWR VGND VPWR VGND sky130_ef_sc_hd__decap_12
XFILLER_0_97_125 VGND VGND VPWR VPWR sky130_fd_sc_hd__decap_8
XTAP_TAPCELL_ROW_3_276 VGND VPWR sky130_fd_sc_hd__tapvpwrvgnd_1
XFILLER_0_97_158 VGND VGND VPWR VPWR sky130_fd_sc_hd__decap_8
XTAP_TAPCELL_ROW_39_684 VGND VPWR sky130_fd_sc_hd__tapvpwrvgnd_1
XTAP_TAPCELL_ROW_104_1432 VGND VPWR sky130_fd_sc_hd__tapvpwrvgnd_1
XFILLER_0_78_361 VGND VGND VPWR VPWR sky130_fd_sc_hd__decap_3
XFILLER_0_66_501 VGND VGND VPWR VPWR sky130_fd_sc_hd__decap_3
XFILLER_0_93_320 VPWR VGND VPWR VGND sky130_ef_sc_hd__decap_12
XFILLER_0_38_214 VGND VGND VPWR VPWR sky130_fd_sc_hd__fill_2
XFILLER_0_38_247 VGND VGND VPWR VPWR sky130_fd_sc_hd__decap_4
XFILLER_0_66_589 VPWR VGND VPWR VGND sky130_ef_sc_hd__decap_12
XFILLER_0_93_397 VGND VGND VPWR VPWR sky130_fd_sc_hd__fill_1
XFILLER_0_19_461 VGND VGND VPWR VPWR sky130_fd_sc_hd__decap_8
XFILLER_0_108_168 VGND VGND VPWR VPWR sky130_fd_sc_hd__fill_1
XFILLER_0_61_261 VPWR VGND VPWR VGND sky130_ef_sc_hd__decap_12
XFILLER_0_21_103 VGND VGND VPWR VPWR sky130_fd_sc_hd__decap_8
XFILLER_0_22_604 VGND VGND VPWR VPWR sky130_fd_sc_hd__fill_1
XFILLER_0_34_464 VPWR VGND VPWR VGND sky130_ef_sc_hd__decap_12
XFILLER_0_21_158 VGND VGND VPWR VPWR sky130_fd_sc_hd__fill_1
XFILLER_0_21_169 VGND VGND VPWR VPWR sky130_fd_sc_hd__decap_8
XFILLER_0_88_114 VGND VGND VPWR VPWR sky130_fd_sc_hd__decap_3
XFILLER_0_107_69 VPWR VGND VPWR VGND sky130_ef_sc_hd__decap_12
XFILLER_0_76_309 VGND VGND VPWR VPWR sky130_fd_sc_hd__fill_1
XFILLER_0_96_191 VGND VGND VPWR VPWR sky130_fd_sc_hd__decap_4
XFILLER_0_29_225 VPWR VGND VPWR VGND sky130_ef_sc_hd__decap_12
XFILLER_0_57_589 VGND VGND VPWR VPWR sky130_fd_sc_hd__fill_1
XFILLER_0_8_119 VGND VGND VPWR VPWR sky130_fd_sc_hd__decap_6
X_4620_ _3395_ _3723_ _3725_ VGND VGND VPWR VPWR _3726_ sky130_fd_sc_hd__a21o_1
XFILLER_0_44_239 VPWR VGND VPWR VGND sky130_ef_sc_hd__decap_12
X_4551_ _2802_ _3324_ _3336_ _3335_ _3317_ _3314_ VGND VGND VPWR VPWR _3658_ sky130_fd_sc_hd__mux4_1
XFILLER_0_13_615 VGND VGND VPWR VPWR sky130_fd_sc_hd__fill_1
XFILLER_0_52_250 VGND VGND VPWR VPWR sky130_fd_sc_hd__fill_2
X_4482_ _3529_ _3588_ VGND VGND VPWR VPWR _3590_ sky130_fd_sc_hd__nand2_1
X_7270_ _2397_ _3269_ _0878_ _1075_ VGND VGND VPWR VPWR _2760_ sky130_fd_sc_hd__and4_1
X_6221_ _1608_ _1609_ _1611_ VGND VGND VPWR VPWR _1613_ sky130_fd_sc_hd__o21ai_1
XFILLER_0_40_489 VPWR VGND VPWR VGND sky130_ef_sc_hd__decap_12
X_6152_ _3119_ _1282_ _1195_ _2550_ VGND VGND VPWR VPWR _1537_ sky130_fd_sc_hd__a22oi_1
X_5103_ _0390_ _3302_ _3597_ _0392_ _3489_ VGND VGND VPWR VPWR _0393_ sky130_fd_sc_hd__a311oi_2
XTAP_TAPCELL_ROW_90_1266 VGND VPWR sky130_fd_sc_hd__tapvpwrvgnd_1
XFILLER_0_57_30 VGND VGND VPWR VPWR sky130_fd_sc_hd__decap_8
XFILLER_0_0_586 VGND VGND VPWR VPWR sky130_fd_sc_hd__fill_2
XTAP_TAPCELL_ROW_90_1277 VGND VPWR sky130_fd_sc_hd__tapvpwrvgnd_1
X_6083_ net32 net57 net13 VGND VGND VPWR VPWR _1462_ sky130_fd_sc_hd__and3_1
X_5034_ _0315_ _0316_ VGND VGND VPWR VPWR _0317_ sky130_fd_sc_hd__xnor2_1
XFILLER_0_79_136 VGND VGND VPWR VPWR sky130_fd_sc_hd__fill_1
XTAP_TAPCELL_ROW_0_224 VGND VPWR sky130_fd_sc_hd__tapvpwrvgnd_1
XTAP_TAPCELL_ROW_0_235 VGND VPWR sky130_fd_sc_hd__tapvpwrvgnd_1
XFILLER_0_18_3 VPWR VGND VPWR VGND sky130_ef_sc_hd__decap_12
XFILLER_0_95_629 VPWR VGND VPWR VGND sky130_ef_sc_hd__decap_12
XFILLER_0_79_169 VPWR VGND VPWR VGND sky130_ef_sc_hd__decap_12
XTAP_TAPCELL_ROW_36_654 VGND VPWR sky130_fd_sc_hd__tapvpwrvgnd_1
XFILLER_0_48_501 VPWR VGND VPWR VGND sky130_ef_sc_hd__decap_12
X_6985_ _2011_ _2174_ _2172_ VGND VGND VPWR VPWR _2448_ sky130_fd_sc_hd__o21a_1
XFILLER_0_94_139 VGND VGND VPWR VPWR sky130_fd_sc_hd__fill_1
XTAP_TAPCELL_ROW_64_974 VGND VPWR sky130_fd_sc_hd__tapvpwrvgnd_1
X_5936_ _1938_ _1719_ VGND VGND VPWR VPWR _1301_ sky130_fd_sc_hd__nand2_1
X_5867_ _0287_ _1225_ _0390_ VGND VGND VPWR VPWR _1226_ sky130_fd_sc_hd__mux2_1
X_7606_ _3121_ _3126_ VGND VGND VPWR VPWR _3127_ sky130_fd_sc_hd__xnor2_2
XFILLER_0_48_589 VGND VGND VPWR VPWR sky130_fd_sc_hd__decap_8
XFILLER_0_105_105 VGND VGND VPWR VPWR sky130_fd_sc_hd__decap_6
X_4818_ _0080_ _0081_ _0003_ _0002_ VGND VGND VPWR VPWR _0082_ sky130_fd_sc_hd__o211a_1
XFILLER_0_63_548 VPWR VGND VPWR VGND sky130_ef_sc_hd__decap_12
X_5798_ _1147_ _1149_ VGND VGND VPWR VPWR _1150_ sky130_fd_sc_hd__xnor2_1
X_4749_ _0039_ _3356_ _3354_ VGND VGND VPWR VPWR _0010_ sky130_fd_sc_hd__or3b_4
XFILLER_0_90_389 VGND VGND VPWR VPWR sky130_fd_sc_hd__decap_8
X_7537_ _3050_ _3051_ VGND VGND VPWR VPWR _3052_ sky130_fd_sc_hd__and2b_1
XFILLER_0_43_250 VGND VGND VPWR VPWR sky130_fd_sc_hd__fill_1
X_7468_ _1391_ _0813_ VGND VGND VPWR VPWR _2976_ sky130_fd_sc_hd__nand2_1
X_6419_ _1813_ _1814_ _1828_ VGND VGND VPWR VPWR _1830_ sky130_fd_sc_hd__a21o_1
X_7399_ _2881_ _2882_ _2898_ VGND VGND VPWR VPWR _2901_ sky130_fd_sc_hd__and3_1
XTAP_TAPCELL_ROW_8_324 VGND VPWR sky130_fd_sc_hd__tapvpwrvgnd_1
Xoutput69 net69 VGND VGND VPWR VPWR result[0] sky130_fd_sc_hd__buf_2
XFILLER_0_98_434 VGND VGND VPWR VPWR sky130_fd_sc_hd__fill_1
XFILLER_0_98_489 VGND VGND VPWR VPWR sky130_fd_sc_hd__decap_8
XFILLER_0_85_117 VGND VGND VPWR VPWR sky130_fd_sc_hd__fill_1
XFILLER_0_58_309 VPWR VGND VPWR VGND sky130_ef_sc_hd__decap_12
XFILLER_0_85_128 VPWR VGND VPWR VGND sky130_ef_sc_hd__decap_12
XFILLER_0_94_651 VGND VGND VPWR VPWR sky130_fd_sc_hd__fill_1
XFILLER_0_109_477 VGND VGND VPWR VPWR sky130_fd_sc_hd__fill_2
XFILLER_0_81_378 VPWR VGND VPWR VGND sky130_ef_sc_hd__decap_12
XFILLER_0_78_29 VGND VGND VPWR VPWR sky130_fd_sc_hd__decap_6
XFILLER_0_34_283 VGND VGND VPWR VPWR sky130_fd_sc_hd__fill_1
XFILLER_0_34_294 VGND VGND VPWR VPWR sky130_fd_sc_hd__decap_3
XFILLER_0_104_182 VGND VGND VPWR VPWR sky130_fd_sc_hd__fill_1
XFILLER_0_104_193 VGND VGND VPWR VPWR sky130_fd_sc_hd__decap_3
XFILLER_0_27_77 VGND VGND VPWR VPWR sky130_fd_sc_hd__decap_3
XFILLER_0_89_456 VGND VGND VPWR VPWR sky130_fd_sc_hd__decap_4
XFILLER_0_89_478 VGND VGND VPWR VPWR sky130_fd_sc_hd__decap_6
X_3982_ A[11] VGND VGND VPWR VPWR _1555_ sky130_fd_sc_hd__clkbuf_4
X_6770_ _2206_ _2212_ VGND VGND VPWR VPWR _2213_ sky130_fd_sc_hd__xnor2_1
XTAP_TAPCELL_ROW_61_933 VGND VPWR sky130_fd_sc_hd__tapvpwrvgnd_1
X_5721_ _0919_ _0935_ _1066_ _1065_ VGND VGND VPWR VPWR _1067_ sky130_fd_sc_hd__o211a_4
XTAP_TAPCELL_ROW_33_613 VGND VPWR sky130_fd_sc_hd__tapvpwrvgnd_1
XFILLER_0_17_228 VPWR VGND VPWR VGND sky130_ef_sc_hd__decap_12
XFILLER_0_94_7 VPWR VGND VPWR VGND sky130_ef_sc_hd__decap_12
X_5652_ _0989_ _0990_ VGND VGND VPWR VPWR _0991_ sky130_fd_sc_hd__nor2_1
XFILLER_0_45_559 VGND VGND VPWR VPWR sky130_fd_sc_hd__fill_1
X_4603_ _3644_ _3708_ VGND VGND VPWR VPWR _3709_ sky130_fd_sc_hd__xnor2_1
XFILLER_0_72_389 VPWR VGND VPWR VGND sky130_ef_sc_hd__decap_12
XTAP_TAPCELL_ROW_13_381 VGND VPWR sky130_fd_sc_hd__tapvpwrvgnd_1
XFILLER_0_4_133 VGND VGND VPWR VPWR sky130_fd_sc_hd__decap_6
X_5583_ _0914_ _0913_ _0804_ _0882_ VGND VGND VPWR VPWR _0916_ sky130_fd_sc_hd__o211a_1
X_4534_ _3619_ _3640_ VGND VGND VPWR VPWR _3641_ sky130_fd_sc_hd__xnor2_2
X_7322_ _2618_ _2621_ _2619_ VGND VGND VPWR VPWR _2817_ sky130_fd_sc_hd__o21ba_1
XFILLER_0_40_220 VGND VGND VPWR VPWR sky130_fd_sc_hd__fill_1
X_4465_ _3411_ _3531_ _3532_ _3573_ VGND VGND VPWR VPWR net94 sky130_fd_sc_hd__o31ai_1
X_7253_ _2739_ _2740_ VGND VGND VPWR VPWR _2741_ sky130_fd_sc_hd__nor2_1
X_7184_ _0848_ _2664_ _2665_ VGND VGND VPWR VPWR _2666_ sky130_fd_sc_hd__or3_1
X_4396_ _3501_ _3505_ VGND VGND VPWR VPWR _3506_ sky130_fd_sc_hd__nand2_1
X_6204_ _2342_ _2495_ net124 _0660_ VGND VGND VPWR VPWR _1594_ sky130_fd_sc_hd__nand4_1
XFILLER_0_40_297 VGND VGND VPWR VPWR sky130_fd_sc_hd__fill_1
X_6135_ _1064_ _1356_ _2266_ VGND VGND VPWR VPWR _1519_ sky130_fd_sc_hd__a21bo_1
X_6066_ _1533_ _1654_ _1283_ _1281_ VGND VGND VPWR VPWR _1443_ sky130_fd_sc_hd__a31oi_2
XFILLER_0_84_83 VGND VGND VPWR VPWR sky130_fd_sc_hd__fill_1
XFILLER_0_84_61 VGND VGND VPWR VPWR sky130_fd_sc_hd__fill_1
X_5017_ _3277_ _3279_ VGND VGND VPWR VPWR _0298_ sky130_fd_sc_hd__or2_1
XFILLER_0_95_426 VGND VGND VPWR VPWR sky130_fd_sc_hd__decap_4
XTAP_TAPCELL_ROW_101_1402 VGND VPWR sky130_fd_sc_hd__tapvpwrvgnd_1
XFILLER_0_76_651 VGND VGND VPWR VPWR sky130_fd_sc_hd__fill_1
X_6968_ _2391_ _2392_ _2427_ _2428_ VGND VGND VPWR VPWR _2429_ sky130_fd_sc_hd__a211oi_2
X_6899_ _2351_ _2352_ VGND VGND VPWR VPWR _2354_ sky130_fd_sc_hd__nor2_1
X_5919_ _3275_ _1280_ _1281_ VGND VGND VPWR VPWR _1283_ sky130_fd_sc_hd__a21oi_1
XFILLER_0_63_356 VGND VGND VPWR VPWR sky130_fd_sc_hd__fill_2
XFILLER_0_16_250 VGND VGND VPWR VPWR sky130_fd_sc_hd__fill_2
XFILLER_0_51_529 VPWR VGND VPWR VGND sky130_ef_sc_hd__decap_12
XFILLER_0_90_197 VGND VGND VPWR VPWR sky130_fd_sc_hd__decap_8
XPHY_EDGE_ROW_2_Left_112 VGND VGND VPWR VPWR sky130_fd_sc_hd__decap_3
XPHY_EDGE_ROW_39_Left_149 VGND VGND VPWR VPWR sky130_fd_sc_hd__decap_3
XFILLER_0_102_642 VGND VGND VPWR VPWR sky130_fd_sc_hd__fill_2
XFILLER_0_7_3 VPWR VGND VPWR VGND sky130_ef_sc_hd__decap_12
XFILLER_0_101_185 VGND VGND VPWR VPWR sky130_fd_sc_hd__decap_6
XTAP_TAPCELL_ROW_67_1010 VGND VPWR sky130_fd_sc_hd__tapvpwrvgnd_1
XFILLER_0_59_629 VGND VGND VPWR VPWR sky130_fd_sc_hd__decap_4
XPHY_EDGE_ROW_48_Left_158 VGND VGND VPWR VPWR sky130_fd_sc_hd__decap_3
XFILLER_0_104_15 VPWR VGND VPWR VGND sky130_ef_sc_hd__decap_12
XFILLER_0_82_643 VGND VGND VPWR VPWR sky130_fd_sc_hd__fill_1
XFILLER_0_54_334 VGND VGND VPWR VPWR sky130_fd_sc_hd__decap_6
XFILLER_0_81_164 VGND VGND VPWR VPWR sky130_fd_sc_hd__decap_4
XFILLER_0_54_389 VGND VGND VPWR VPWR sky130_fd_sc_hd__decap_4
XPHY_EDGE_ROW_57_Left_167 VGND VGND VPWR VPWR sky130_fd_sc_hd__decap_3
XTAP_TAPCELL_ROW_10_351 VGND VPWR sky130_fd_sc_hd__tapvpwrvgnd_1
XFILLER_0_35_581 VGND VGND VPWR VPWR sky130_fd_sc_hd__fill_1
XFILLER_0_1_125 VPWR VGND VPWR VGND sky130_ef_sc_hd__decap_12
XFILLER_0_2_637 VGND VGND VPWR VPWR sky130_fd_sc_hd__decap_6
XFILLER_0_22_253 VPWR VGND VPWR VGND sky130_ef_sc_hd__decap_12
XFILLER_0_50_540 VPWR VGND VPWR VGND sky130_ef_sc_hd__decap_12
XFILLER_0_50_584 VGND VGND VPWR VPWR sky130_fd_sc_hd__decap_4
X_4250_ _3354_ _0039_ _3361_ VGND VGND VPWR VPWR _3362_ sky130_fd_sc_hd__nor3_1
XFILLER_0_10_459 VPWR VGND VPWR VGND sky130_ef_sc_hd__decap_12
XFILLER_0_22_297 VGND VGND VPWR VPWR sky130_fd_sc_hd__decap_8
X_4181_ _3281_ _3286_ _3292_ VGND VGND VPWR VPWR _3293_ sky130_fd_sc_hd__and3_1
XPHY_EDGE_ROW_66_Left_176 VGND VGND VPWR VPWR sky130_fd_sc_hd__decap_3
X_6822_ _2268_ _2269_ VGND VGND VPWR VPWR _2270_ sky130_fd_sc_hd__nor2_1
XTAP_TAPCELL_ROW_18_440 VGND VPWR sky130_fd_sc_hd__tapvpwrvgnd_1
XTAP_TAPCELL_ROW_46_760 VGND VPWR sky130_fd_sc_hd__tapvpwrvgnd_1
XFILLER_0_58_651 VGND VGND VPWR VPWR sky130_fd_sc_hd__fill_1
XFILLER_0_9_225 VPWR VGND VPWR VGND sky130_ef_sc_hd__decap_12
XTAP_TAPCELL_ROW_46_771 VGND VPWR sky130_fd_sc_hd__tapvpwrvgnd_1
X_3965_ _0747_ _0846_ _1359_ VGND VGND VPWR VPWR _1370_ sky130_fd_sc_hd__and3_1
X_6753_ net149 net18 _0856_ _2627_ VGND VGND VPWR VPWR _2194_ sky130_fd_sc_hd__a22oi_1
XFILLER_0_18_515 VGND VGND VPWR VPWR sky130_fd_sc_hd__fill_1
X_3896_ _0105_ _0116_ VGND VGND VPWR VPWR _0617_ sky130_fd_sc_hd__or2_1
XFILLER_0_72_131 VGND VGND VPWR VPWR sky130_fd_sc_hd__decap_8
XFILLER_0_70_85 VGND VGND VPWR VPWR sky130_fd_sc_hd__decap_4
XFILLER_0_57_183 VGND VGND VPWR VPWR sky130_fd_sc_hd__fill_1
X_5704_ _1045_ _1046_ _1047_ VGND VGND VPWR VPWR _1048_ sky130_fd_sc_hd__nand3_1
X_6684_ _2096_ _2097_ _2116_ _2117_ VGND VGND VPWR VPWR _2119_ sky130_fd_sc_hd__a2bb2oi_1
X_5635_ _0960_ _3440_ _0972_ VGND VGND VPWR VPWR _0973_ sky130_fd_sc_hd__a21oi_1
XPHY_EDGE_ROW_75_Left_185 VGND VGND VPWR VPWR sky130_fd_sc_hd__decap_3
XFILLER_0_72_153 VGND VGND VPWR VPWR sky130_fd_sc_hd__decap_4
XFILLER_0_60_304 VGND VGND VPWR VPWR sky130_fd_sc_hd__fill_1
XFILLER_0_33_529 VGND VGND VPWR VPWR sky130_fd_sc_hd__fill_1
XFILLER_0_85_3 VGND VGND VPWR VPWR sky130_fd_sc_hd__decap_6
XFILLER_0_72_197 VPWR VGND VPWR VGND sky130_ef_sc_hd__decap_12
XFILLER_0_5_442 VGND VGND VPWR VPWR sky130_fd_sc_hd__fill_1
XFILLER_0_79_72 VGND VGND VPWR VPWR sky130_fd_sc_hd__decap_8
X_5566_ _0893_ _0896_ VGND VGND VPWR VPWR _0897_ sky130_fd_sc_hd__xnor2_2
X_7305_ _2796_ _2797_ VGND VGND VPWR VPWR _2798_ sky130_fd_sc_hd__or2_1
X_5497_ _0819_ _0820_ _0699_ net128 VGND VGND VPWR VPWR _0822_ sky130_fd_sc_hd__a211o_1
X_4517_ _3449_ _3621_ _3623_ _3185_ VGND VGND VPWR VPWR _3624_ sky130_fd_sc_hd__a22oi_1
X_4448_ _3304_ _3547_ _3556_ VGND VGND VPWR VPWR _3557_ sky130_fd_sc_hd__o21a_1
X_7236_ _2509_ _2716_ _2721_ VGND VGND VPWR VPWR _2722_ sky130_fd_sc_hd__o21ai_1
XFILLER_0_0_180 VGND VGND VPWR VPWR sky130_fd_sc_hd__decap_3
X_4379_ _3297_ VGND VGND VPWR VPWR _3489_ sky130_fd_sc_hd__clkbuf_4
XPHY_EDGE_ROW_84_Left_194 VGND VGND VPWR VPWR sky130_fd_sc_hd__decap_3
X_7167_ _2645_ _2646_ VGND VGND VPWR VPWR _2647_ sky130_fd_sc_hd__or2b_1
X_7098_ _2569_ _2570_ VGND VGND VPWR VPWR _2571_ sky130_fd_sc_hd__nor2_1
X_6118_ _1387_ _1499_ VGND VGND VPWR VPWR _1500_ sky130_fd_sc_hd__xnor2_2
X_6049_ _1393_ _1394_ _1422_ _1423_ VGND VGND VPWR VPWR _1425_ sky130_fd_sc_hd__a211oi_2
XFILLER_0_68_448 VGND VGND VPWR VPWR sky130_fd_sc_hd__decap_8
XFILLER_0_68_437 VGND VGND VPWR VPWR sky130_fd_sc_hd__fill_1
XFILLER_0_95_256 VGND VGND VPWR VPWR sky130_fd_sc_hd__decap_3
XFILLER_0_95_289 VGND VGND VPWR VPWR sky130_fd_sc_hd__fill_1
XFILLER_0_83_418 VGND VGND VPWR VPWR sky130_fd_sc_hd__decap_3
XFILLER_0_64_621 VGND VGND VPWR VPWR sky130_fd_sc_hd__decap_6
XFILLER_0_64_610 VGND VGND VPWR VPWR sky130_fd_sc_hd__decap_4
XFILLER_0_55_109 VGND VGND VPWR VPWR sky130_fd_sc_hd__decap_3
XFILLER_0_64_643 VGND VGND VPWR VPWR sky130_fd_sc_hd__fill_1
XFILLER_0_91_473 VPWR VGND VPWR VGND sky130_ef_sc_hd__decap_12
XFILLER_0_51_315 VGND VGND VPWR VPWR sky130_fd_sc_hd__fill_1
XFILLER_0_51_337 VPWR VGND VPWR VGND sky130_ef_sc_hd__decap_12
XFILLER_0_102_472 VGND VGND VPWR VPWR sky130_fd_sc_hd__decap_4
XTAP_TAPCELL_ROW_73_1080 VGND VPWR sky130_fd_sc_hd__tapvpwrvgnd_1
XFILLER_0_99_573 VPWR VGND VPWR VGND sky130_ef_sc_hd__decap_12
XFILLER_0_59_437 VGND VGND VPWR VPWR sky130_fd_sc_hd__fill_1
XTAP_TAPCELL_ROW_15_410 VGND VPWR sky130_fd_sc_hd__tapvpwrvgnd_1
XTAP_TAPCELL_ROW_43_730 VGND VPWR sky130_fd_sc_hd__tapvpwrvgnd_1
XFILLER_0_46_109 VGND VGND VPWR VPWR sky130_fd_sc_hd__decap_8
XFILLER_0_67_481 VGND VGND VPWR VPWR sky130_fd_sc_hd__decap_3
XFILLER_0_55_632 VGND VGND VPWR VPWR sky130_fd_sc_hd__decap_6
XFILLER_0_70_624 VPWR VGND VPWR VGND sky130_ef_sc_hd__decap_12
XFILLER_0_42_326 VPWR VGND VPWR VGND sky130_ef_sc_hd__decap_12
XFILLER_0_54_175 VPWR VGND VPWR VGND sky130_ef_sc_hd__decap_12
XFILLER_0_54_197 VGND VGND VPWR VPWR sky130_fd_sc_hd__decap_6
XTAP_TAPCELL_ROW_76_1109 VGND VPWR sky130_fd_sc_hd__tapvpwrvgnd_1
X_5420_ _3332_ _2091_ _0715_ _3287_ VGND VGND VPWR VPWR _0738_ sky130_fd_sc_hd__a22o_1
XFILLER_0_42_348 VPWR VGND VPWR VGND sky130_ef_sc_hd__decap_12
X_5351_ _0656_ _0661_ _0662_ VGND VGND VPWR VPWR _0663_ sky130_fd_sc_hd__nand3_1
XFILLER_0_23_573 VPWR VGND VPWR VGND sky130_ef_sc_hd__decap_12
XFILLER_0_100_409 VGND VGND VPWR VPWR sky130_fd_sc_hd__decap_8
X_4302_ _3355_ _3412_ VGND VGND VPWR VPWR _3413_ sky130_fd_sc_hd__nor2_1
X_5282_ _0495_ _0494_ _0586_ VGND VGND VPWR VPWR _0588_ sky130_fd_sc_hd__nand3_1
X_7021_ _0518_ _2487_ _0953_ VGND VGND VPWR VPWR _2488_ sky130_fd_sc_hd__a21oi_1
X_4233_ _3288_ VGND VGND VPWR VPWR _3345_ sky130_fd_sc_hd__clkbuf_4
X_4164_ _1850_ _1818_ VGND VGND VPWR VPWR _3276_ sky130_fd_sc_hd__or2_1
XFILLER_0_4_77 VGND VGND VPWR VPWR sky130_fd_sc_hd__decap_6
X_4095_ _2671_ _2703_ VGND VGND VPWR VPWR _2791_ sky130_fd_sc_hd__nand2_2
XTAP_TAPCELL_ROW_87_1238 VGND VPWR sky130_fd_sc_hd__tapvpwrvgnd_1
XFILLER_0_81_73 VPWR VGND VPWR VGND sky130_ef_sc_hd__decap_12
XFILLER_0_77_267 VGND VGND VPWR VPWR sky130_fd_sc_hd__fill_1
X_6805_ _2249_ _2250_ VGND VGND VPWR VPWR _2251_ sky130_fd_sc_hd__nor2_1
X_4997_ _1861_ _0179_ _3279_ VGND VGND VPWR VPWR _0277_ sky130_fd_sc_hd__a21bo_1
XFILLER_0_46_621 VPWR VGND VPWR VGND sky130_ef_sc_hd__decap_12
XFILLER_0_46_643 VGND VGND VPWR VPWR sky130_fd_sc_hd__fill_1
X_6736_ _2011_ _2174_ VGND VGND VPWR VPWR _2175_ sky130_fd_sc_hd__xnor2_1
X_3948_ _1173_ VGND VGND VPWR VPWR _1184_ sky130_fd_sc_hd__clkbuf_4
XFILLER_0_18_356 VGND VGND VPWR VPWR sky130_fd_sc_hd__decap_8
X_3879_ net20 net51 VGND VGND VPWR VPWR _0431_ sky130_fd_sc_hd__or2_1
XTAP_TAPCELL_ROW_21_479 VGND VPWR sky130_fd_sc_hd__tapvpwrvgnd_1
XFILLER_0_33_337 VGND VGND VPWR VPWR sky130_fd_sc_hd__decap_4
X_6667_ _1413_ _1938_ _3254_ _1381_ VGND VGND VPWR VPWR _2100_ sky130_fd_sc_hd__a22o_1
XFILLER_0_103_214 VGND VGND VPWR VPWR sky130_fd_sc_hd__fill_2
XTAP_TAPCELL_ROW_98_1367 VGND VPWR sky130_fd_sc_hd__tapvpwrvgnd_1
X_5618_ _0726_ _0846_ _0839_ _0953_ VGND VGND VPWR VPWR _0954_ sky130_fd_sc_hd__a31o_1
X_6598_ _1863_ _1877_ _1878_ VGND VGND VPWR VPWR _2024_ sky130_fd_sc_hd__or3_1
XFILLER_0_33_348 VPWR VGND VPWR VGND sky130_ef_sc_hd__decap_12
X_5549_ _0875_ _0876_ _0860_ VGND VGND VPWR VPWR _0879_ sky130_fd_sc_hd__a21oi_1
XPHY_EDGE_ROW_92_Left_202 VGND VGND VPWR VPWR sky130_fd_sc_hd__decap_3
X_7219_ _2501_ _2503_ _2500_ VGND VGND VPWR VPWR _2704_ sky130_fd_sc_hd__o21ba_1
XFILLER_0_96_510 VGND VGND VPWR VPWR sky130_fd_sc_hd__decap_6
XTAP_TAPCELL_ROW_57_888 VGND VPWR sky130_fd_sc_hd__tapvpwrvgnd_1
XTAP_TAPCELL_ROW_29_568 VGND VPWR sky130_fd_sc_hd__tapvpwrvgnd_1
XTAP_TAPCELL_ROW_107_1463 VGND VPWR sky130_fd_sc_hd__tapvpwrvgnd_1
XFILLER_0_68_245 VGND VGND VPWR VPWR sky130_fd_sc_hd__fill_1
XTAP_TAPCELL_ROW_40_700 VGND VPWR sky130_fd_sc_hd__tapvpwrvgnd_1
XFILLER_0_36_153 VPWR VGND VPWR VGND sky130_ef_sc_hd__decap_12
XFILLER_0_91_281 VGND VGND VPWR VPWR sky130_fd_sc_hd__decap_8
XFILLER_0_91_270 VGND VGND VPWR VPWR sky130_fd_sc_hd__decap_8
XFILLER_0_52_635 VGND VGND VPWR VPWR sky130_fd_sc_hd__decap_8
XFILLER_0_107_597 VPWR VGND VPWR VGND sky130_ef_sc_hd__decap_12
XFILLER_0_101_27 VPWR VGND VPWR VGND sky130_ef_sc_hd__decap_12
XFILLER_0_36_197 VGND VGND VPWR VPWR sky130_fd_sc_hd__fill_2
XFILLER_0_51_156 VGND VGND VPWR VPWR sky130_fd_sc_hd__decap_3
XFILLER_0_51_189 VPWR VGND VPWR VGND sky130_ef_sc_hd__decap_12
XFILLER_0_86_29 VGND VGND VPWR VPWR sky130_fd_sc_hd__fill_2
XFILLER_0_86_18 VGND VGND VPWR VPWR sky130_fd_sc_hd__decap_6
XFILLER_0_20_587 VGND VGND VPWR VPWR sky130_fd_sc_hd__fill_1
XFILLER_0_99_381 VGND VGND VPWR VPWR sky130_fd_sc_hd__fill_2
XFILLER_0_35_55 VGND VGND VPWR VPWR sky130_fd_sc_hd__fill_1
XFILLER_0_87_565 VPWR VGND VPWR VGND sky130_ef_sc_hd__decap_12
X_4920_ _1872_ _3305_ _3309_ VGND VGND VPWR VPWR _0194_ sky130_fd_sc_hd__mux2_1
XFILLER_0_59_278 VGND VGND VPWR VPWR sky130_fd_sc_hd__fill_2
X_4851_ _3832_ _3834_ _0067_ _0068_ VGND VGND VPWR VPWR _0118_ sky130_fd_sc_hd__o211a_1
XTAP_TAPCELL_ROW_82_1179 VGND VPWR sky130_fd_sc_hd__tapvpwrvgnd_1
XFILLER_0_28_643 VGND VGND VPWR VPWR sky130_fd_sc_hd__fill_1
X_7570_ _2517_ _0148_ _0192_ _2364_ VGND VGND VPWR VPWR _3088_ sky130_fd_sc_hd__a22oi_1
X_4782_ _3196_ _1730_ VGND VGND VPWR VPWR _0043_ sky130_fd_sc_hd__nand2_1
XFILLER_0_70_421 VPWR VGND VPWR VGND sky130_ef_sc_hd__decap_12
XFILLER_0_55_484 VGND VGND VPWR VPWR sky130_fd_sc_hd__decap_8
X_6521_ _1929_ _1930_ _1940_ VGND VGND VPWR VPWR _1941_ sky130_fd_sc_hd__and3_1
XFILLER_0_15_337 VGND VGND VPWR VPWR sky130_fd_sc_hd__fill_1
X_6452_ _1490_ _1665_ _1731_ _1729_ VGND VGND VPWR VPWR _1865_ sky130_fd_sc_hd__a31o_1
X_5403_ _0718_ _0097_ _3751_ _3265_ _0719_ VGND VGND VPWR VPWR _0720_ sky130_fd_sc_hd__o221a_1
XFILLER_0_2_231 VPWR VGND VPWR VGND sky130_ef_sc_hd__decap_12
XFILLER_0_30_307 VGND VGND VPWR VPWR sky130_fd_sc_hd__fill_1
XFILLER_0_42_167 VGND VGND VPWR VPWR sky130_fd_sc_hd__fill_1
XFILLER_0_2_253 VGND VGND VPWR VPWR sky130_fd_sc_hd__decap_4
X_6383_ _1787_ _1788_ _1750_ VGND VGND VPWR VPWR _1790_ sky130_fd_sc_hd__o21ai_2
XFILLER_0_2_297 VGND VGND VPWR VPWR sky130_fd_sc_hd__decap_3
X_5334_ _0640_ _0643_ VGND VGND VPWR VPWR _0644_ sky130_fd_sc_hd__xnor2_1
X_5265_ _0565_ _0566_ _0567_ VGND VGND VPWR VPWR _0569_ sky130_fd_sc_hd__a21o_1
XFILLER_0_76_73 VGND VGND VPWR VPWR sky130_fd_sc_hd__fill_1
X_7004_ _2467_ _2468_ _2295_ VGND VGND VPWR VPWR _2469_ sky130_fd_sc_hd__o21a_1
X_5196_ _0492_ _0493_ VGND VGND VPWR VPWR _0494_ sky130_fd_sc_hd__nor2_2
XFILLER_0_48_3 VGND VGND VPWR VPWR sky130_fd_sc_hd__decap_4
X_4216_ _3287_ VGND VGND VPWR VPWR _3328_ sky130_fd_sc_hd__clkbuf_4
X_4147_ _1993_ _1435_ VGND VGND VPWR VPWR _3259_ sky130_fd_sc_hd__nor2b_2
X_4078_ net57 VGND VGND VPWR VPWR _2605_ sky130_fd_sc_hd__buf_6
XFILLER_0_93_513 VGND VGND VPWR VPWR sky130_fd_sc_hd__fill_2
XFILLER_0_78_587 VGND VGND VPWR VPWR sky130_fd_sc_hd__fill_1
XFILLER_0_65_215 VGND VGND VPWR VPWR sky130_fd_sc_hd__decap_8
XTAP_TAPCELL_ROW_26_538 VGND VPWR sky130_fd_sc_hd__tapvpwrvgnd_1
XTAP_TAPCELL_ROW_54_858 VGND VPWR sky130_fd_sc_hd__tapvpwrvgnd_1
XFILLER_0_93_535 VGND VGND VPWR VPWR sky130_fd_sc_hd__decap_6
XFILLER_0_65_237 VGND VGND VPWR VPWR sky130_fd_sc_hd__fill_2
XFILLER_0_108_328 VGND VGND VPWR VPWR sky130_fd_sc_hd__fill_2
XFILLER_0_65_259 VGND VGND VPWR VPWR sky130_fd_sc_hd__fill_1
XFILLER_0_18_153 VGND VGND VPWR VPWR sky130_fd_sc_hd__decap_4
X_6719_ _2001_ _2002_ _2156_ VGND VGND VPWR VPWR net86 sky130_fd_sc_hd__o21ai_2
XFILLER_0_73_281 VPWR VGND VPWR VGND sky130_ef_sc_hd__decap_12
X_7699_ net70 net71 _3227_ VGND VGND VPWR VPWR _3229_ sky130_fd_sc_hd__or3_1
XFILLER_0_18_164 VPWR VGND VPWR VGND sky130_ef_sc_hd__decap_12
XFILLER_0_46_495 VPWR VGND VPWR VGND sky130_ef_sc_hd__decap_12
XFILLER_0_18_197 VPWR VGND VPWR VGND sky130_ef_sc_hd__decap_12
XFILLER_0_61_476 VGND VGND VPWR VPWR sky130_fd_sc_hd__fill_2
XFILLER_0_21_318 VPWR VGND VPWR VGND sky130_ef_sc_hd__decap_12
XFILLER_0_33_167 VGND VGND VPWR VPWR sky130_fd_sc_hd__fill_1
XFILLER_0_104_589 VPWR VGND VPWR VGND sky130_ef_sc_hd__decap_12
XFILLER_0_14_370 VPWR VGND VPWR VGND sky130_ef_sc_hd__decap_12
XTAP_TAPCELL_ROW_109_1503 VGND VPWR sky130_fd_sc_hd__tapvpwrvgnd_1
XFILLER_0_88_318 VPWR VGND VPWR VGND sky130_ef_sc_hd__decap_12
XFILLER_0_96_373 VGND VGND VPWR VPWR sky130_fd_sc_hd__fill_2
XFILLER_0_96_384 VGND VGND VPWR VPWR sky130_fd_sc_hd__decap_8
XFILLER_0_56_259 VGND VGND VPWR VPWR sky130_fd_sc_hd__decap_4
XFILLER_0_37_473 VPWR VGND VPWR VGND sky130_ef_sc_hd__decap_12
XFILLER_0_21_79 VPWR VGND VPWR VGND sky130_ef_sc_hd__decap_12
XFILLER_0_24_156 VGND VGND VPWR VPWR sky130_fd_sc_hd__decap_6
X_5050_ _3448_ _3622_ net144 _3267_ VGND VGND VPWR VPWR _0335_ sky130_fd_sc_hd__and4_1
X_4001_ _1675_ _1632_ VGND VGND VPWR VPWR _1763_ sky130_fd_sc_hd__nor2b_2
XFILLER_0_79_318 VPWR VGND VPWR VGND sky130_ef_sc_hd__decap_12
XTAP_TAPCELL_ROW_84_1208 VGND VPWR sky130_fd_sc_hd__tapvpwrvgnd_1
X_5952_ _1316_ _1314_ _1317_ VGND VGND VPWR VPWR _1319_ sky130_fd_sc_hd__a21o_1
X_4903_ _0117_ _0084_ _0173_ _3647_ VGND VGND VPWR VPWR _0175_ sky130_fd_sc_hd__a31o_1
XFILLER_0_62_53 VPWR VGND VPWR VGND sky130_ef_sc_hd__decap_12
XFILLER_0_75_535 VGND VGND VPWR VPWR sky130_fd_sc_hd__fill_1
XFILLER_0_62_97 VPWR VGND VPWR VGND sky130_ef_sc_hd__decap_12
X_5883_ _3414_ _1020_ VGND VGND VPWR VPWR _1243_ sky130_fd_sc_hd__nand2_1
XFILLER_0_47_237 VGND VGND VPWR VPWR sky130_fd_sc_hd__decap_4
XTAP_TAPCELL_ROW_51_828 VGND VPWR sky130_fd_sc_hd__tapvpwrvgnd_1
X_4834_ _3396_ _3438_ _3536_ VGND VGND VPWR VPWR _0100_ sky130_fd_sc_hd__o21ai_1
XFILLER_0_75_568 VGND VGND VPWR VPWR sky130_fd_sc_hd__fill_2
XFILLER_0_75_557 VGND VGND VPWR VPWR sky130_fd_sc_hd__decap_3
X_7622_ _2058_ _0715_ VGND VGND VPWR VPWR _3145_ sky130_fd_sc_hd__nand2_1
XFILLER_0_47_248 VGND VGND VPWR VPWR sky130_fd_sc_hd__fill_1
XFILLER_0_90_527 VGND VGND VPWR VPWR sky130_fd_sc_hd__decap_4
X_4765_ _3737_ _3749_ _3273_ VGND VGND VPWR VPWR _0026_ sky130_fd_sc_hd__a21oi_1
X_7553_ _3044_ _3046_ VGND VGND VPWR VPWR _3069_ sky130_fd_sc_hd__nand2_1
XFILLER_0_7_345 VPWR VGND VPWR VGND sky130_ef_sc_hd__decap_12
XFILLER_0_7_334 VGND VGND VPWR VPWR sky130_fd_sc_hd__fill_2
XFILLER_0_16_613 VPWR VGND VPWR VGND sky130_ef_sc_hd__decap_12
X_6504_ _1920_ _1921_ VGND VGND VPWR VPWR _1922_ sky130_fd_sc_hd__nor2_1
XTAP_TAPCELL_ROW_95_1326 VGND VPWR sky130_fd_sc_hd__tapvpwrvgnd_1
X_4696_ _3644_ _3708_ VGND VGND VPWR VPWR _3801_ sky130_fd_sc_hd__and2b_1
XFILLER_0_70_251 VGND VGND VPWR VPWR sky130_fd_sc_hd__fill_1
X_7484_ _2754_ _2755_ VGND VGND VPWR VPWR _2994_ sky130_fd_sc_hd__or2_1
XFILLER_0_15_156 VGND VGND VPWR VPWR sky130_fd_sc_hd__decap_4
XTAP_TAPCELL_ROW_31_596 VGND VPWR sky130_fd_sc_hd__tapvpwrvgnd_1
XFILLER_0_30_137 VGND VGND VPWR VPWR sky130_fd_sc_hd__decap_3
XFILLER_0_31_649 VGND VGND VPWR VPWR sky130_fd_sc_hd__decap_3
X_6435_ _2474_ _2671_ _1282_ _1195_ VGND VGND VPWR VPWR _1846_ sky130_fd_sc_hd__and4_1
XFILLER_0_101_537 VGND VGND VPWR VPWR sky130_fd_sc_hd__decap_3
X_6366_ _1768_ _1769_ _1770_ VGND VGND VPWR VPWR _1771_ sky130_fd_sc_hd__nand3_1
XFILLER_0_30_148 VPWR VGND VPWR VGND sky130_ef_sc_hd__decap_12
X_5317_ _0535_ _0537_ _0623_ VGND VGND VPWR VPWR _0625_ sky130_fd_sc_hd__and3_1
X_6297_ _1693_ _1694_ VGND VGND VPWR VPWR _1695_ sky130_fd_sc_hd__xnor2_2
XTAP_TAPCELL_ROW_59_917 VGND VPWR sky130_fd_sc_hd__tapvpwrvgnd_1
X_5248_ _2692_ _1654_ VGND VGND VPWR VPWR _0550_ sky130_fd_sc_hd__nand2_1
XFILLER_0_98_616 VPWR VGND VPWR VGND sky130_ef_sc_hd__decap_12
X_5179_ _0338_ _0347_ _0346_ VGND VGND VPWR VPWR _0476_ sky130_fd_sc_hd__a21bo_1
XTAP_TAPCELL_ROW_3_266 VGND VPWR sky130_fd_sc_hd__tapvpwrvgnd_1
XTAP_TAPCELL_ROW_39_685 VGND VPWR sky130_fd_sc_hd__tapvpwrvgnd_1
XTAP_TAPCELL_ROW_104_1433 VGND VPWR sky130_fd_sc_hd__tapvpwrvgnd_1
XFILLER_0_78_373 VGND VGND VPWR VPWR sky130_fd_sc_hd__decap_3
XFILLER_0_93_332 VGND VGND VPWR VPWR sky130_fd_sc_hd__decap_4
XFILLER_0_66_524 VGND VGND VPWR VPWR sky130_fd_sc_hd__fill_1
XFILLER_0_81_505 VPWR VGND VPWR VGND sky130_ef_sc_hd__decap_12
XFILLER_0_34_421 VPWR VGND VPWR VGND sky130_ef_sc_hd__decap_12
XFILLER_0_104_320 VGND VGND VPWR VPWR sky130_fd_sc_hd__fill_2
XFILLER_0_34_454 VGND VGND VPWR VPWR sky130_fd_sc_hd__decap_3
XFILLER_0_61_273 VGND VGND VPWR VPWR sky130_fd_sc_hd__decap_6
XFILLER_0_107_15 VPWR VGND VPWR VGND sky130_ef_sc_hd__decap_12
XFILLER_0_89_649 VGND VGND VPWR VPWR sky130_fd_sc_hd__decap_3
XFILLER_0_69_351 VGND VGND VPWR VPWR sky130_fd_sc_hd__decap_6
XFILLER_0_84_321 VPWR VGND VPWR VGND sky130_ef_sc_hd__decap_12
XFILLER_0_29_237 VPWR VGND VPWR VGND sky130_ef_sc_hd__decap_12
XFILLER_0_32_23 VGND VGND VPWR VPWR sky130_fd_sc_hd__decap_4
XFILLER_0_44_229 VGND VGND VPWR VPWR sky130_fd_sc_hd__decap_3
XFILLER_0_37_281 VPWR VGND VPWR VGND sky130_ef_sc_hd__decap_12
XFILLER_0_106_3 VPWR VGND VPWR VGND sky130_ef_sc_hd__decap_12
X_4550_ _3655_ _3656_ _3606_ VGND VGND VPWR VPWR _3657_ sky130_fd_sc_hd__a21o_1
X_4481_ _3531_ _3588_ VGND VGND VPWR VPWR _3589_ sky130_fd_sc_hd__nand2_1
XFILLER_0_12_115 VPWR VGND VPWR VGND sky130_ef_sc_hd__decap_12
XFILLER_0_13_649 VGND VGND VPWR VPWR sky130_fd_sc_hd__decap_3
X_6220_ _1608_ _1609_ _1611_ VGND VGND VPWR VPWR _1612_ sky130_fd_sc_hd__or3_4
X_6151_ _1534_ _1535_ VGND VGND VPWR VPWR _1536_ sky130_fd_sc_hd__or2_1
X_5102_ _0280_ _0391_ _3371_ VGND VGND VPWR VPWR _0392_ sky130_fd_sc_hd__a21oi_2
XTAP_TAPCELL_ROW_90_1267 VGND VPWR sky130_fd_sc_hd__tapvpwrvgnd_1
XFILLER_0_57_75 VGND VGND VPWR VPWR sky130_fd_sc_hd__decap_3
X_6082_ _1452_ _1460_ VGND VGND VPWR VPWR _1461_ sky130_fd_sc_hd__xnor2_1
X_5033_ _0209_ _0211_ _0210_ VGND VGND VPWR VPWR _0316_ sky130_fd_sc_hd__o21ba_1
XFILLER_0_73_74 VGND VGND VPWR VPWR sky130_fd_sc_hd__decap_3
XTAP_TAPCELL_ROW_0_225 VGND VPWR sky130_fd_sc_hd__tapvpwrvgnd_1
XTAP_TAPCELL_ROW_0_236 VGND VPWR sky130_fd_sc_hd__tapvpwrvgnd_1
X_6984_ _2436_ _2446_ VGND VGND VPWR VPWR _2447_ sky130_fd_sc_hd__xnor2_1
XFILLER_0_87_181 VGND VGND VPWR VPWR sky130_fd_sc_hd__fill_1
XTAP_TAPCELL_ROW_64_975 VGND VPWR sky130_fd_sc_hd__tapvpwrvgnd_1
X_5935_ _1298_ _1299_ VGND VGND VPWR VPWR _1300_ sky130_fd_sc_hd__nor2_1
XTAP_TAPCELL_ROW_36_655 VGND VPWR sky130_fd_sc_hd__tapvpwrvgnd_1
XFILLER_0_48_513 VPWR VGND VPWR VGND sky130_ef_sc_hd__decap_12
X_5866_ _0728_ _1224_ _0402_ VGND VGND VPWR VPWR _1225_ sky130_fd_sc_hd__mux2_1
XFILLER_0_63_505 VGND VGND VPWR VPWR sky130_fd_sc_hd__fill_1
XFILLER_0_48_557 VGND VGND VPWR VPWR sky130_fd_sc_hd__decap_4
XFILLER_0_48_568 VPWR VGND VPWR VGND sky130_ef_sc_hd__decap_12
X_4817_ _0078_ _0079_ _0030_ VGND VGND VPWR VPWR _0081_ sky130_fd_sc_hd__a21oi_1
X_7605_ _3122_ _3125_ VGND VGND VPWR VPWR _3126_ sky130_fd_sc_hd__xnor2_1
XFILLER_0_8_643 VGND VGND VPWR VPWR sky130_fd_sc_hd__fill_1
XFILLER_0_7_131 VGND VGND VPWR VPWR sky130_fd_sc_hd__fill_1
XFILLER_0_90_357 VGND VGND VPWR VPWR sky130_fd_sc_hd__decap_6
XFILLER_0_16_421 VGND VGND VPWR VPWR sky130_fd_sc_hd__decap_4
X_5797_ _3275_ _0095_ _1148_ VGND VGND VPWR VPWR _1149_ sky130_fd_sc_hd__o21a_1
XFILLER_0_90_379 VGND VGND VPWR VPWR sky130_fd_sc_hd__fill_1
X_4748_ _3273_ _2408_ _0008_ _3364_ VGND VGND VPWR VPWR _0009_ sky130_fd_sc_hd__o31a_1
X_7536_ _3046_ _3047_ _3049_ VGND VGND VPWR VPWR _3051_ sky130_fd_sc_hd__a21o_1
XFILLER_0_7_197 VGND VGND VPWR VPWR sky130_fd_sc_hd__decap_6
XFILLER_0_7_186 VGND VGND VPWR VPWR sky130_fd_sc_hd__fill_1
X_7467_ _3263_ _2973_ _2974_ VGND VGND VPWR VPWR _2975_ sky130_fd_sc_hd__a21oi_1
X_4679_ _3781_ _3782_ _3783_ VGND VGND VPWR VPWR _3784_ sky130_fd_sc_hd__nand3_1
XFILLER_0_101_323 VGND VGND VPWR VPWR sky130_fd_sc_hd__fill_1
X_6418_ _1823_ _1824_ _1827_ VGND VGND VPWR VPWR _1828_ sky130_fd_sc_hd__or3_1
XPHY_EDGE_ROW_1_Right_1 VGND VGND VPWR VPWR sky130_fd_sc_hd__decap_3
X_7398_ _2881_ _2882_ _2898_ VGND VGND VPWR VPWR _2899_ sky130_fd_sc_hd__a21oi_1
XTAP_TAPCELL_ROW_8_325 VGND VPWR sky130_fd_sc_hd__tapvpwrvgnd_1
X_6349_ _1594_ _1596_ VGND VGND VPWR VPWR _1753_ sky130_fd_sc_hd__nand2_1
XFILLER_0_39_502 VGND VGND VPWR VPWR sky130_fd_sc_hd__fill_2
XFILLER_0_39_535 VPWR VGND VPWR VGND sky130_ef_sc_hd__decap_12
XFILLER_0_109_401 VGND VGND VPWR VPWR sky130_fd_sc_hd__fill_1
XFILLER_0_26_207 VGND VGND VPWR VPWR sky130_fd_sc_hd__decap_6
XFILLER_0_81_335 VGND VGND VPWR VPWR sky130_fd_sc_hd__fill_1
XFILLER_0_19_281 VGND VGND VPWR VPWR sky130_fd_sc_hd__decap_8
XFILLER_0_34_240 VGND VGND VPWR VPWR sky130_fd_sc_hd__decap_4
XFILLER_0_34_251 VGND VGND VPWR VPWR sky130_fd_sc_hd__fill_1
XFILLER_0_104_150 VGND VGND VPWR VPWR sky130_fd_sc_hd__decap_4
XFILLER_0_1_318 VGND VGND VPWR VPWR sky130_fd_sc_hd__fill_2
XFILLER_0_94_29 VPWR VGND VPWR VGND sky130_ef_sc_hd__decap_12
XFILLER_0_76_129 VGND VGND VPWR VPWR sky130_fd_sc_hd__fill_1
X_3981_ _1533_ VGND VGND VPWR VPWR _1544_ sky130_fd_sc_hd__clkbuf_4
XFILLER_0_43_55 VGND VGND VPWR VPWR sky130_fd_sc_hd__fill_1
XTAP_TAPCELL_ROW_61_934 VGND VPWR sky130_fd_sc_hd__tapvpwrvgnd_1
X_5720_ _1062_ _1063_ _1001_ VGND VGND VPWR VPWR _1066_ sky130_fd_sc_hd__o21ai_1
XTAP_TAPCELL_ROW_33_614 VGND VPWR sky130_fd_sc_hd__tapvpwrvgnd_1
XFILLER_0_57_365 VGND VGND VPWR VPWR sky130_fd_sc_hd__decap_6
XFILLER_0_45_505 VGND VGND VPWR VPWR sky130_fd_sc_hd__decap_6
X_5651_ _3119_ _2069_ _0693_ _2889_ VGND VGND VPWR VPWR _0990_ sky130_fd_sc_hd__a22oi_1
X_4602_ _3706_ _3707_ VGND VGND VPWR VPWR _3708_ sky130_fd_sc_hd__xnor2_2
XFILLER_0_60_508 VPWR VGND VPWR VGND sky130_ef_sc_hd__decap_12
XTAP_TAPCELL_ROW_13_382 VGND VPWR sky130_fd_sc_hd__tapvpwrvgnd_1
X_5582_ _0804_ _0882_ _0914_ net131 VGND VGND VPWR VPWR _0915_ sky130_fd_sc_hd__a211oi_4
XFILLER_0_25_251 VPWR VGND VPWR VGND sky130_ef_sc_hd__decap_12
X_4533_ _3638_ _3639_ VGND VGND VPWR VPWR _3640_ sky130_fd_sc_hd__and2b_1
X_7321_ _2575_ _2574_ VGND VGND VPWR VPWR _2816_ sky130_fd_sc_hd__and2b_1
XFILLER_0_4_156 VGND VGND VPWR VPWR sky130_fd_sc_hd__fill_1
XFILLER_0_13_413 VGND VGND VPWR VPWR sky130_fd_sc_hd__fill_1
X_7252_ _1818_ _1632_ _0998_ _1271_ VGND VGND VPWR VPWR _2740_ sky130_fd_sc_hd__and4_1
X_4464_ _3441_ _3542_ _3572_ VGND VGND VPWR VPWR _3573_ sky130_fd_sc_hd__a21oi_1
X_6203_ _2342_ net124 net7 _2452_ VGND VGND VPWR VPWR _1593_ sky130_fd_sc_hd__a22o_1
XFILLER_0_7_55 VGND VGND VPWR VPWR sky130_fd_sc_hd__fill_1
X_7183_ _0072_ _1360_ _3558_ _0442_ VGND VGND VPWR VPWR _2665_ sky130_fd_sc_hd__a2bb2o_1
X_4395_ _3289_ _3355_ _3412_ VGND VGND VPWR VPWR _3505_ sky130_fd_sc_hd__o21a_1
XFILLER_0_68_85 VPWR VGND VPWR VGND sky130_ef_sc_hd__decap_12
XFILLER_0_7_99 VGND VGND VPWR VPWR sky130_fd_sc_hd__fill_2
X_6134_ _3303_ _3671_ _1511_ _1517_ VGND VGND VPWR VPWR _1518_ sky130_fd_sc_hd__o211a_1
X_6065_ _1440_ _1441_ VGND VGND VPWR VPWR _1442_ sky130_fd_sc_hd__xnor2_1
X_5016_ _0204_ _0205_ _0297_ VGND VGND VPWR VPWR net71 sky130_fd_sc_hd__o21ai_1
XFILLER_0_30_3 VGND VGND VPWR VPWR sky130_fd_sc_hd__decap_8
XFILLER_0_95_449 VGND VGND VPWR VPWR sky130_fd_sc_hd__decap_4
X_6967_ _2425_ _2426_ _2393_ _2240_ VGND VGND VPWR VPWR _2428_ sky130_fd_sc_hd__a211oi_1
XTAP_TAPCELL_ROW_101_1403 VGND VPWR sky130_fd_sc_hd__tapvpwrvgnd_1
X_5918_ _0465_ net2 _1785_ _0093_ VGND VGND VPWR VPWR _1281_ sky130_fd_sc_hd__and4_1
X_6898_ _2506_ _1097_ _0998_ _2353_ VGND VGND VPWR VPWR _2352_ sky130_fd_sc_hd__a22oi_1
XFILLER_0_48_365 VPWR VGND VPWR VGND sky130_ef_sc_hd__decap_12
XFILLER_0_90_121 VPWR VGND VPWR VGND sky130_ef_sc_hd__decap_12
XFILLER_0_63_335 VGND VGND VPWR VPWR sky130_fd_sc_hd__fill_1
X_5849_ _1204_ _1203_ _1067_ _1104_ VGND VGND VPWR VPWR _1207_ sky130_fd_sc_hd__a211o_4
XFILLER_0_36_549 VPWR VGND VPWR VGND sky130_ef_sc_hd__decap_12
X_7519_ _3015_ _3016_ _3030_ _3031_ VGND VGND VPWR VPWR _3033_ sky130_fd_sc_hd__a211oi_1
XFILLER_0_102_610 VPWR VGND VPWR VGND sky130_ef_sc_hd__decap_12
XFILLER_0_71_390 VGND VGND VPWR VPWR sky130_fd_sc_hd__fill_2
XFILLER_0_31_221 VGND VGND VPWR VPWR sky130_fd_sc_hd__decap_3
XFILLER_0_31_232 VGND VGND VPWR VPWR sky130_fd_sc_hd__decap_6
XFILLER_0_31_254 VPWR VGND VPWR VGND sky130_ef_sc_hd__decap_12
XFILLER_0_101_197 VPWR VGND VPWR VGND sky130_ef_sc_hd__decap_12
XPHY_EDGE_ROW_103_Left_213 VGND VGND VPWR VPWR sky130_fd_sc_hd__decap_3
XTAP_TAPCELL_ROW_67_1011 VGND VPWR sky130_fd_sc_hd__tapvpwrvgnd_1
XFILLER_0_86_427 VGND VGND VPWR VPWR sky130_fd_sc_hd__fill_1
XFILLER_0_104_27 VGND VGND VPWR VPWR sky130_fd_sc_hd__fill_1
XFILLER_0_27_505 VPWR VGND VPWR VGND sky130_ef_sc_hd__decap_12
XFILLER_0_109_253 VPWR VGND VPWR VGND sky130_ef_sc_hd__decap_12
XTAP_TAPCELL_ROW_10_352 VGND VPWR sky130_fd_sc_hd__tapvpwrvgnd_1
XFILLER_0_35_593 VPWR VGND VPWR VGND sky130_ef_sc_hd__decap_12
XFILLER_0_50_552 VPWR VGND VPWR VGND sky130_ef_sc_hd__decap_12
XFILLER_0_1_148 VGND VGND VPWR VPWR sky130_fd_sc_hd__decap_4
XFILLER_0_1_137 VGND VGND VPWR VPWR sky130_fd_sc_hd__decap_3
XFILLER_0_22_265 VGND VGND VPWR VPWR sky130_fd_sc_hd__decap_4
X_4180_ _3108_ _3290_ net116 _3291_ VGND VGND VPWR VPWR _3292_ sky130_fd_sc_hd__and4bb_1
XFILLER_0_38_33 VGND VGND VPWR VPWR sky130_fd_sc_hd__fill_1
XFILLER_0_38_55 VGND VGND VPWR VPWR sky130_fd_sc_hd__decap_8
XFILLER_0_54_10 VPWR VGND VPWR VGND sky130_ef_sc_hd__decap_12
XTAP_TAPCELL_ROW_18_441 VGND VPWR sky130_fd_sc_hd__tapvpwrvgnd_1
XTAP_TAPCELL_ROW_46_761 VGND VPWR sky130_fd_sc_hd__tapvpwrvgnd_1
X_6821_ _2080_ _1566_ _1839_ _0704_ VGND VGND VPWR VPWR _2269_ sky130_fd_sc_hd__a22oi_1
XFILLER_0_77_449 VGND VGND VPWR VPWR sky130_fd_sc_hd__fill_1
XFILLER_0_58_630 VPWR VGND VPWR VGND sky130_ef_sc_hd__decap_12
X_3964_ _1151_ _1249_ _1348_ VGND VGND VPWR VPWR _1359_ sky130_fd_sc_hd__and3_1
XFILLER_0_73_600 VGND VGND VPWR VPWR sky130_fd_sc_hd__decap_3
XFILLER_0_9_237 VPWR VGND VPWR VGND sky130_ef_sc_hd__decap_12
X_6752_ _2188_ _2190_ _2191_ VGND VGND VPWR VPWR _2193_ sky130_fd_sc_hd__a21o_1
X_3895_ _0105_ _0116_ VGND VGND VPWR VPWR _0606_ sky130_fd_sc_hd__nand2_1
XFILLER_0_73_644 VGND VGND VPWR VPWR sky130_fd_sc_hd__decap_8
XFILLER_0_73_633 VGND VGND VPWR VPWR sky130_fd_sc_hd__decap_6
X_5703_ _0898_ _0901_ _0899_ VGND VGND VPWR VPWR _1047_ sky130_fd_sc_hd__o21bai_1
X_6683_ _2096_ _2097_ _2116_ _2117_ VGND VGND VPWR VPWR _2118_ sky130_fd_sc_hd__and4bb_2
XFILLER_0_45_335 VGND VGND VPWR VPWR sky130_fd_sc_hd__fill_1
X_5634_ _0961_ _3446_ _0962_ _0968_ _0971_ VGND VGND VPWR VPWR _0972_ sky130_fd_sc_hd__a221o_1
XFILLER_0_60_316 VPWR VGND VPWR VGND sky130_ef_sc_hd__decap_12
XFILLER_0_26_571 VGND VGND VPWR VPWR sky130_fd_sc_hd__fill_2
XFILLER_0_103_429 VPWR VGND VPWR VGND sky130_ef_sc_hd__decap_12
X_7304_ _2794_ _2795_ _2757_ _2595_ VGND VGND VPWR VPWR _2797_ sky130_fd_sc_hd__o211a_1
X_5565_ _0894_ _0895_ VGND VGND VPWR VPWR _0896_ sky130_fd_sc_hd__nor2_1
XFILLER_0_5_498 VGND VGND VPWR VPWR sky130_fd_sc_hd__decap_6
XFILLER_0_79_95 VGND VGND VPWR VPWR sky130_fd_sc_hd__decap_4
X_4516_ _3622_ VGND VGND VPWR VPWR _3623_ sky130_fd_sc_hd__buf_4
X_5496_ _0699_ _0701_ _0819_ _0820_ VGND VGND VPWR VPWR _0821_ sky130_fd_sc_hd__o211a_1
X_4447_ _3394_ _3550_ _3552_ _3555_ _3350_ VGND VGND VPWR VPWR _3556_ sky130_fd_sc_hd__a221o_1
X_7235_ _2719_ _2720_ VGND VGND VPWR VPWR _2721_ sky130_fd_sc_hd__xnor2_1
X_7166_ _2642_ _2643_ _2644_ VGND VGND VPWR VPWR _2646_ sky130_fd_sc_hd__a21o_1
X_4378_ _3485_ _3487_ _3322_ VGND VGND VPWR VPWR _3488_ sky130_fd_sc_hd__mux2_1
X_6117_ _1497_ _1498_ VGND VGND VPWR VPWR _1499_ sky130_fd_sc_hd__or2b_1
X_7097_ _1839_ _1665_ _1293_ _1206_ VGND VGND VPWR VPWR _2570_ sky130_fd_sc_hd__and4_1
X_6048_ net115 _1421_ _1290_ _1395_ VGND VGND VPWR VPWR _1423_ sky130_fd_sc_hd__o211a_1
XFILLER_0_68_405 VPWR VGND VPWR VGND sky130_ef_sc_hd__decap_12
XFILLER_0_49_641 VGND VGND VPWR VPWR sky130_fd_sc_hd__decap_8
XFILLER_0_95_268 VPWR VGND VPWR VGND sky130_ef_sc_hd__decap_12
XFILLER_0_106_212 VGND VGND VPWR VPWR sky130_fd_sc_hd__decap_8
XFILLER_0_24_508 VPWR VGND VPWR VGND sky130_ef_sc_hd__decap_12
XFILLER_0_91_485 VPWR VGND VPWR VGND sky130_ef_sc_hd__decap_12
XFILLER_0_17_571 VPWR VGND VPWR VGND sky130_ef_sc_hd__decap_12
XFILLER_0_106_289 VGND VGND VPWR VPWR sky130_fd_sc_hd__fill_2
XFILLER_0_51_349 VPWR VGND VPWR VGND sky130_ef_sc_hd__decap_12
XFILLER_0_32_596 VPWR VGND VPWR VGND sky130_ef_sc_hd__decap_12
XTAP_TAPCELL_ROW_73_1081 VGND VPWR sky130_fd_sc_hd__tapvpwrvgnd_1
XFILLER_0_59_405 VGND VGND VPWR VPWR sky130_fd_sc_hd__decap_3
XFILLER_0_99_585 VPWR VGND VPWR VGND sky130_ef_sc_hd__decap_12
XFILLER_0_59_449 VPWR VGND VPWR VGND sky130_ef_sc_hd__decap_12
XTAP_TAPCELL_ROW_15_411 VGND VPWR sky130_fd_sc_hd__tapvpwrvgnd_1
XFILLER_0_24_68 VPWR VGND VPWR VGND sky130_ef_sc_hd__decap_12
XTAP_TAPCELL_ROW_43_731 VGND VPWR sky130_fd_sc_hd__tapvpwrvgnd_1
XFILLER_0_82_430 VPWR VGND VPWR VGND sky130_ef_sc_hd__decap_12
XFILLER_0_82_485 VGND VGND VPWR VPWR sky130_fd_sc_hd__decap_4
XFILLER_0_70_636 VGND VGND VPWR VPWR sky130_fd_sc_hd__decap_8
XFILLER_0_42_338 VGND VGND VPWR VPWR sky130_fd_sc_hd__decap_4
XFILLER_0_54_187 VGND VGND VPWR VPWR sky130_fd_sc_hd__decap_3
X_5350_ _0658_ _0659_ _0657_ VGND VGND VPWR VPWR _0662_ sky130_fd_sc_hd__a21bo_1
XFILLER_0_23_552 VGND VGND VPWR VPWR sky130_fd_sc_hd__fill_1
XFILLER_0_23_585 VGND VGND VPWR VPWR sky130_fd_sc_hd__decap_6
X_4301_ _3196_ _3043_ VGND VGND VPWR VPWR _3412_ sky130_fd_sc_hd__nand2_1
X_5281_ _0495_ _0494_ _0586_ _0492_ VGND VGND VPWR VPWR _0587_ sky130_fd_sc_hd__a211o_1
X_4232_ _3323_ _3341_ _3343_ VGND VGND VPWR VPWR _3344_ sky130_fd_sc_hd__mux2_1
X_7020_ _2317_ _2303_ VGND VGND VPWR VPWR _2487_ sky130_fd_sc_hd__or2_1
XFILLER_0_10_268 VGND VGND VPWR VPWR sky130_fd_sc_hd__decap_3
XFILLER_0_10_246 VGND VGND VPWR VPWR sky130_fd_sc_hd__decap_6
XFILLER_0_49_76 VGND VGND VPWR VPWR sky130_fd_sc_hd__decap_4
X_4163_ _1829_ _1785_ VGND VGND VPWR VPWR _3275_ sky130_fd_sc_hd__nand2_4
X_4094_ _2758_ _2769_ VGND VGND VPWR VPWR _2780_ sky130_fd_sc_hd__nand2_2
XTAP_TAPCELL_ROW_87_1239 VGND VPWR sky130_fd_sc_hd__tapvpwrvgnd_1
XFILLER_0_77_213 VGND VGND VPWR VPWR sky130_fd_sc_hd__decap_8
XFILLER_0_81_85 VGND VGND VPWR VPWR sky130_fd_sc_hd__decap_4
XFILLER_0_77_279 VGND VGND VPWR VPWR sky130_fd_sc_hd__fill_1
X_4996_ _3279_ _1861_ _0179_ VGND VGND VPWR VPWR _0276_ sky130_fd_sc_hd__nand3b_1
XFILLER_0_58_460 VGND VGND VPWR VPWR sky130_fd_sc_hd__decap_8
X_6804_ _2583_ _0867_ _1075_ _2681_ VGND VGND VPWR VPWR _2250_ sky130_fd_sc_hd__a22oi_1
XFILLER_0_105_81 VPWR VGND VPWR VGND sky130_ef_sc_hd__decap_12
XFILLER_0_92_249 VGND VGND VPWR VPWR sky130_fd_sc_hd__decap_3
XFILLER_0_73_430 VGND VGND VPWR VPWR sky130_fd_sc_hd__decap_3
X_3947_ _1162_ VGND VGND VPWR VPWR _1173_ sky130_fd_sc_hd__buf_2
XFILLER_0_46_633 VGND VGND VPWR VPWR sky130_fd_sc_hd__decap_6
X_6735_ _2172_ _2173_ VGND VGND VPWR VPWR _2174_ sky130_fd_sc_hd__nand2_1
X_3878_ _0072_ net51 VGND VGND VPWR VPWR _0420_ sky130_fd_sc_hd__and2_1
X_6666_ _1931_ _1939_ VGND VGND VPWR VPWR _2099_ sky130_fd_sc_hd__or2b_1
XTAP_TAPCELL_ROW_98_1368 VGND VPWR sky130_fd_sc_hd__tapvpwrvgnd_1
X_5617_ _3651_ VGND VGND VPWR VPWR _0953_ sky130_fd_sc_hd__clkbuf_4
X_6597_ _1877_ VGND VGND VPWR VPWR _2023_ sky130_fd_sc_hd__inv_2
XFILLER_0_60_157 VPWR VGND VPWR VGND sky130_ef_sc_hd__decap_12
X_5548_ _0860_ _0875_ _0876_ VGND VGND VPWR VPWR _0877_ sky130_fd_sc_hd__and3_1
XFILLER_0_103_259 VGND VGND VPWR VPWR sky130_fd_sc_hd__decap_4
XFILLER_0_41_393 VPWR VGND VPWR VGND sky130_ef_sc_hd__decap_12
X_7218_ _2700_ _2701_ VGND VGND VPWR VPWR _2702_ sky130_fd_sc_hd__xnor2_1
X_5479_ _0673_ _0681_ _0680_ VGND VGND VPWR VPWR _0803_ sky130_fd_sc_hd__a21bo_1
X_7149_ _2612_ _2613_ _2625_ _2626_ VGND VGND VPWR VPWR _2628_ sky130_fd_sc_hd__a211oi_2
XTAP_TAPCELL_ROW_29_569 VGND VPWR sky130_fd_sc_hd__tapvpwrvgnd_1
XTAP_TAPCELL_ROW_107_1464 VGND VPWR sky130_fd_sc_hd__tapvpwrvgnd_1
XTAP_TAPCELL_ROW_57_889 VGND VPWR sky130_fd_sc_hd__tapvpwrvgnd_1
XFILLER_0_68_268 VGND VGND VPWR VPWR sky130_fd_sc_hd__decap_4
XFILLER_0_56_419 VGND VGND VPWR VPWR sky130_fd_sc_hd__fill_1
XTAP_TAPCELL_ROW_40_701 VGND VPWR sky130_fd_sc_hd__tapvpwrvgnd_1
XFILLER_0_36_165 VGND VGND VPWR VPWR sky130_fd_sc_hd__decap_4
XFILLER_0_51_113 VGND VGND VPWR VPWR sky130_fd_sc_hd__decap_3
XFILLER_0_101_39 VPWR VGND VPWR VGND sky130_ef_sc_hd__decap_12
XFILLER_0_10_15 VPWR VGND VPWR VGND sky130_ef_sc_hd__decap_12
XFILLER_0_51_146 VGND VGND VPWR VPWR sky130_fd_sc_hd__decap_3
XFILLER_0_20_533 VPWR VGND VPWR VGND sky130_ef_sc_hd__decap_12
XFILLER_0_19_57 VPWR VGND VPWR VGND sky130_ef_sc_hd__decap_12
XFILLER_0_99_393 VGND VGND VPWR VPWR sky130_fd_sc_hd__decap_4
XFILLER_0_87_533 VGND VGND VPWR VPWR sky130_fd_sc_hd__fill_2
XFILLER_0_87_577 VPWR VGND VPWR VGND sky130_ef_sc_hd__decap_12
X_4850_ _0030_ _0078_ _0079_ VGND VGND VPWR VPWR _0117_ sky130_fd_sc_hd__nand3_1
XFILLER_0_7_505 VGND VGND VPWR VPWR sky130_fd_sc_hd__decap_8
XFILLER_0_51_33 VGND VGND VPWR VPWR sky130_fd_sc_hd__fill_2
X_6520_ _1931_ _1939_ VGND VGND VPWR VPWR _1940_ sky130_fd_sc_hd__xnor2_1
X_4781_ _0040_ _0041_ VGND VGND VPWR VPWR _0042_ sky130_fd_sc_hd__nor2_1
XFILLER_0_51_99 VPWR VGND VPWR VGND sky130_ef_sc_hd__decap_12
XFILLER_0_70_433 VPWR VGND VPWR VGND sky130_ef_sc_hd__decap_12
X_6451_ _1709_ _1710_ VGND VGND VPWR VPWR _1864_ sky130_fd_sc_hd__nand2_1
X_5402_ _2058_ _0376_ _3747_ _3263_ VGND VGND VPWR VPWR _0719_ sky130_fd_sc_hd__o22a_1
XFILLER_0_70_477 VGND VGND VPWR VPWR sky130_fd_sc_hd__fill_2
X_6382_ _1750_ _1788_ _1787_ VGND VGND VPWR VPWR _1789_ sky130_fd_sc_hd__or3_4
XFILLER_0_2_243 VGND VGND VPWR VPWR sky130_fd_sc_hd__decap_8
X_5333_ _0641_ _0642_ VGND VGND VPWR VPWR _0643_ sky130_fd_sc_hd__and2b_1
XFILLER_0_23_371 VPWR VGND VPWR VGND sky130_ef_sc_hd__decap_12
XFILLER_0_23_393 VGND VGND VPWR VPWR sky130_fd_sc_hd__decap_4
XFILLER_0_76_41 VPWR VGND VPWR VGND sky130_ef_sc_hd__decap_12
X_5264_ _0565_ _0566_ _0567_ VGND VGND VPWR VPWR _0568_ sky130_fd_sc_hd__nand3_4
X_4215_ _3324_ _2802_ _3325_ _3326_ _3317_ _3313_ VGND VGND VPWR VPWR _3327_ sky130_fd_sc_hd__mux4_1
X_7003_ _2465_ _2466_ _2291_ _2324_ VGND VGND VPWR VPWR _2468_ sky130_fd_sc_hd__o211a_1
X_5195_ _0490_ _0491_ _0364_ VGND VGND VPWR VPWR _0493_ sky130_fd_sc_hd__o21a_1
X_4146_ _3255_ _3257_ VGND VGND VPWR VPWR _3258_ sky130_fd_sc_hd__nand2_2
XFILLER_0_97_319 VGND VGND VPWR VPWR sky130_fd_sc_hd__fill_1
X_4077_ _2583_ VGND VGND VPWR VPWR _2594_ sky130_fd_sc_hd__inv_2
XTAP_TAPCELL_ROW_26_539 VGND VPWR sky130_fd_sc_hd__tapvpwrvgnd_1
XFILLER_0_38_408 VPWR VGND VPWR VGND sky130_ef_sc_hd__decap_12
XTAP_TAPCELL_ROW_54_859 VGND VPWR sky130_fd_sc_hd__tapvpwrvgnd_1
XFILLER_0_78_599 VPWR VGND VPWR VGND sky130_ef_sc_hd__decap_12
XFILLER_0_19_611 VGND VGND VPWR VPWR sky130_fd_sc_hd__decap_4
X_4979_ _0254_ _0255_ _0233_ VGND VGND VPWR VPWR _0258_ sky130_fd_sc_hd__a21oi_1
X_7698_ net98 net99 net100 _3226_ VGND VGND VPWR VPWR _3227_ sky130_fd_sc_hd__or4_1
X_6718_ _3647_ _2139_ _2140_ _2155_ VGND VGND VPWR VPWR _2156_ sky130_fd_sc_hd__o31a_1
XFILLER_0_33_102 VGND VGND VPWR VPWR sky130_fd_sc_hd__fill_1
XFILLER_0_46_463 VGND VGND VPWR VPWR sky130_fd_sc_hd__fill_1
XFILLER_0_46_474 VGND VGND VPWR VPWR sky130_fd_sc_hd__fill_2
XFILLER_0_61_422 VGND VGND VPWR VPWR sky130_fd_sc_hd__decap_4
X_6649_ _1919_ _1924_ _1918_ VGND VGND VPWR VPWR _2081_ sky130_fd_sc_hd__a21bo_1
XFILLER_0_14_382 VGND VGND VPWR VPWR sky130_fd_sc_hd__decap_8
XTAP_TAPCELL_ROW_70_1040 VGND VPWR sky130_fd_sc_hd__tapvpwrvgnd_1
XTAP_TAPCELL_ROW_109_1504 VGND VPWR sky130_fd_sc_hd__tapvpwrvgnd_1
XFILLER_0_69_533 VPWR VGND VPWR VGND sky130_ef_sc_hd__decap_12
XFILLER_0_96_341 VGND VGND VPWR VPWR sky130_fd_sc_hd__decap_8
XFILLER_0_37_485 VGND VGND VPWR VPWR sky130_fd_sc_hd__decap_6
XFILLER_0_52_411 VGND VGND VPWR VPWR sky130_fd_sc_hd__decap_3
XFILLER_0_21_47 VGND VGND VPWR VPWR sky130_fd_sc_hd__fill_1
XFILLER_0_40_617 VGND VGND VPWR VPWR sky130_fd_sc_hd__decap_8
XFILLER_0_32_190 VGND VGND VPWR VPWR sky130_fd_sc_hd__decap_6
XFILLER_0_20_396 VGND VGND VPWR VPWR sky130_fd_sc_hd__decap_4
X_4000_ _1741_ VGND VGND VPWR VPWR _1752_ sky130_fd_sc_hd__buf_4
X_5951_ _1314_ _1316_ _1317_ VGND VGND VPWR VPWR _1318_ sky130_fd_sc_hd__nand3_1
XFILLER_0_75_503 VGND VGND VPWR VPWR sky130_fd_sc_hd__fill_1
X_4902_ _0084_ _0117_ _0173_ VGND VGND VPWR VPWR _0174_ sky130_fd_sc_hd__a21oi_4
XFILLER_0_1_57 VPWR VGND VPWR VGND sky130_ef_sc_hd__decap_12
XFILLER_0_62_76 VGND VGND VPWR VPWR sky130_fd_sc_hd__decap_8
XFILLER_0_62_65 VGND VGND VPWR VPWR sky130_fd_sc_hd__decap_6
X_5882_ _1113_ _1240_ _1241_ VGND VGND VPWR VPWR _1242_ sky130_fd_sc_hd__a21oi_1
XTAP_TAPCELL_ROW_51_818 VGND VPWR sky130_fd_sc_hd__tapvpwrvgnd_1
X_4833_ _3305_ _3358_ _0096_ _0097_ _0098_ VGND VGND VPWR VPWR _0099_ sky130_fd_sc_hd__o221a_1
X_7621_ _1479_ _0813_ VGND VGND VPWR VPWR _3144_ sky130_fd_sc_hd__nand2_1
X_4764_ _0011_ _0015_ _0023_ _0024_ VGND VGND VPWR VPWR _0025_ sky130_fd_sc_hd__a211o_1
X_7552_ _3013_ _3050_ VGND VGND VPWR VPWR _3068_ sky130_fd_sc_hd__xnor2_1
XFILLER_0_7_357 VGND VGND VPWR VPWR sky130_fd_sc_hd__decap_8
XFILLER_0_16_625 VPWR VGND VPWR VGND sky130_ef_sc_hd__decap_12
X_7483_ _2950_ _2992_ VGND VGND VPWR VPWR _2993_ sky130_fd_sc_hd__xor2_1
XFILLER_0_15_113 VPWR VGND VPWR VGND sky130_ef_sc_hd__decap_12
X_6503_ net152 _3623_ net16 _0987_ VGND VGND VPWR VPWR _1921_ sky130_fd_sc_hd__and4_1
XTAP_TAPCELL_ROW_95_1327 VGND VPWR sky130_fd_sc_hd__tapvpwrvgnd_1
X_4695_ _3710_ _3799_ VGND VGND VPWR VPWR _3800_ sky130_fd_sc_hd__nor2_1
XFILLER_0_3_530 VGND VGND VPWR VPWR sky130_fd_sc_hd__fill_1
X_6434_ _1701_ _1716_ _1717_ VGND VGND VPWR VPWR _1845_ sky130_fd_sc_hd__or3_1
XTAP_TAPCELL_ROW_31_597 VGND VPWR sky130_fd_sc_hd__tapvpwrvgnd_1
XFILLER_0_31_617 VPWR VGND VPWR VGND sky130_ef_sc_hd__decap_12
XFILLER_0_101_505 VPWR VGND VPWR VGND sky130_ef_sc_hd__decap_12
XFILLER_0_60_3 VPWR VGND VPWR VGND sky130_ef_sc_hd__decap_12
X_6365_ _1609_ _1611_ _1608_ VGND VGND VPWR VPWR _1770_ sky130_fd_sc_hd__o21bai_1
X_5316_ _0535_ _0537_ _0623_ VGND VGND VPWR VPWR _0624_ sky130_fd_sc_hd__a21oi_1
X_6296_ _3130_ net43 VGND VGND VPWR VPWR _1694_ sky130_fd_sc_hd__nand2_1
X_5247_ _0542_ _0548_ VGND VGND VPWR VPWR _0549_ sky130_fd_sc_hd__xor2_1
XTAP_TAPCELL_ROW_59_918 VGND VPWR sky130_fd_sc_hd__tapvpwrvgnd_1
X_5178_ _0471_ _0472_ _0461_ VGND VGND VPWR VPWR _0474_ sky130_fd_sc_hd__a21o_1
XFILLER_0_98_628 VPWR VGND VPWR VGND sky130_ef_sc_hd__decap_12
X_4129_ _3152_ VGND VGND VPWR VPWR _3163_ sky130_fd_sc_hd__buf_6
XTAP_TAPCELL_ROW_3_267 VGND VPWR sky130_fd_sc_hd__tapvpwrvgnd_1
XTAP_TAPCELL_ROW_39_686 VGND VPWR sky130_fd_sc_hd__tapvpwrvgnd_1
XTAP_TAPCELL_ROW_104_1434 VGND VPWR sky130_fd_sc_hd__tapvpwrvgnd_1
XFILLER_0_66_547 VPWR VGND VPWR VGND sky130_ef_sc_hd__decap_12
XFILLER_0_66_514 VGND VGND VPWR VPWR sky130_fd_sc_hd__fill_1
XFILLER_0_81_517 VPWR VGND VPWR VGND sky130_ef_sc_hd__decap_12
XFILLER_0_34_433 VGND VGND VPWR VPWR sky130_fd_sc_hd__decap_3
XFILLER_0_46_282 VGND VGND VPWR VPWR sky130_fd_sc_hd__fill_1
XFILLER_0_107_27 VPWR VGND VPWR VGND sky130_ef_sc_hd__decap_12
XFILLER_0_89_617 VPWR VGND VPWR VGND sky130_ef_sc_hd__decap_12
XFILLER_0_57_503 VGND VGND VPWR VPWR sky130_fd_sc_hd__fill_1
XFILLER_0_84_300 VGND VGND VPWR VPWR sky130_fd_sc_hd__decap_8
XFILLER_0_29_249 VGND VGND VPWR VPWR sky130_fd_sc_hd__decap_3
XFILLER_0_37_293 VGND VGND VPWR VPWR sky130_fd_sc_hd__decap_4
XFILLER_0_13_617 VPWR VGND VPWR VGND sky130_ef_sc_hd__decap_12
XFILLER_0_52_263 VGND VGND VPWR VPWR sky130_fd_sc_hd__fill_1
XFILLER_0_107_192 VGND VGND VPWR VPWR sky130_fd_sc_hd__fill_2
X_4480_ _3587_ _3585_ VGND VGND VPWR VPWR _3588_ sky130_fd_sc_hd__xnor2_2
XFILLER_0_12_127 VPWR VGND VPWR VGND sky130_ef_sc_hd__decap_12
XFILLER_0_0_533 VGND VGND VPWR VPWR sky130_fd_sc_hd__fill_1
X_6150_ _3414_ _3196_ _0867_ net44 VGND VGND VPWR VPWR _1535_ sky130_fd_sc_hd__and4_1
X_5101_ _3343_ _3597_ VGND VGND VPWR VPWR _0391_ sky130_fd_sc_hd__nand2_1
XFILLER_0_0_566 VPWR VGND VPWR VGND sky130_ef_sc_hd__decap_12
XTAP_TAPCELL_ROW_90_1268 VGND VPWR sky130_fd_sc_hd__tapvpwrvgnd_1
X_6081_ _1453_ _1459_ VGND VGND VPWR VPWR _1460_ sky130_fd_sc_hd__xnor2_1
X_5032_ _0310_ _0314_ VGND VGND VPWR VPWR _0315_ sky130_fd_sc_hd__xnor2_1
XFILLER_0_73_53 VGND VGND VPWR VPWR sky130_fd_sc_hd__decap_3
XTAP_TAPCELL_ROW_0_226 VGND VPWR sky130_fd_sc_hd__tapvpwrvgnd_1
XFILLER_0_95_609 VGND VGND VPWR VPWR sky130_fd_sc_hd__decap_6
XTAP_TAPCELL_ROW_0_237 VGND VPWR sky130_fd_sc_hd__tapvpwrvgnd_1
XTAP_TAPCELL_ROW_36_645 VGND VPWR sky130_fd_sc_hd__tapvpwrvgnd_1
X_6983_ _2437_ _2445_ VGND VGND VPWR VPWR _2446_ sky130_fd_sc_hd__xor2_1
XTAP_TAPCELL_ROW_64_976 VGND VPWR sky130_fd_sc_hd__tapvpwrvgnd_1
X_5934_ net60 net59 net5 net4 VGND VGND VPWR VPWR _1299_ sky130_fd_sc_hd__and4_1
XTAP_TAPCELL_ROW_36_656 VGND VPWR sky130_fd_sc_hd__tapvpwrvgnd_1
XFILLER_0_48_525 VGND VGND VPWR VPWR sky130_fd_sc_hd__decap_6
X_5865_ _0963_ _1223_ _3482_ VGND VGND VPWR VPWR _1224_ sky130_fd_sc_hd__mux2_1
X_4816_ _0078_ _0030_ _0079_ VGND VGND VPWR VPWR _0080_ sky130_fd_sc_hd__and3_1
X_7604_ _3123_ _3124_ VGND VGND VPWR VPWR _3125_ sky130_fd_sc_hd__nand2_1
XFILLER_0_7_154 VGND VGND VPWR VPWR sky130_fd_sc_hd__decap_8
X_5796_ _1785_ net31 _0093_ _1829_ VGND VGND VPWR VPWR _1148_ sky130_fd_sc_hd__a22o_1
X_4747_ _2419_ _3740_ VGND VGND VPWR VPWR _0008_ sky130_fd_sc_hd__nor2_1
XFILLER_0_71_561 VGND VGND VPWR VPWR sky130_fd_sc_hd__decap_8
X_7535_ _3046_ _3047_ _3049_ VGND VGND VPWR VPWR _3050_ sky130_fd_sc_hd__and3_1
XFILLER_0_16_477 VGND VGND VPWR VPWR sky130_fd_sc_hd__decap_6
XFILLER_0_43_230 VPWR VGND VPWR VGND sky130_ef_sc_hd__decap_12
X_7466_ _2047_ _2091_ _1468_ _0715_ VGND VGND VPWR VPWR _2974_ sky130_fd_sc_hd__and4_1
XFILLER_0_16_499 VGND VGND VPWR VPWR sky130_fd_sc_hd__decap_3
X_4678_ _3690_ _3693_ _3691_ VGND VGND VPWR VPWR _3783_ sky130_fd_sc_hd__a21bo_1
X_7397_ _2892_ _2897_ VGND VGND VPWR VPWR _2898_ sky130_fd_sc_hd__xor2_1
XFILLER_0_98_83 VGND VGND VPWR VPWR sky130_fd_sc_hd__fill_1
X_6417_ _1825_ _1826_ VGND VGND VPWR VPWR _1827_ sky130_fd_sc_hd__nor2_1
XTAP_TAPCELL_ROW_8_326 VGND VPWR sky130_fd_sc_hd__tapvpwrvgnd_1
XFILLER_0_3_382 VGND VGND VPWR VPWR sky130_fd_sc_hd__decap_8
X_6348_ _1602_ _1620_ _1622_ VGND VGND VPWR VPWR _1751_ sky130_fd_sc_hd__nand3_2
XFILLER_0_11_160 VGND VGND VPWR VPWR sky130_fd_sc_hd__fill_1
X_6279_ _1542_ _1541_ VGND VGND VPWR VPWR _1676_ sky130_fd_sc_hd__and2b_1
XFILLER_0_66_344 VGND VGND VPWR VPWR sky130_fd_sc_hd__fill_1
XFILLER_0_39_547 VGND VGND VPWR VPWR sky130_fd_sc_hd__decap_4
XFILLER_0_105_641 VGND VGND VPWR VPWR sky130_fd_sc_hd__decap_8
XFILLER_0_62_594 VGND VGND VPWR VPWR sky130_fd_sc_hd__decap_8
XFILLER_0_22_403 VGND VGND VPWR VPWR sky130_fd_sc_hd__decap_6
XFILLER_0_22_458 VGND VGND VPWR VPWR sky130_fd_sc_hd__fill_1
XFILLER_0_94_19 VGND VGND VPWR VPWR sky130_fd_sc_hd__decap_8
XFILLER_0_27_57 VPWR VGND VPWR VGND sky130_ef_sc_hd__decap_12
XFILLER_0_89_447 VGND VGND VPWR VPWR sky130_fd_sc_hd__fill_1
XFILLER_0_77_609 VGND VGND VPWR VPWR sky130_fd_sc_hd__decap_6
X_3980_ _1523_ VGND VGND VPWR VPWR _1533_ sky130_fd_sc_hd__buf_4
XFILLER_0_97_491 VPWR VGND VPWR VGND sky130_ef_sc_hd__decap_12
XTAP_TAPCELL_ROW_61_935 VGND VPWR sky130_fd_sc_hd__tapvpwrvgnd_1
XTAP_TAPCELL_ROW_33_615 VGND VPWR sky130_fd_sc_hd__tapvpwrvgnd_1
XFILLER_0_84_141 VPWR VGND VPWR VGND sky130_ef_sc_hd__decap_12
XFILLER_0_17_208 VGND VGND VPWR VPWR sky130_fd_sc_hd__fill_1
X_5650_ net25 _2889_ net37 net38 VGND VGND VPWR VPWR _0989_ sky130_fd_sc_hd__and4_1
X_4601_ _3619_ _3639_ _3638_ VGND VGND VPWR VPWR _3707_ sky130_fd_sc_hd__a21oi_2
XTAP_TAPCELL_ROW_13_383 VGND VPWR sky130_fd_sc_hd__tapvpwrvgnd_1
X_5581_ _0910_ _0912_ _0892_ VGND VGND VPWR VPWR _0914_ sky130_fd_sc_hd__a21oi_2
XFILLER_0_53_561 VPWR VGND VPWR VGND sky130_ef_sc_hd__decap_12
X_4532_ _3635_ _3636_ _3637_ VGND VGND VPWR VPWR _3639_ sky130_fd_sc_hd__a21o_1
X_7320_ _2615_ _2623_ VGND VGND VPWR VPWR _2815_ sky130_fd_sc_hd__or2b_1
XFILLER_0_25_263 VGND VGND VPWR VPWR sky130_fd_sc_hd__fill_1
X_4463_ _3364_ _3544_ _3557_ _3568_ _3571_ VGND VGND VPWR VPWR _3572_ sky130_fd_sc_hd__a2111o_1
X_7251_ _1632_ _0998_ _1271_ _1818_ VGND VGND VPWR VPWR _2739_ sky130_fd_sc_hd__a22oi_1
XFILLER_0_4_168 VGND VGND VPWR VPWR sky130_fd_sc_hd__fill_1
XFILLER_0_13_447 VGND VGND VPWR VPWR sky130_fd_sc_hd__fill_1
XFILLER_0_68_42 VPWR VGND VPWR VGND sky130_ef_sc_hd__decap_12
X_6202_ _0332_ _0660_ _1463_ _1462_ _0758_ VGND VGND VPWR VPWR _1592_ sky130_fd_sc_hd__a32o_1
X_7182_ _0431_ _1096_ _3512_ _0420_ VGND VGND VPWR VPWR _2664_ sky130_fd_sc_hd__a22o_1
X_4394_ _3503_ _3290_ _3174_ VGND VGND VPWR VPWR _3504_ sky130_fd_sc_hd__a21o_1
XFILLER_0_68_75 VGND VGND VPWR VPWR sky130_fd_sc_hd__decap_8
XFILLER_0_0_341 VPWR VGND VPWR VGND sky130_ef_sc_hd__decap_12
XPHY_EDGE_ROW_15_Right_15 VGND VGND VPWR VPWR sky130_fd_sc_hd__decap_3
X_6133_ _3300_ _3672_ _0717_ _1516_ VGND VGND VPWR VPWR _1517_ sky130_fd_sc_hd__o211a_1
XFILLER_0_68_97 VPWR VGND VPWR VGND sky130_ef_sc_hd__decap_12
X_6064_ _1523_ _0240_ VGND VGND VPWR VPWR _1441_ sky130_fd_sc_hd__nand2_1
X_5015_ _0274_ _0275_ _0296_ VGND VGND VPWR VPWR _0297_ sky130_fd_sc_hd__a21oi_1
XFILLER_0_23_3 VPWR VGND VPWR VGND sky130_ef_sc_hd__decap_12
XFILLER_0_95_406 VGND VGND VPWR VPWR sky130_fd_sc_hd__fill_1
XFILLER_0_76_620 VGND VGND VPWR VPWR sky130_fd_sc_hd__decap_8
XPHY_EDGE_ROW_24_Right_24 VGND VGND VPWR VPWR sky130_fd_sc_hd__decap_3
X_6966_ _2393_ _2240_ _2425_ _2426_ VGND VGND VPWR VPWR _2427_ sky130_fd_sc_hd__o211a_1
X_5917_ _1555_ _1599_ VGND VGND VPWR VPWR _1280_ sky130_fd_sc_hd__nand2_1
XFILLER_0_91_601 VGND VGND VPWR VPWR sky130_fd_sc_hd__fill_1
XFILLER_0_75_141 VPWR VGND VPWR VGND sky130_ef_sc_hd__decap_12
X_6897_ _2353_ _2506_ _1097_ _0987_ VGND VGND VPWR VPWR _2351_ sky130_fd_sc_hd__and4_1
XFILLER_0_48_377 VPWR VGND VPWR VGND sky130_ef_sc_hd__decap_12
XFILLER_0_106_405 VPWR VGND VPWR VGND sky130_ef_sc_hd__decap_12
X_5848_ _1067_ _1104_ _1203_ _1204_ VGND VGND VPWR VPWR _1205_ sky130_fd_sc_hd__o211ai_4
XFILLER_0_90_133 VGND VGND VPWR VPWR sky130_fd_sc_hd__decap_6
X_5779_ _1112_ _1114_ _1127_ _1128_ VGND VGND VPWR VPWR _1130_ sky130_fd_sc_hd__nand4_4
XFILLER_0_44_550 VGND VGND VPWR VPWR sky130_fd_sc_hd__decap_4
X_7518_ _3017_ _2772_ _3029_ VGND VGND VPWR VPWR _3031_ sky130_fd_sc_hd__nor3_1
XFILLER_0_16_296 VGND VGND VPWR VPWR sky130_fd_sc_hd__decap_4
XFILLER_0_102_622 VPWR VGND VPWR VGND sky130_ef_sc_hd__decap_12
X_7449_ _2397_ _0944_ VGND VGND VPWR VPWR _2956_ sky130_fd_sc_hd__nand2_1
XFILLER_0_31_266 VGND VGND VPWR VPWR sky130_fd_sc_hd__fill_2
XPHY_EDGE_ROW_33_Right_33 VGND VGND VPWR VPWR sky130_fd_sc_hd__decap_3
XFILLER_0_12_480 VPWR VGND VPWR VGND sky130_ef_sc_hd__decap_12
XTAP_TAPCELL_ROW_67_1012 VGND VPWR sky130_fd_sc_hd__tapvpwrvgnd_1
XPHY_EDGE_ROW_42_Right_42 VGND VGND VPWR VPWR sky130_fd_sc_hd__decap_3
XFILLER_0_67_631 VGND VGND VPWR VPWR sky130_fd_sc_hd__decap_3
XFILLER_0_13_15 VPWR VGND VPWR VGND sky130_ef_sc_hd__decap_12
XFILLER_0_109_221 VGND VGND VPWR VPWR sky130_fd_sc_hd__decap_3
XFILLER_0_82_612 VGND VGND VPWR VPWR sky130_fd_sc_hd__decap_4
XFILLER_0_66_141 VGND VGND VPWR VPWR sky130_fd_sc_hd__decap_8
XFILLER_0_27_517 VPWR VGND VPWR VGND sky130_ef_sc_hd__decap_12
XFILLER_0_109_265 VPWR VGND VPWR VGND sky130_ef_sc_hd__decap_12
XFILLER_0_82_645 VGND VGND VPWR VPWR sky130_fd_sc_hd__decap_6
XFILLER_0_54_347 VGND VGND VPWR VPWR sky130_fd_sc_hd__decap_6
XFILLER_0_81_199 VGND VGND VPWR VPWR sky130_fd_sc_hd__decap_8
XFILLER_0_35_561 VPWR VGND VPWR VGND sky130_ef_sc_hd__decap_12
XPHY_EDGE_ROW_51_Right_51 VGND VGND VPWR VPWR sky130_fd_sc_hd__decap_3
XTAP_TAPCELL_ROW_78_1130 VGND VPWR sky130_fd_sc_hd__tapvpwrvgnd_1
XFILLER_0_62_391 VGND VGND VPWR VPWR sky130_fd_sc_hd__fill_1
XTAP_TAPCELL_ROW_10_353 VGND VPWR sky130_fd_sc_hd__tapvpwrvgnd_1
XFILLER_0_1_105 VGND VGND VPWR VPWR sky130_fd_sc_hd__decap_6
XFILLER_0_105_493 VGND VGND VPWR VPWR sky130_fd_sc_hd__decap_8
XFILLER_0_50_564 VGND VGND VPWR VPWR sky130_fd_sc_hd__decap_4
XFILLER_0_38_45 VGND VGND VPWR VPWR sky130_fd_sc_hd__fill_1
XPHY_EDGE_ROW_60_Right_60 VGND VGND VPWR VPWR sky130_fd_sc_hd__decap_3
XFILLER_0_54_22 VGND VGND VPWR VPWR sky130_fd_sc_hd__decap_6
X_6820_ _2080_ _1566_ _1839_ _0704_ VGND VGND VPWR VPWR _2268_ sky130_fd_sc_hd__and4_1
XTAP_TAPCELL_ROW_18_442 VGND VPWR sky130_fd_sc_hd__tapvpwrvgnd_1
XFILLER_0_58_642 VGND VGND VPWR VPWR sky130_fd_sc_hd__fill_2
XFILLER_0_9_205 VGND VGND VPWR VPWR sky130_fd_sc_hd__decap_6
XTAP_TAPCELL_ROW_46_762 VGND VPWR sky130_fd_sc_hd__tapvpwrvgnd_1
XFILLER_0_85_472 VGND VGND VPWR VPWR sky130_fd_sc_hd__fill_2
XFILLER_0_85_461 VGND VGND VPWR VPWR sky130_fd_sc_hd__decap_8
X_3963_ _1326_ _1337_ VGND VGND VPWR VPWR _1348_ sky130_fd_sc_hd__nor2_2
XFILLER_0_9_249 VPWR VGND VPWR VGND sky130_ef_sc_hd__decap_12
X_6751_ _2188_ _2190_ _2191_ VGND VGND VPWR VPWR _2192_ sky130_fd_sc_hd__nand3_1
X_3894_ _0573_ _0584_ VGND VGND VPWR VPWR _0595_ sky130_fd_sc_hd__nand2_2
XFILLER_0_72_122 VGND VGND VPWR VPWR sky130_fd_sc_hd__fill_1
XFILLER_0_70_76 VGND VGND VPWR VPWR sky130_fd_sc_hd__decap_8
X_5702_ _1043_ _1044_ _1041_ VGND VGND VPWR VPWR _1046_ sky130_fd_sc_hd__o21ai_1
X_6682_ _2114_ _2115_ _1901_ _1903_ VGND VGND VPWR VPWR _2117_ sky130_fd_sc_hd__o211ai_1
X_5633_ _0969_ _0970_ VGND VGND VPWR VPWR _0971_ sky130_fd_sc_hd__nand2_1
XFILLER_0_45_347 VPWR VGND VPWR VGND sky130_ef_sc_hd__decap_12
XFILLER_0_60_328 VGND VGND VPWR VPWR sky130_fd_sc_hd__fill_1
X_5564_ _2616_ _1381_ net152 _0758_ VGND VGND VPWR VPWR _0895_ sky130_fd_sc_hd__a22oi_2
X_7303_ _2757_ _2595_ _2794_ _2795_ VGND VGND VPWR VPWR _2796_ sky130_fd_sc_hd__a211oi_1
XFILLER_0_13_211 VGND VGND VPWR VPWR sky130_fd_sc_hd__decap_3
X_4515_ net57 VGND VGND VPWR VPWR _3622_ sky130_fd_sc_hd__clkbuf_4
XFILLER_0_5_477 VGND VGND VPWR VPWR sky130_fd_sc_hd__fill_1
XPHY_EDGE_ROW_103_Right_103 VGND VGND VPWR VPWR sky130_fd_sc_hd__decap_3
X_5495_ _0817_ _0818_ _0624_ VGND VGND VPWR VPWR _0820_ sky130_fd_sc_hd__a21o_1
X_4446_ _3553_ _3447_ _3554_ _3348_ _2944_ VGND VGND VPWR VPWR _3555_ sky130_fd_sc_hd__o221a_1
X_7234_ _1741_ _1107_ VGND VGND VPWR VPWR _2720_ sky130_fd_sc_hd__nand2_1
X_4377_ _3486_ _3375_ _3314_ VGND VGND VPWR VPWR _3487_ sky130_fd_sc_hd__mux2_1
X_7165_ _2642_ _2643_ _2644_ VGND VGND VPWR VPWR _2645_ sky130_fd_sc_hd__and3_1
X_6116_ _1495_ _1496_ _1336_ _1339_ VGND VGND VPWR VPWR _1498_ sky130_fd_sc_hd__a211o_1
X_7096_ _1675_ _1293_ _1206_ _1850_ VGND VGND VPWR VPWR _2569_ sky130_fd_sc_hd__a22oi_1
X_6047_ _1290_ _1395_ net115 _1421_ VGND VGND VPWR VPWR _1422_ sky130_fd_sc_hd__a211oi_2
XFILLER_0_68_417 VGND VGND VPWR VPWR sky130_fd_sc_hd__decap_3
X_6949_ _2399_ _2406_ VGND VGND VPWR VPWR _2409_ sky130_fd_sc_hd__nor2_1
XFILLER_0_48_141 VGND VGND VPWR VPWR sky130_fd_sc_hd__fill_1
XFILLER_0_76_483 VGND VGND VPWR VPWR sky130_fd_sc_hd__fill_1
XFILLER_0_76_472 VGND VGND VPWR VPWR sky130_fd_sc_hd__decap_4
XFILLER_0_63_111 VGND VGND VPWR VPWR sky130_fd_sc_hd__fill_1
XFILLER_0_63_144 VGND VGND VPWR VPWR sky130_fd_sc_hd__decap_6
XFILLER_0_8_271 VGND VGND VPWR VPWR sky130_fd_sc_hd__fill_1
XFILLER_0_91_497 VGND VGND VPWR VPWR sky130_fd_sc_hd__decap_6
XFILLER_0_17_561 VGND VGND VPWR VPWR sky130_fd_sc_hd__fill_2
XFILLER_0_17_583 VPWR VGND VPWR VGND sky130_ef_sc_hd__decap_12
XFILLER_0_44_380 VPWR VGND VPWR VGND sky130_ef_sc_hd__decap_12
XTAP_TAPCELL_ROW_73_1071 VGND VPWR sky130_fd_sc_hd__tapvpwrvgnd_1
XFILLER_0_99_597 VGND VGND VPWR VPWR sky130_fd_sc_hd__fill_1
XTAP_TAPCELL_ROW_15_412 VGND VPWR sky130_fd_sc_hd__tapvpwrvgnd_1
XTAP_TAPCELL_ROW_43_732 VGND VPWR sky130_fd_sc_hd__tapvpwrvgnd_1
XFILLER_0_94_291 VGND VGND VPWR VPWR sky130_fd_sc_hd__decap_6
XFILLER_0_35_391 VGND VGND VPWR VPWR sky130_fd_sc_hd__fill_1
X_4300_ _3298_ _3356_ VGND VGND VPWR VPWR _3411_ sky130_fd_sc_hd__or2_1
XFILLER_0_10_225 VGND VGND VPWR VPWR sky130_fd_sc_hd__decap_8
XFILLER_0_2_469 VGND VGND VPWR VPWR sky130_fd_sc_hd__decap_3
X_5280_ _0583_ _0585_ VGND VGND VPWR VPWR _0586_ sky130_fd_sc_hd__nor2b_1
XFILLER_0_49_33 VGND VGND VPWR VPWR sky130_fd_sc_hd__decap_3
XFILLER_0_49_55 VGND VGND VPWR VPWR sky130_fd_sc_hd__fill_1
X_4231_ _3342_ VGND VGND VPWR VPWR _3343_ sky130_fd_sc_hd__clkbuf_4
X_4162_ _1763_ _1686_ VGND VGND VPWR VPWR _3274_ sky130_fd_sc_hd__nor2_1
XFILLER_0_65_54 VGND VGND VPWR VPWR sky130_fd_sc_hd__fill_2
X_4093_ _2572_ _2638_ VGND VGND VPWR VPWR _2769_ sky130_fd_sc_hd__or2_1
XFILLER_0_81_31 VGND VGND VPWR VPWR sky130_fd_sc_hd__fill_1
XFILLER_0_77_225 VPWR VGND VPWR VGND sky130_ef_sc_hd__decap_12
X_4995_ _0174_ _0273_ _3492_ VGND VGND VPWR VPWR _0275_ sky130_fd_sc_hd__o21a_1
XFILLER_0_46_601 VGND VGND VPWR VPWR sky130_fd_sc_hd__decap_8
X_6803_ _2671_ _2583_ _0867_ net44 VGND VGND VPWR VPWR _2249_ sky130_fd_sc_hd__and4_1
XFILLER_0_105_93 VPWR VGND VPWR VGND sky130_ef_sc_hd__decap_12
X_3946_ net9 VGND VGND VPWR VPWR _1162_ sky130_fd_sc_hd__clkbuf_4
XFILLER_0_45_111 VGND VGND VPWR VPWR sky130_fd_sc_hd__fill_1
X_6734_ _2170_ _2171_ _2165_ VGND VGND VPWR VPWR _2173_ sky130_fd_sc_hd__a21o_1
XFILLER_0_46_645 VGND VGND VPWR VPWR sky130_fd_sc_hd__fill_1
X_3877_ _0366_ _0399_ VGND VGND VPWR VPWR _0409_ sky130_fd_sc_hd__or2b_1
XFILLER_0_90_3 VPWR VGND VPWR VGND sky130_ef_sc_hd__decap_12
XFILLER_0_73_464 VGND VGND VPWR VPWR sky130_fd_sc_hd__fill_1
X_6665_ _1932_ _1937_ VGND VGND VPWR VPWR _2098_ sky130_fd_sc_hd__or2b_1
XFILLER_0_103_205 VGND VGND VPWR VPWR sky130_fd_sc_hd__decap_3
XTAP_TAPCELL_ROW_98_1369 VGND VPWR sky130_fd_sc_hd__tapvpwrvgnd_1
XTAP_TAPCELL_ROW_98_1358 VGND VPWR sky130_fd_sc_hd__tapvpwrvgnd_1
X_5616_ _0726_ _0839_ _0846_ VGND VGND VPWR VPWR _0952_ sky130_fd_sc_hd__a21oi_1
XFILLER_0_5_263 VGND VGND VPWR VPWR sky130_fd_sc_hd__fill_2
X_6596_ _2006_ _2021_ VGND VGND VPWR VPWR _2022_ sky130_fd_sc_hd__xnor2_1
X_5547_ _0868_ _0869_ _0874_ VGND VGND VPWR VPWR _0876_ sky130_fd_sc_hd__o21bai_1
X_5478_ _0799_ _0798_ _0790_ VGND VGND VPWR VPWR _0801_ sky130_fd_sc_hd__a21o_1
X_4429_ _3425_ _3427_ _3311_ VGND VGND VPWR VPWR _3538_ sky130_fd_sc_hd__mux2_2
X_7217_ _3310_ net20 VGND VGND VPWR VPWR _2701_ sky130_fd_sc_hd__nand2_1
X_7148_ _2614_ _2407_ _2624_ VGND VGND VPWR VPWR _2626_ sky130_fd_sc_hd__nor3_1
X_7079_ _2542_ _2549_ VGND VGND VPWR VPWR _2551_ sky130_fd_sc_hd__and2_1
XTAP_TAPCELL_ROW_107_1465 VGND VPWR sky130_fd_sc_hd__tapvpwrvgnd_1
XFILLER_0_96_589 VGND VGND VPWR VPWR sky130_fd_sc_hd__decap_8
XFILLER_0_83_206 VGND VGND VPWR VPWR sky130_fd_sc_hd__decap_4
XFILLER_0_49_461 VGND VGND VPWR VPWR sky130_fd_sc_hd__decap_8
XTAP_TAPCELL_ROW_40_702 VGND VPWR sky130_fd_sc_hd__tapvpwrvgnd_1
XFILLER_0_107_533 VPWR VGND VPWR VGND sky130_ef_sc_hd__decap_12
XFILLER_0_36_177 VPWR VGND VPWR VGND sky130_ef_sc_hd__decap_12
XFILLER_0_10_27 VGND VGND VPWR VPWR sky130_fd_sc_hd__fill_1
XTAP_TAPCELL_ROW_75_1100 VGND VPWR sky130_fd_sc_hd__tapvpwrvgnd_1
XTAP_TAPCELL_ROW_20_470 VGND VPWR sky130_fd_sc_hd__tapvpwrvgnd_1
XFILLER_0_51_169 VGND VGND VPWR VPWR sky130_fd_sc_hd__decap_8
XFILLER_0_32_372 VGND VGND VPWR VPWR sky130_fd_sc_hd__decap_3
XFILLER_0_20_545 VPWR VGND VPWR VGND sky130_ef_sc_hd__decap_12
XFILLER_0_19_36 VPWR VGND VPWR VGND sky130_ef_sc_hd__decap_12
XFILLER_0_20_589 VPWR VGND VPWR VGND sky130_ef_sc_hd__decap_12
XFILLER_0_19_69 VPWR VGND VPWR VGND sky130_ef_sc_hd__decap_12
XFILLER_0_35_57 VPWR VGND VPWR VGND sky130_ef_sc_hd__decap_12
XFILLER_0_59_225 VGND VGND VPWR VPWR sky130_fd_sc_hd__decap_3
XFILLER_0_87_589 VPWR VGND VPWR VGND sky130_ef_sc_hd__decap_12
XFILLER_0_28_601 VPWR VGND VPWR VGND sky130_ef_sc_hd__decap_12
XFILLER_0_27_111 VGND VGND VPWR VPWR sky130_fd_sc_hd__fill_1
X_4780_ _2911_ _3152_ _3809_ _3810_ VGND VGND VPWR VPWR _0041_ sky130_fd_sc_hd__and4_1
XFILLER_0_27_144 VPWR VGND VPWR VGND sky130_ef_sc_hd__decap_12
XFILLER_0_28_645 VGND VGND VPWR VPWR sky130_fd_sc_hd__decap_6
XFILLER_0_70_445 VGND VGND VPWR VPWR sky130_fd_sc_hd__decap_8
XFILLER_0_55_497 VGND VGND VPWR VPWR sky130_fd_sc_hd__decap_6
X_6450_ _1860_ _1862_ VGND VGND VPWR VPWR _1863_ sky130_fd_sc_hd__or2_1
X_5401_ _2058_ _2091_ VGND VGND VPWR VPWR _0718_ sky130_fd_sc_hd__nor2_1
X_6381_ _1786_ _1784_ _1620_ _1751_ VGND VGND VPWR VPWR _1788_ sky130_fd_sc_hd__o211a_1
XFILLER_0_30_309 VPWR VGND VPWR VGND sky130_ef_sc_hd__decap_12
X_5332_ net27 _1785_ _0093_ net28 VGND VGND VPWR VPWR _0642_ sky130_fd_sc_hd__a22o_1
XFILLER_0_23_383 VGND VGND VPWR VPWR sky130_fd_sc_hd__fill_2
XFILLER_0_50_191 VGND VGND VPWR VPWR sky130_fd_sc_hd__decap_4
XFILLER_0_11_578 VGND VGND VPWR VPWR sky130_fd_sc_hd__decap_8
X_5263_ _0461_ _0472_ _0471_ VGND VGND VPWR VPWR _0567_ sky130_fd_sc_hd__a21bo_1
X_4214_ _2397_ VGND VGND VPWR VPWR _3326_ sky130_fd_sc_hd__buf_2
XFILLER_0_76_53 VPWR VGND VPWR VGND sky130_ef_sc_hd__decap_12
X_7002_ _2291_ _2324_ _2465_ _2466_ VGND VGND VPWR VPWR _2467_ sky130_fd_sc_hd__a211oi_4
X_5194_ _0364_ _0490_ _0491_ VGND VGND VPWR VPWR _0492_ sky130_fd_sc_hd__nor3_2
XFILLER_0_76_97 VPWR VGND VPWR VGND sky130_ef_sc_hd__decap_12
X_4145_ _1960_ _3256_ VGND VGND VPWR VPWR _3257_ sky130_fd_sc_hd__or2_1
XFILLER_0_92_41 VGND VGND VPWR VPWR sky130_fd_sc_hd__fill_1
X_4076_ _2572_ VGND VGND VPWR VPWR _2583_ sky130_fd_sc_hd__clkbuf_4
XFILLER_0_78_589 VGND VGND VPWR VPWR sky130_fd_sc_hd__decap_6
X_4978_ _0233_ _0254_ _0255_ VGND VGND VPWR VPWR _0256_ sky130_fd_sc_hd__and3_1
X_3929_ _0955_ _0966_ VGND VGND VPWR VPWR _0976_ sky130_fd_sc_hd__nand2b_2
X_7697_ net69 net96 net97 _3225_ VGND VGND VPWR VPWR _3226_ sky130_fd_sc_hd__or4_1
X_6717_ _0596_ _2143_ _2147_ _2154_ VGND VGND VPWR VPWR _2155_ sky130_fd_sc_hd__o211a_1
XFILLER_0_34_604 VGND VGND VPWR VPWR sky130_fd_sc_hd__decap_3
XFILLER_0_6_561 VGND VGND VPWR VPWR sky130_fd_sc_hd__fill_1
X_6648_ _2071_ _2072_ _2077_ VGND VGND VPWR VPWR _2079_ sky130_fd_sc_hd__a21o_1
XFILLER_0_61_456 VPWR VGND VPWR VGND sky130_ef_sc_hd__decap_12
XFILLER_0_21_309 VGND VGND VPWR VPWR sky130_fd_sc_hd__fill_1
XFILLER_0_33_147 VGND VGND VPWR VPWR sky130_fd_sc_hd__decap_6
X_6579_ _1832_ _1842_ VGND VGND VPWR VPWR _2004_ sky130_fd_sc_hd__and2_1
XTAP_TAPCELL_ROW_70_1041 VGND VPWR sky130_fd_sc_hd__tapvpwrvgnd_1
XTAP_TAPCELL_ROW_109_1505 VGND VPWR sky130_fd_sc_hd__tapvpwrvgnd_1
XFILLER_0_69_512 VGND VGND VPWR VPWR sky130_fd_sc_hd__decap_3
XFILLER_0_69_545 VPWR VGND VPWR VGND sky130_ef_sc_hd__decap_12
XFILLER_0_84_548 VPWR VGND VPWR VGND sky130_ef_sc_hd__decap_12
XFILLER_0_84_537 VGND VGND VPWR VPWR sky130_fd_sc_hd__fill_1
XTAP_TAPCELL_ROW_81_1170 VGND VPWR sky130_fd_sc_hd__tapvpwrvgnd_1
XFILLER_0_21_15 VPWR VGND VPWR VGND sky130_ef_sc_hd__decap_12
XFILLER_0_107_363 VGND VGND VPWR VPWR sky130_fd_sc_hd__fill_2
XFILLER_0_24_136 VGND VGND VPWR VPWR sky130_fd_sc_hd__decap_4
XFILLER_0_37_497 VGND VGND VPWR VPWR sky130_fd_sc_hd__decap_6
XFILLER_0_97_19 VPWR VGND VPWR VGND sky130_ef_sc_hd__decap_12
XFILLER_0_12_309 VGND VGND VPWR VPWR sky130_fd_sc_hd__decap_6
XFILLER_0_103_580 VPWR VGND VPWR VGND sky130_ef_sc_hd__decap_12
X_5950_ _1176_ _1178_ _1177_ VGND VGND VPWR VPWR _1317_ sky130_fd_sc_hd__o21bai_1
X_4901_ _0171_ _0172_ VGND VGND VPWR VPWR _0173_ sky130_fd_sc_hd__xnor2_1
XFILLER_0_1_69 VPWR VGND VPWR VGND sky130_ef_sc_hd__decap_12
X_7620_ _3316_ _0813_ _2975_ _2974_ VGND VGND VPWR VPWR _3143_ sky130_fd_sc_hd__a31o_1
X_5881_ net11 _2889_ _1282_ _1195_ VGND VGND VPWR VPWR _1241_ sky130_fd_sc_hd__and4_1
XTAP_TAPCELL_ROW_51_819 VGND VPWR sky130_fd_sc_hd__tapvpwrvgnd_1
X_4832_ _3274_ _3405_ VGND VGND VPWR VPWR _0098_ sky130_fd_sc_hd__or2_1
X_4763_ _3536_ _0017_ _3611_ VGND VGND VPWR VPWR _0024_ sky130_fd_sc_hd__a21oi_1
X_7551_ _2877_ _3052_ VGND VGND VPWR VPWR _3067_ sky130_fd_sc_hd__nand2_1
X_7482_ _2951_ _2991_ VGND VGND VPWR VPWR _2992_ sky130_fd_sc_hd__xor2_1
X_4694_ _3797_ _3798_ VGND VGND VPWR VPWR _3799_ sky130_fd_sc_hd__nand2_1
XFILLER_0_15_125 VGND VGND VPWR VPWR sky130_fd_sc_hd__fill_1
XFILLER_0_16_637 VGND VGND VPWR VPWR sky130_fd_sc_hd__decap_6
X_6502_ _3449_ net16 _0987_ _3623_ VGND VGND VPWR VPWR _1920_ sky130_fd_sc_hd__a22oi_2
XFILLER_0_70_253 VPWR VGND VPWR VGND sky130_ef_sc_hd__decap_12
XFILLER_0_15_169 VPWR VGND VPWR VGND sky130_ef_sc_hd__decap_12
X_6433_ _1716_ VGND VGND VPWR VPWR _1844_ sky130_fd_sc_hd__inv_2
XTAP_TAPCELL_ROW_31_598 VGND VPWR sky130_fd_sc_hd__tapvpwrvgnd_1
XTAP_TAPCELL_ROW_95_1328 VGND VPWR sky130_fd_sc_hd__tapvpwrvgnd_1
XFILLER_0_70_297 VGND VGND VPWR VPWR sky130_fd_sc_hd__decap_3
XFILLER_0_30_106 VGND VGND VPWR VPWR sky130_fd_sc_hd__fill_2
XFILLER_0_31_629 VPWR VGND VPWR VGND sky130_ef_sc_hd__decap_12
XFILLER_0_101_517 VPWR VGND VPWR VGND sky130_ef_sc_hd__decap_12
X_6364_ _1765_ _1766_ _1767_ VGND VGND VPWR VPWR _1769_ sky130_fd_sc_hd__o21ai_1
XFILLER_0_23_180 VGND VGND VPWR VPWR sky130_fd_sc_hd__fill_1
XFILLER_0_11_375 VPWR VGND VPWR VGND sky130_ef_sc_hd__decap_12
X_5315_ _0621_ _0622_ VGND VGND VPWR VPWR _0623_ sky130_fd_sc_hd__xnor2_1
X_6295_ _1691_ _1692_ VGND VGND VPWR VPWR _1693_ sky130_fd_sc_hd__and2b_1
X_5246_ _0543_ _0547_ VGND VGND VPWR VPWR _0548_ sky130_fd_sc_hd__xnor2_1
XFILLER_0_53_3 VGND VGND VPWR VPWR sky130_fd_sc_hd__fill_2
XPHY_EDGE_ROW_89_Right_89 VGND VGND VPWR VPWR sky130_fd_sc_hd__decap_3
XTAP_TAPCELL_ROW_59_919 VGND VPWR sky130_fd_sc_hd__tapvpwrvgnd_1
X_5177_ _0461_ _0471_ _0472_ VGND VGND VPWR VPWR _0473_ sky130_fd_sc_hd__nand3_1
XFILLER_0_97_106 VGND VGND VPWR VPWR sky130_fd_sc_hd__decap_6
XTAP_TAPCELL_ROW_3_268 VGND VPWR sky130_fd_sc_hd__tapvpwrvgnd_1
X_4128_ _2889_ VGND VGND VPWR VPWR _3152_ sky130_fd_sc_hd__clkbuf_4
XTAP_TAPCELL_ROW_39_687 VGND VPWR sky130_fd_sc_hd__tapvpwrvgnd_1
X_4059_ _2386_ VGND VGND VPWR VPWR _2397_ sky130_fd_sc_hd__clkbuf_4
XFILLER_0_78_353 VGND VGND VPWR VPWR sky130_fd_sc_hd__decap_3
XTAP_TAPCELL_ROW_104_1435 VGND VPWR sky130_fd_sc_hd__tapvpwrvgnd_1
XFILLER_0_93_301 VGND VGND VPWR VPWR sky130_fd_sc_hd__decap_8
XFILLER_0_78_386 VPWR VGND VPWR VGND sky130_ef_sc_hd__decap_12
XFILLER_0_109_617 VPWR VGND VPWR VGND sky130_ef_sc_hd__decap_12
XPHY_EDGE_ROW_98_Right_98 VGND VGND VPWR VPWR sky130_fd_sc_hd__decap_3
XFILLER_0_93_345 VGND VGND VPWR VPWR sky130_fd_sc_hd__decap_3
XFILLER_0_66_559 VPWR VGND VPWR VGND sky130_ef_sc_hd__decap_12
XFILLER_0_81_529 VGND VGND VPWR VPWR sky130_fd_sc_hd__decap_4
XFILLER_0_21_139 VGND VGND VPWR VPWR sky130_fd_sc_hd__decap_4
XFILLER_0_30_640 VGND VGND VPWR VPWR sky130_fd_sc_hd__decap_4
XFILLER_0_30_651 VGND VGND VPWR VPWR sky130_fd_sc_hd__fill_1
XFILLER_0_107_39 VPWR VGND VPWR VGND sky130_ef_sc_hd__decap_12
XFILLER_0_89_629 VPWR VGND VPWR VGND sky130_ef_sc_hd__decap_12
XFILLER_0_88_106 VGND VGND VPWR VPWR sky130_fd_sc_hd__fill_1
XFILLER_0_16_15 VPWR VGND VPWR VGND sky130_ef_sc_hd__decap_12
XFILLER_0_57_537 VGND VGND VPWR VPWR sky130_fd_sc_hd__fill_1
XFILLER_0_25_401 VPWR VGND VPWR VGND sky130_ef_sc_hd__decap_12
XFILLER_0_32_69 VGND VGND VPWR VPWR sky130_fd_sc_hd__fill_1
XFILLER_0_44_209 VPWR VGND VPWR VGND sky130_ef_sc_hd__decap_12
XFILLER_0_80_551 VPWR VGND VPWR VGND sky130_ef_sc_hd__decap_12
XFILLER_0_52_242 VGND VGND VPWR VPWR sky130_fd_sc_hd__decap_8
XFILLER_0_107_182 VGND VGND VPWR VPWR sky130_fd_sc_hd__fill_1
XFILLER_0_13_629 VPWR VGND VPWR VGND sky130_ef_sc_hd__decap_12
XFILLER_0_12_139 VGND VGND VPWR VPWR sky130_fd_sc_hd__fill_1
XFILLER_0_0_501 VGND VGND VPWR VPWR sky130_fd_sc_hd__decap_3
X_5100_ _3343_ VGND VGND VPWR VPWR _0390_ sky130_fd_sc_hd__clkbuf_4
X_6080_ _1456_ _1458_ VGND VGND VPWR VPWR _1459_ sky130_fd_sc_hd__xnor2_1
XFILLER_0_0_578 VGND VGND VPWR VPWR sky130_fd_sc_hd__decap_8
XFILLER_0_0_589 VPWR VGND VPWR VGND sky130_ef_sc_hd__decap_12
XTAP_TAPCELL_ROW_90_1269 VGND VPWR sky130_fd_sc_hd__tapvpwrvgnd_1
X_5031_ _0312_ _0313_ VGND VGND VPWR VPWR _0314_ sky130_fd_sc_hd__nor2_1
XTAP_TAPCELL_ROW_0_227 VGND VPWR sky130_fd_sc_hd__tapvpwrvgnd_1
XFILLER_0_88_651 VGND VGND VPWR VPWR sky130_fd_sc_hd__fill_1
XTAP_TAPCELL_ROW_0_238 VGND VPWR sky130_fd_sc_hd__tapvpwrvgnd_1
X_6982_ _2438_ _2444_ VGND VGND VPWR VPWR _2445_ sky130_fd_sc_hd__xnor2_1
XTAP_TAPCELL_ROW_64_977 VGND VPWR sky130_fd_sc_hd__tapvpwrvgnd_1
X_5933_ _2452_ net5 _0457_ _3748_ VGND VGND VPWR VPWR _1298_ sky130_fd_sc_hd__a22oi_1
XTAP_TAPCELL_ROW_36_646 VGND VPWR sky130_fd_sc_hd__tapvpwrvgnd_1
X_5864_ _3376_ _1184_ _3360_ VGND VGND VPWR VPWR _1223_ sky130_fd_sc_hd__mux2_1
XFILLER_0_8_601 VPWR VGND VPWR VGND sky130_ef_sc_hd__decap_12
XFILLER_0_75_389 VGND VGND VPWR VPWR sky130_fd_sc_hd__decap_3
X_4815_ _3797_ _3842_ _0076_ _0077_ VGND VGND VPWR VPWR _0079_ sky130_fd_sc_hd__o22ai_2
X_7603_ _3305_ _0878_ _1086_ _1872_ VGND VGND VPWR VPWR _3124_ sky130_fd_sc_hd__a22o_1
XFILLER_0_8_645 VGND VGND VPWR VPWR sky130_fd_sc_hd__decap_6
X_7534_ _2842_ _2843_ _3048_ VGND VGND VPWR VPWR _3049_ sky130_fd_sc_hd__a21o_1
X_5795_ _1523_ net129 VGND VGND VPWR VPWR _1147_ sky130_fd_sc_hd__nand2_1
XFILLER_0_28_294 VGND VGND VPWR VPWR sky130_fd_sc_hd__fill_1
X_4746_ _2408_ _3679_ _3739_ _0006_ _3273_ VGND VGND VPWR VPWR _0007_ sky130_fd_sc_hd__o311ai_4
XFILLER_0_43_242 VGND VGND VPWR VPWR sky130_fd_sc_hd__decap_8
X_7465_ _1468_ _0715_ VGND VGND VPWR VPWR _2973_ sky130_fd_sc_hd__nand2_1
XFILLER_0_31_415 VGND VGND VPWR VPWR sky130_fd_sc_hd__fill_2
XFILLER_0_43_264 VPWR VGND VPWR VGND sky130_ef_sc_hd__decap_12
X_4677_ _3779_ _3780_ _3778_ VGND VGND VPWR VPWR _3782_ sky130_fd_sc_hd__o21ai_1
X_7396_ _2895_ _2896_ VGND VGND VPWR VPWR _2897_ sky130_fd_sc_hd__xnor2_1
XFILLER_0_98_73 VGND VGND VPWR VPWR sky130_fd_sc_hd__fill_1
X_6416_ _0900_ _0976_ _1655_ _0953_ VGND VGND VPWR VPWR _1826_ sky130_fd_sc_hd__a31o_1
XFILLER_0_3_361 VGND VGND VPWR VPWR sky130_fd_sc_hd__fill_1
XTAP_TAPCELL_ROW_8_327 VGND VPWR sky130_fd_sc_hd__tapvpwrvgnd_1
X_6347_ _1748_ _1749_ VGND VGND VPWR VPWR _1750_ sky130_fd_sc_hd__nand2_1
XFILLER_0_101_358 VGND VGND VPWR VPWR sky130_fd_sc_hd__fill_1
X_6278_ _1543_ VGND VGND VPWR VPWR _1674_ sky130_fd_sc_hd__inv_2
X_5229_ _0527_ _0528_ VGND VGND VPWR VPWR _0530_ sky130_fd_sc_hd__nor2_1
XFILLER_0_98_426 VGND VGND VPWR VPWR sky130_fd_sc_hd__decap_4
XFILLER_0_79_651 VGND VGND VPWR VPWR sky130_fd_sc_hd__fill_1
XFILLER_0_85_109 VGND VGND VPWR VPWR sky130_fd_sc_hd__decap_3
XFILLER_0_94_643 VGND VGND VPWR VPWR sky130_fd_sc_hd__fill_1
XFILLER_0_39_559 VGND VGND VPWR VPWR sky130_fd_sc_hd__fill_1
XFILLER_0_109_447 VGND VGND VPWR VPWR sky130_fd_sc_hd__fill_1
XFILLER_0_109_436 VGND VGND VPWR VPWR sky130_fd_sc_hd__fill_1
XFILLER_0_19_250 VGND VGND VPWR VPWR sky130_fd_sc_hd__decap_3
XFILLER_0_81_337 VPWR VGND VPWR VGND sky130_ef_sc_hd__decap_12
XFILLER_0_81_315 VPWR VGND VPWR VGND sky130_ef_sc_hd__decap_12
XFILLER_0_22_415 VGND VGND VPWR VPWR sky130_fd_sc_hd__decap_4
XFILLER_0_34_253 VGND VGND VPWR VPWR sky130_fd_sc_hd__decap_6
XFILLER_0_27_36 VGND VGND VPWR VPWR sky130_fd_sc_hd__decap_4
XFILLER_0_27_69 VGND VGND VPWR VPWR sky130_fd_sc_hd__decap_8
XFILLER_0_97_470 VGND VGND VPWR VPWR sky130_fd_sc_hd__decap_8
XFILLER_0_76_109 VGND VGND VPWR VPWR sky130_fd_sc_hd__decap_4
XFILLER_0_85_632 VPWR VGND VPWR VGND sky130_ef_sc_hd__decap_12
XTAP_TAPCELL_ROW_61_936 VGND VPWR sky130_fd_sc_hd__tapvpwrvgnd_1
XFILLER_0_57_334 VGND VGND VPWR VPWR sky130_fd_sc_hd__fill_2
XFILLER_0_9_409 VPWR VGND VPWR VGND sky130_ef_sc_hd__decap_12
XTAP_TAPCELL_ROW_33_616 VGND VPWR sky130_fd_sc_hd__tapvpwrvgnd_1
XFILLER_0_43_57 VGND VGND VPWR VPWR sky130_fd_sc_hd__decap_4
XFILLER_0_84_197 VGND VGND VPWR VPWR sky130_fd_sc_hd__decap_6
XFILLER_0_84_175 VPWR VGND VPWR VGND sky130_ef_sc_hd__decap_12
X_4600_ _3704_ _3705_ VGND VGND VPWR VPWR _3706_ sky130_fd_sc_hd__nor2_1
XFILLER_0_5_604 VPWR VGND VPWR VGND sky130_ef_sc_hd__decap_12
XFILLER_0_38_581 VGND VGND VPWR VPWR sky130_fd_sc_hd__decap_3
XTAP_TAPCELL_ROW_13_384 VGND VPWR sky130_fd_sc_hd__tapvpwrvgnd_1
X_5580_ _0912_ _0910_ _0892_ VGND VGND VPWR VPWR _0913_ sky130_fd_sc_hd__and3_1
X_4531_ _3635_ _3636_ _3637_ VGND VGND VPWR VPWR _3638_ sky130_fd_sc_hd__and3_1
XFILLER_0_25_275 VGND VGND VPWR VPWR sky130_fd_sc_hd__decap_4
XFILLER_0_53_573 VPWR VGND VPWR VGND sky130_ef_sc_hd__decap_12
X_4462_ _3141_ _3569_ _3570_ _3403_ VGND VGND VPWR VPWR _3571_ sky130_fd_sc_hd__o211a_1
X_7250_ _2735_ _2737_ VGND VGND VPWR VPWR _2738_ sky130_fd_sc_hd__xnor2_2
XFILLER_0_7_57 VPWR VGND VPWR VGND sky130_ef_sc_hd__decap_12
X_6201_ _1381_ _1730_ _1456_ _1455_ VGND VGND VPWR VPWR _1591_ sky130_fd_sc_hd__a31o_1
X_7181_ _0392_ _2661_ _2662_ VGND VGND VPWR VPWR _2663_ sky130_fd_sc_hd__o21a_1
X_4393_ _3331_ _3391_ VGND VGND VPWR VPWR _3503_ sky130_fd_sc_hd__nand2_1
XFILLER_0_68_54 VPWR VGND VPWR VGND sky130_ef_sc_hd__decap_12
XFILLER_0_0_353 VGND VGND VPWR VPWR sky130_fd_sc_hd__decap_6
X_6132_ _1140_ _1094_ _1513_ _0097_ _1515_ VGND VGND VPWR VPWR _1516_ sky130_fd_sc_hd__o221a_1
X_6063_ _1438_ _1439_ VGND VGND VPWR VPWR _1440_ sky130_fd_sc_hd__nor2_1
X_5014_ _3364_ _0276_ _0277_ _0295_ VGND VGND VPWR VPWR _0296_ sky130_fd_sc_hd__a31o_1
XFILLER_0_16_3 VPWR VGND VPWR VGND sky130_ef_sc_hd__decap_12
XFILLER_0_48_301 VGND VGND VPWR VPWR sky130_fd_sc_hd__decap_6
X_6965_ _2423_ _2424_ _2410_ VGND VGND VPWR VPWR _2426_ sky130_fd_sc_hd__a21bo_1
XFILLER_0_76_643 VGND VGND VPWR VPWR sky130_fd_sc_hd__fill_1
X_5916_ _1277_ _1278_ VGND VGND VPWR VPWR _1279_ sky130_fd_sc_hd__xnor2_2
XFILLER_0_48_334 VGND VGND VPWR VPWR sky130_fd_sc_hd__fill_2
XFILLER_0_75_153 VPWR VGND VPWR VGND sky130_ef_sc_hd__decap_12
X_6896_ _2194_ _2197_ _2195_ VGND VGND VPWR VPWR _2350_ sky130_fd_sc_hd__o21ba_1
X_5847_ _1202_ _1201_ _1106_ VGND VGND VPWR VPWR _1204_ sky130_fd_sc_hd__o21ai_2
XFILLER_0_48_389 VPWR VGND VPWR VGND sky130_ef_sc_hd__decap_12
XFILLER_0_106_417 VGND VGND VPWR VPWR sky130_fd_sc_hd__decap_3
XFILLER_0_16_242 VGND VGND VPWR VPWR sky130_fd_sc_hd__decap_8
X_5778_ _1115_ _1116_ _1126_ VGND VGND VPWR VPWR _1128_ sky130_fd_sc_hd__nand3_2
X_7517_ _3017_ _2772_ _3029_ VGND VGND VPWR VPWR _3030_ sky130_fd_sc_hd__o21a_1
XFILLER_0_16_264 VPWR VGND VPWR VGND sky130_ef_sc_hd__decap_12
X_4729_ _3829_ _3830_ _3831_ VGND VGND VPWR VPWR _3833_ sky130_fd_sc_hd__a21oi_1
X_7448_ _1086_ _2952_ _2953_ VGND VGND VPWR VPWR _2954_ sky130_fd_sc_hd__a21bo_1
XFILLER_0_102_645 VGND VGND VPWR VPWR sky130_fd_sc_hd__decap_6
XFILLER_0_102_634 VGND VGND VPWR VPWR sky130_fd_sc_hd__decap_8
XFILLER_0_101_155 VGND VGND VPWR VPWR sky130_fd_sc_hd__decap_4
XFILLER_0_101_144 VGND VGND VPWR VPWR sky130_fd_sc_hd__decap_8
X_7379_ _2799_ _2800_ VGND VGND VPWR VPWR _2879_ sky130_fd_sc_hd__or2b_1
XFILLER_0_12_470 VGND VGND VPWR VPWR sky130_fd_sc_hd__fill_1
XFILLER_0_98_234 VGND VGND VPWR VPWR sky130_fd_sc_hd__decap_4
XTAP_TAPCELL_ROW_67_1002 VGND VPWR sky130_fd_sc_hd__tapvpwrvgnd_1
XFILLER_0_86_418 VGND VGND VPWR VPWR sky130_fd_sc_hd__fill_2
XFILLER_0_58_109 VGND VGND VPWR VPWR sky130_fd_sc_hd__decap_8
XFILLER_0_104_29 VPWR VGND VPWR VGND sky130_ef_sc_hd__decap_12
XFILLER_0_13_27 VPWR VGND VPWR VGND sky130_ef_sc_hd__decap_12
XPHY_EDGE_ROW_17_Left_127 VGND VGND VPWR VPWR sky130_fd_sc_hd__decap_3
XFILLER_0_94_495 VPWR VGND VPWR VGND sky130_ef_sc_hd__decap_12
XFILLER_0_81_101 VGND VGND VPWR VPWR sky130_fd_sc_hd__decap_8
XFILLER_0_66_197 VPWR VGND VPWR VGND sky130_ef_sc_hd__decap_12
XFILLER_0_27_529 VGND VGND VPWR VPWR sky130_fd_sc_hd__decap_3
XFILLER_0_109_277 VGND VGND VPWR VPWR sky130_fd_sc_hd__decap_3
XFILLER_0_81_156 VGND VGND VPWR VPWR sky130_fd_sc_hd__fill_1
XFILLER_0_54_359 VGND VGND VPWR VPWR sky130_fd_sc_hd__decap_4
XFILLER_0_35_573 VGND VGND VPWR VPWR sky130_fd_sc_hd__decap_8
XFILLER_0_105_461 VPWR VGND VPWR VGND sky130_ef_sc_hd__decap_12
XTAP_TAPCELL_ROW_78_1131 VGND VPWR sky130_fd_sc_hd__tapvpwrvgnd_1
XTAP_TAPCELL_ROW_10_354 VGND VPWR sky130_fd_sc_hd__tapvpwrvgnd_1
XFILLER_0_22_234 VGND VGND VPWR VPWR sky130_fd_sc_hd__fill_1
XFILLER_0_10_418 VGND VGND VPWR VPWR sky130_fd_sc_hd__fill_2
XPHY_EDGE_ROW_26_Left_136 VGND VGND VPWR VPWR sky130_fd_sc_hd__decap_3
XFILLER_0_38_13 VPWR VGND VPWR VGND sky130_ef_sc_hd__decap_12
XTAP_TAPCELL_ROW_89_1260 VGND VPWR sky130_fd_sc_hd__tapvpwrvgnd_1
XFILLER_0_77_429 VGND VGND VPWR VPWR sky130_fd_sc_hd__fill_1
XTAP_TAPCELL_ROW_18_443 VGND VPWR sky130_fd_sc_hd__tapvpwrvgnd_1
XPHY_EDGE_ROW_35_Left_145 VGND VGND VPWR VPWR sky130_fd_sc_hd__decap_3
XTAP_TAPCELL_ROW_46_763 VGND VPWR sky130_fd_sc_hd__tapvpwrvgnd_1
X_6750_ _2065_ _2066_ _2064_ VGND VGND VPWR VPWR _2191_ sky130_fd_sc_hd__a21bo_1
X_3962_ _1304_ _1271_ VGND VGND VPWR VPWR _1337_ sky130_fd_sc_hd__and2b_1
X_5701_ _1041_ _1043_ _1044_ VGND VGND VPWR VPWR _1045_ sky130_fd_sc_hd__or3_4
X_3893_ _0192_ _0213_ VGND VGND VPWR VPWR _0584_ sky130_fd_sc_hd__or2_1
XFILLER_0_57_197 VGND VGND VPWR VPWR sky130_fd_sc_hd__decap_6
XFILLER_0_57_175 VGND VGND VPWR VPWR sky130_fd_sc_hd__decap_8
X_6681_ _1901_ _1903_ _2114_ _2115_ VGND VGND VPWR VPWR _2116_ sky130_fd_sc_hd__a211o_1
XFILLER_0_45_337 VGND VGND VPWR VPWR sky130_fd_sc_hd__decap_4
XFILLER_0_92_7 VPWR VGND VPWR VGND sky130_ef_sc_hd__decap_12
X_5632_ _0846_ _3751_ _3747_ _0835_ VGND VGND VPWR VPWR _0970_ sky130_fd_sc_hd__o22a_1
XFILLER_0_45_359 VPWR VGND VPWR VGND sky130_ef_sc_hd__decap_12
XFILLER_0_72_167 VPWR VGND VPWR VGND sky130_ef_sc_hd__decap_12
X_5563_ _3448_ _3622_ _0457_ _0758_ VGND VGND VPWR VPWR _0894_ sky130_fd_sc_hd__and4_1
X_7302_ _2554_ _2556_ _2793_ VGND VGND VPWR VPWR _2795_ sky130_fd_sc_hd__and3_1
XFILLER_0_13_223 VGND VGND VPWR VPWR sky130_fd_sc_hd__fill_1
X_4514_ _2649_ VGND VGND VPWR VPWR _3621_ sky130_fd_sc_hd__clkbuf_4
XFILLER_0_53_370 VGND VGND VPWR VPWR sky130_fd_sc_hd__decap_3
XFILLER_0_53_381 VGND VGND VPWR VPWR sky130_fd_sc_hd__decap_8
X_5494_ _0624_ _0817_ _0818_ VGND VGND VPWR VPWR _0819_ sky130_fd_sc_hd__nand3_4
XFILLER_0_41_565 VPWR VGND VPWR VGND sky130_ef_sc_hd__decap_12
XPHY_EDGE_ROW_44_Left_154 VGND VGND VPWR VPWR sky130_fd_sc_hd__decap_3
X_4445_ _3336_ _3324_ _3308_ VGND VGND VPWR VPWR _3554_ sky130_fd_sc_hd__mux2_1
X_7233_ _2717_ _2718_ VGND VGND VPWR VPWR _2719_ sky130_fd_sc_hd__nor2_1
XFILLER_0_13_289 VGND VGND VPWR VPWR sky130_fd_sc_hd__fill_2
X_4376_ _1479_ _2058_ _3317_ VGND VGND VPWR VPWR _3486_ sky130_fd_sc_hd__mux2_1
X_7164_ _2434_ _2460_ VGND VGND VPWR VPWR _2644_ sky130_fd_sc_hd__nand2_1
X_6115_ _1336_ _1339_ _1495_ _1496_ VGND VGND VPWR VPWR _1497_ sky130_fd_sc_hd__o211a_1
X_7095_ _2566_ _2567_ VGND VGND VPWR VPWR _2568_ sky130_fd_sc_hd__xnor2_1
X_6046_ _1418_ _1419_ _1405_ VGND VGND VPWR VPWR _1421_ sky130_fd_sc_hd__o21a_1
XFILLER_0_68_429 VGND VGND VPWR VPWR sky130_fd_sc_hd__decap_8
XPHY_EDGE_ROW_53_Left_163 VGND VGND VPWR VPWR sky130_fd_sc_hd__decap_3
XFILLER_0_95_248 VGND VGND VPWR VPWR sky130_fd_sc_hd__decap_8
X_6948_ _2399_ _2406_ VGND VGND VPWR VPWR _2407_ sky130_fd_sc_hd__and2_1
XFILLER_0_91_410 VGND VGND VPWR VPWR sky130_fd_sc_hd__fill_1
X_6879_ _2977_ _0137_ _0181_ _2867_ VGND VGND VPWR VPWR _2332_ sky130_fd_sc_hd__a22o_1
XFILLER_0_48_186 VGND VGND VPWR VPWR sky130_fd_sc_hd__decap_3
XFILLER_0_63_156 VPWR VGND VPWR VGND sky130_ef_sc_hd__decap_12
XPHY_EDGE_ROW_62_Left_172 VGND VGND VPWR VPWR sky130_fd_sc_hd__decap_3
XFILLER_0_17_595 VGND VGND VPWR VPWR sky130_fd_sc_hd__decap_8
XFILLER_0_44_370 VGND VGND VPWR VPWR sky130_fd_sc_hd__decap_6
XFILLER_0_44_392 VGND VGND VPWR VPWR sky130_fd_sc_hd__decap_6
XFILLER_0_102_431 VGND VGND VPWR VPWR sky130_fd_sc_hd__decap_4
XFILLER_0_32_587 VGND VGND VPWR VPWR sky130_fd_sc_hd__fill_1
XFILLER_0_5_3 VPWR VGND VPWR VGND sky130_ef_sc_hd__decap_12
XTAP_TAPCELL_ROW_73_1072 VGND VPWR sky130_fd_sc_hd__tapvpwrvgnd_1
XPHY_EDGE_ROW_71_Left_181 VGND VGND VPWR VPWR sky130_fd_sc_hd__decap_3
XFILLER_0_24_15 VGND VGND VPWR VPWR sky130_fd_sc_hd__decap_6
XFILLER_0_86_237 VPWR VGND VPWR VGND sky130_ef_sc_hd__decap_12
XFILLER_0_67_440 VGND VGND VPWR VPWR sky130_fd_sc_hd__fill_1
XTAP_TAPCELL_ROW_15_413 VGND VPWR sky130_fd_sc_hd__tapvpwrvgnd_1
XTAP_TAPCELL_ROW_43_733 VGND VPWR sky130_fd_sc_hd__tapvpwrvgnd_1
XFILLER_0_82_421 VGND VGND VPWR VPWR sky130_fd_sc_hd__decap_4
XFILLER_0_27_337 VPWR VGND VPWR VGND sky130_ef_sc_hd__decap_12
XFILLER_0_54_134 VGND VGND VPWR VPWR sky130_fd_sc_hd__decap_6
XPHY_EDGE_ROW_80_Left_190 VGND VGND VPWR VPWR sky130_fd_sc_hd__decap_3
XFILLER_0_42_307 VGND VGND VPWR VPWR sky130_fd_sc_hd__fill_1
XFILLER_0_50_351 VGND VGND VPWR VPWR sky130_fd_sc_hd__fill_1
XFILLER_0_50_362 VGND VGND VPWR VPWR sky130_fd_sc_hd__fill_2
X_4230_ _2944_ VGND VGND VPWR VPWR _3342_ sky130_fd_sc_hd__clkbuf_4
X_4161_ _3270_ _3272_ VGND VGND VPWR VPWR _3273_ sky130_fd_sc_hd__or2_2
X_4092_ _2550_ _2616_ VGND VGND VPWR VPWR _2758_ sky130_fd_sc_hd__nand2_4
XFILLER_0_77_237 VGND VGND VPWR VPWR sky130_fd_sc_hd__decap_6
X_6802_ _2114_ VGND VGND VPWR VPWR _2248_ sky130_fd_sc_hd__inv_2
X_4994_ _0174_ _0273_ VGND VGND VPWR VPWR _0274_ sky130_fd_sc_hd__nand2_1
XFILLER_0_92_229 VGND VGND VPWR VPWR sky130_fd_sc_hd__fill_1
X_3945_ _0911_ _0976_ _1064_ _1140_ VGND VGND VPWR VPWR _1151_ sky130_fd_sc_hd__and4_1
XFILLER_0_18_326 VGND VGND VPWR VPWR sky130_fd_sc_hd__decap_3
X_6733_ _2165_ _2170_ _2171_ VGND VGND VPWR VPWR _2172_ sky130_fd_sc_hd__nand3_1
XFILLER_0_85_281 VPWR VGND VPWR VGND sky130_ef_sc_hd__decap_12
XFILLER_0_73_443 VGND VGND VPWR VPWR sky130_fd_sc_hd__decap_4
X_6664_ _2094_ _2095_ _1929_ _2063_ VGND VGND VPWR VPWR _2097_ sky130_fd_sc_hd__o211a_1
X_3876_ net54 net23 VGND VGND VPWR VPWR _0399_ sky130_fd_sc_hd__and2b_1
X_5615_ _0855_ _0832_ _0949_ VGND VGND VPWR VPWR _0951_ sky130_fd_sc_hd__o21ai_1
XFILLER_0_60_104 VGND VGND VPWR VPWR sky130_fd_sc_hd__decap_6
XFILLER_0_33_307 VPWR VGND VPWR VGND sky130_ef_sc_hd__decap_12
XTAP_TAPCELL_ROW_98_1359 VGND VPWR sky130_fd_sc_hd__tapvpwrvgnd_1
XFILLER_0_83_3 VGND VGND VPWR VPWR sky130_fd_sc_hd__decap_6
XFILLER_0_61_649 VGND VGND VPWR VPWR sky130_fd_sc_hd__decap_3
XFILLER_0_60_126 VGND VGND VPWR VPWR sky130_fd_sc_hd__fill_2
X_6595_ _2019_ _2020_ VGND VGND VPWR VPWR _2021_ sky130_fd_sc_hd__nor2_1
X_5546_ _0868_ _0869_ _0874_ VGND VGND VPWR VPWR _0875_ sky130_fd_sc_hd__or3b_4
XFILLER_0_14_543 VGND VGND VPWR VPWR sky130_fd_sc_hd__decap_8
X_5477_ _0790_ _0798_ _0799_ VGND VGND VPWR VPWR _0800_ sky130_fd_sc_hd__nand3_2
XFILLER_0_14_587 VGND VGND VPWR VPWR sky130_fd_sc_hd__fill_1
XFILLER_0_41_384 VGND VGND VPWR VPWR sky130_fd_sc_hd__decap_8
X_7216_ _2698_ _2699_ VGND VGND VPWR VPWR _2700_ sky130_fd_sc_hd__nor2_1
X_4428_ _3339_ _3536_ VGND VGND VPWR VPWR _3537_ sky130_fd_sc_hd__nor2_2
X_4359_ _3381_ _3384_ _3311_ VGND VGND VPWR VPWR _3469_ sky130_fd_sc_hd__mux2_1
X_7147_ _2614_ _2407_ _2624_ VGND VGND VPWR VPWR _2625_ sky130_fd_sc_hd__o21a_1
X_7078_ _2547_ _2548_ VGND VGND VPWR VPWR _2549_ sky130_fd_sc_hd__xnor2_1
X_6029_ _1400_ _1401_ VGND VGND VPWR VPWR _1403_ sky130_fd_sc_hd__xnor2_1
XTAP_TAPCELL_ROW_107_1466 VGND VPWR sky130_fd_sc_hd__tapvpwrvgnd_1
XFILLER_0_96_524 VGND VGND VPWR VPWR sky130_fd_sc_hd__decap_8
XFILLER_0_83_229 VGND VGND VPWR VPWR sky130_fd_sc_hd__fill_1
XFILLER_0_37_635 VPWR VGND VPWR VGND sky130_ef_sc_hd__decap_12
XFILLER_0_76_292 VGND VGND VPWR VPWR sky130_fd_sc_hd__decap_3
XFILLER_0_64_421 VGND VGND VPWR VPWR sky130_fd_sc_hd__decap_6
XFILLER_0_36_123 VGND VGND VPWR VPWR sky130_fd_sc_hd__fill_2
XFILLER_0_36_145 VGND VGND VPWR VPWR sky130_fd_sc_hd__fill_1
XFILLER_0_107_545 VPWR VGND VPWR VGND sky130_ef_sc_hd__decap_12
XFILLER_0_91_251 VGND VGND VPWR VPWR sky130_fd_sc_hd__decap_8
XFILLER_0_36_189 VGND VGND VPWR VPWR sky130_fd_sc_hd__decap_6
XFILLER_0_51_126 VPWR VGND VPWR VGND sky130_ef_sc_hd__decap_12
XTAP_TAPCELL_ROW_75_1101 VGND VPWR sky130_fd_sc_hd__tapvpwrvgnd_1
XTAP_TAPCELL_ROW_20_471 VGND VPWR sky130_fd_sc_hd__tapvpwrvgnd_1
XFILLER_0_32_351 VGND VGND VPWR VPWR sky130_fd_sc_hd__decap_8
XFILLER_0_20_557 VPWR VGND VPWR VGND sky130_ef_sc_hd__decap_12
XFILLER_0_19_15 VPWR VGND VPWR VGND sky130_ef_sc_hd__decap_12
XFILLER_0_19_48 VGND VGND VPWR VPWR sky130_fd_sc_hd__decap_8
XFILLER_0_87_513 VGND VGND VPWR VPWR sky130_fd_sc_hd__fill_2
XTAP_TAPCELL_ROW_86_1230 VGND VPWR sky130_fd_sc_hd__tapvpwrvgnd_1
XTAP_TAPCELL_ROW_28_560 VGND VPWR sky130_fd_sc_hd__tapvpwrvgnd_1
XFILLER_0_35_69 VPWR VGND VPWR VGND sky130_ef_sc_hd__decap_12
XTAP_TAPCELL_ROW_56_880 VGND VPWR sky130_fd_sc_hd__tapvpwrvgnd_1
XFILLER_0_28_613 VPWR VGND VPWR VGND sky130_ef_sc_hd__decap_12
XFILLER_0_51_57 VGND VGND VPWR VPWR sky130_fd_sc_hd__decap_8
XFILLER_0_27_156 VGND VGND VPWR VPWR sky130_fd_sc_hd__fill_2
XFILLER_0_27_167 VGND VGND VPWR VPWR sky130_fd_sc_hd__fill_1
XFILLER_0_70_413 VGND VGND VPWR VPWR sky130_fd_sc_hd__decap_6
XFILLER_0_43_649 VGND VGND VPWR VPWR sky130_fd_sc_hd__decap_3
X_5400_ _3463_ _3441_ VGND VGND VPWR VPWR _0717_ sky130_fd_sc_hd__nand2_4
XFILLER_0_70_457 VGND VGND VPWR VPWR sky130_fd_sc_hd__decap_3
X_6380_ _1620_ _1751_ _1786_ net126 VGND VGND VPWR VPWR _1787_ sky130_fd_sc_hd__a211oi_4
X_5331_ net28 net27 _1785_ net62 VGND VGND VPWR VPWR _0641_ sky130_fd_sc_hd__and4_1
XFILLER_0_2_289 VGND VGND VPWR VPWR sky130_fd_sc_hd__decap_8
XFILLER_0_76_32 VGND VGND VPWR VPWR sky130_fd_sc_hd__decap_3
X_5262_ _0563_ _0564_ _0555_ VGND VGND VPWR VPWR _0566_ sky130_fd_sc_hd__a21o_1
X_7001_ _2462_ _2464_ _2325_ _2326_ VGND VGND VPWR VPWR _2466_ sky130_fd_sc_hd__o211a_1
XFILLER_0_55_7 VGND VGND VPWR VPWR sky130_fd_sc_hd__fill_2
X_4213_ _2485_ VGND VGND VPWR VPWR _3325_ sky130_fd_sc_hd__buf_2
XFILLER_0_76_65 VGND VGND VPWR VPWR sky130_fd_sc_hd__decap_8
X_5193_ _0488_ _0489_ _0360_ _0421_ VGND VGND VPWR VPWR _0491_ sky130_fd_sc_hd__o211a_1
X_4144_ _3254_ VGND VGND VPWR VPWR _3256_ sky130_fd_sc_hd__clkbuf_4
X_4075_ _2561_ VGND VGND VPWR VPWR _2572_ sky130_fd_sc_hd__buf_4
XFILLER_0_93_505 VGND VGND VPWR VPWR sky130_fd_sc_hd__decap_8
XFILLER_0_78_557 VPWR VGND VPWR VGND sky130_ef_sc_hd__decap_12
XFILLER_0_108_309 VGND VGND VPWR VPWR sky130_fd_sc_hd__fill_1
X_6716_ _3489_ _0111_ _0101_ _2153_ VGND VGND VPWR VPWR _2154_ sky130_fd_sc_hd__a2bb2o_1
X_4977_ _0251_ _0252_ _0253_ VGND VGND VPWR VPWR _0255_ sky130_fd_sc_hd__a21o_1
XFILLER_0_46_421 VPWR VGND VPWR VGND sky130_ef_sc_hd__decap_12
X_7696_ net80 net91 net94 net95 VGND VGND VPWR VPWR _3225_ sky130_fd_sc_hd__or4_1
X_3928_ _0933_ _0944_ VGND VGND VPWR VPWR _0966_ sky130_fd_sc_hd__nand2_1
XFILLER_0_73_240 VPWR VGND VPWR VGND sky130_ef_sc_hd__decap_12
X_3859_ net47 VGND VGND VPWR VPWR _0213_ sky130_fd_sc_hd__buf_2
XFILLER_0_61_413 VGND VGND VPWR VPWR sky130_fd_sc_hd__fill_2
X_6647_ _2071_ _2072_ _2077_ VGND VGND VPWR VPWR _2078_ sky130_fd_sc_hd__nand3_1
X_6578_ _0562_ _2000_ _0953_ VGND VGND VPWR VPWR _2002_ sky130_fd_sc_hd__a21o_1
XFILLER_0_61_468 VGND VGND VPWR VPWR sky130_fd_sc_hd__decap_8
XFILLER_0_33_159 VGND VGND VPWR VPWR sky130_fd_sc_hd__decap_8
XFILLER_0_104_559 VGND VGND VPWR VPWR sky130_fd_sc_hd__decap_3
X_5529_ _0705_ _0821_ _0822_ VGND VGND VPWR VPWR _0857_ sky130_fd_sc_hd__nor3b_2
XTAP_TAPCELL_ROW_70_1042 VGND VPWR sky130_fd_sc_hd__tapvpwrvgnd_1
XTAP_TAPCELL_ROW_109_1506 VGND VPWR sky130_fd_sc_hd__tapvpwrvgnd_1
XFILLER_0_69_502 VGND VGND VPWR VPWR sky130_fd_sc_hd__fill_2
XFILLER_0_96_365 VGND VGND VPWR VPWR sky130_fd_sc_hd__decap_8
XFILLER_0_69_557 VGND VGND VPWR VPWR sky130_fd_sc_hd__decap_3
XFILLER_0_84_527 VGND VGND VPWR VPWR sky130_fd_sc_hd__decap_4
XTAP_TAPCELL_ROW_53_850 VGND VPWR sky130_fd_sc_hd__tapvpwrvgnd_1
XFILLER_0_37_432 VGND VGND VPWR VPWR sky130_fd_sc_hd__fill_2
XFILLER_0_49_292 VPWR VGND VPWR VGND sky130_ef_sc_hd__decap_12
XFILLER_0_92_560 VPWR VGND VPWR VGND sky130_ef_sc_hd__decap_12
XTAP_TAPCELL_ROW_81_1171 VGND VPWR sky130_fd_sc_hd__tapvpwrvgnd_1
XFILLER_0_21_27 VPWR VGND VPWR VGND sky130_ef_sc_hd__decap_12
XFILLER_0_64_295 VGND VGND VPWR VPWR sky130_fd_sc_hd__decap_3
XFILLER_0_64_273 VGND VGND VPWR VPWR sky130_fd_sc_hd__decap_6
XFILLER_0_24_115 VGND VGND VPWR VPWR sky130_fd_sc_hd__fill_1
XFILLER_0_25_649 VGND VGND VPWR VPWR sky130_fd_sc_hd__decap_3
XFILLER_0_20_321 VPWR VGND VPWR VGND sky130_ef_sc_hd__decap_12
XFILLER_0_103_592 VPWR VGND VPWR VGND sky130_ef_sc_hd__decap_12
XFILLER_0_20_365 VPWR VGND VPWR VGND sky130_ef_sc_hd__decap_12
XFILLER_0_46_13 VGND VGND VPWR VPWR sky130_fd_sc_hd__fill_1
XFILLER_0_99_181 VGND VGND VPWR VPWR sky130_fd_sc_hd__decap_3
XPHY_EDGE_ROW_9_Left_119 VGND VGND VPWR VPWR sky130_fd_sc_hd__decap_3
XFILLER_0_1_15 VPWR VGND VPWR VGND sky130_ef_sc_hd__decap_12
XFILLER_0_75_505 VPWR VGND VPWR VGND sky130_ef_sc_hd__decap_12
X_4900_ _0076_ _0078_ VGND VGND VPWR VPWR _0172_ sky130_fd_sc_hd__and2b_1
X_5880_ _3508_ _1195_ VGND VGND VPWR VPWR _1240_ sky130_fd_sc_hd__nand2_1
X_4831_ _3408_ VGND VGND VPWR VPWR _0097_ sky130_fd_sc_hd__clkbuf_4
XFILLER_0_28_421 VGND VGND VPWR VPWR sky130_fd_sc_hd__decap_6
X_7550_ _0953_ _3065_ VGND VGND VPWR VPWR _3066_ sky130_fd_sc_hd__nor2_1
X_4762_ _3304_ _0016_ _0022_ VGND VGND VPWR VPWR _0023_ sky130_fd_sc_hd__a21bo_1
X_7481_ _2989_ _2990_ VGND VGND VPWR VPWR _2991_ sky130_fd_sc_hd__nand2_1
X_4693_ _3795_ _3796_ _3762_ VGND VGND VPWR VPWR _3798_ sky130_fd_sc_hd__a21o_1
X_6501_ _1914_ _1915_ _1917_ VGND VGND VPWR VPWR _1919_ sky130_fd_sc_hd__a21o_1
XTAP_TAPCELL_ROW_31_588 VGND VPWR sky130_fd_sc_hd__tapvpwrvgnd_1
X_6432_ _1832_ _1842_ VGND VGND VPWR VPWR _1843_ sky130_fd_sc_hd__xnor2_1
XFILLER_0_102_95 VGND VGND VPWR VPWR sky130_fd_sc_hd__decap_3
XTAP_TAPCELL_ROW_95_1329 VGND VPWR sky130_fd_sc_hd__tapvpwrvgnd_1
XFILLER_0_70_265 VPWR VGND VPWR VGND sky130_ef_sc_hd__decap_12
XFILLER_0_101_529 VGND VGND VPWR VPWR sky130_fd_sc_hd__decap_8
X_6363_ _1765_ _1766_ _1767_ VGND VGND VPWR VPWR _1768_ sky130_fd_sc_hd__or3_4
X_5314_ _3097_ _2080_ VGND VGND VPWR VPWR _0622_ sky130_fd_sc_hd__nand2_1
X_6294_ net26 net41 net40 _2649_ VGND VGND VPWR VPWR _1692_ sky130_fd_sc_hd__a22o_1
XFILLER_0_11_387 VGND VGND VPWR VPWR sky130_fd_sc_hd__fill_2
X_5245_ _0544_ _0546_ VGND VGND VPWR VPWR _0547_ sky130_fd_sc_hd__xnor2_1
X_5176_ _0468_ _0469_ _0470_ VGND VGND VPWR VPWR _0472_ sky130_fd_sc_hd__a21o_1
X_4127_ _3130_ _2867_ VGND VGND VPWR VPWR _3141_ sky130_fd_sc_hd__xor2_4
XTAP_TAPCELL_ROW_3_269 VGND VPWR sky130_fd_sc_hd__tapvpwrvgnd_1
XFILLER_0_78_321 VPWR VGND VPWR VGND sky130_ef_sc_hd__decap_12
X_4058_ _2375_ VGND VGND VPWR VPWR _2386_ sky130_fd_sc_hd__buf_6
XTAP_TAPCELL_ROW_39_688 VGND VPWR sky130_fd_sc_hd__tapvpwrvgnd_1
XTAP_TAPCELL_ROW_104_1436 VGND VPWR sky130_fd_sc_hd__tapvpwrvgnd_1
XFILLER_0_78_365 VGND VGND VPWR VPWR sky130_fd_sc_hd__decap_8
XFILLER_0_109_629 VPWR VGND VPWR VGND sky130_ef_sc_hd__decap_12
XFILLER_0_93_357 VPWR VGND VPWR VGND sky130_ef_sc_hd__decap_12
XFILLER_0_78_398 VPWR VGND VPWR VGND sky130_ef_sc_hd__decap_12
XFILLER_0_108_117 VGND VGND VPWR VPWR sky130_fd_sc_hd__fill_2
XFILLER_0_74_560 VGND VGND VPWR VPWR sky130_fd_sc_hd__fill_1
XFILLER_0_46_251 VGND VGND VPWR VPWR sky130_fd_sc_hd__fill_1
X_7679_ _3068_ _3206_ VGND VGND VPWR VPWR _3208_ sky130_fd_sc_hd__xnor2_1
XFILLER_0_34_402 VPWR VGND VPWR VGND sky130_ef_sc_hd__decap_12
XFILLER_0_34_446 VGND VGND VPWR VPWR sky130_fd_sc_hd__decap_8
XFILLER_0_14_181 VGND VGND VPWR VPWR sky130_fd_sc_hd__fill_2
XFILLER_0_100_551 VPWR VGND VPWR VGND sky130_ef_sc_hd__decap_12
XFILLER_0_16_27 VGND VGND VPWR VPWR sky130_fd_sc_hd__fill_1
XFILLER_0_97_641 VGND VGND VPWR VPWR sky130_fd_sc_hd__decap_8
XFILLER_0_69_343 VGND VGND VPWR VPWR sky130_fd_sc_hd__fill_1
XFILLER_0_57_505 VPWR VGND VPWR VGND sky130_ef_sc_hd__decap_12
XFILLER_0_96_195 VGND VGND VPWR VPWR sky130_fd_sc_hd__fill_1
XFILLER_0_37_240 VPWR VGND VPWR VGND sky130_ef_sc_hd__decap_12
XFILLER_0_108_651 VGND VGND VPWR VPWR sky130_fd_sc_hd__fill_1
XFILLER_0_65_593 VGND VGND VPWR VPWR sky130_fd_sc_hd__decap_3
XFILLER_0_4_307 VGND VGND VPWR VPWR sky130_fd_sc_hd__fill_1
XFILLER_0_25_413 VPWR VGND VPWR VGND sky130_ef_sc_hd__decap_12
XFILLER_0_80_563 VPWR VGND VPWR VGND sky130_ef_sc_hd__decap_12
XFILLER_0_21_641 VGND VGND VPWR VPWR sky130_fd_sc_hd__decap_8
XFILLER_0_40_438 VPWR VGND VPWR VGND sky130_ef_sc_hd__decap_12
XFILLER_0_57_67 VGND VGND VPWR VPWR sky130_fd_sc_hd__fill_2
XFILLER_0_20_195 VGND VGND VPWR VPWR sky130_fd_sc_hd__fill_1
X_5030_ _3508_ _1796_ _1610_ _3130_ VGND VGND VPWR VPWR _0313_ sky130_fd_sc_hd__a22oi_1
X_6981_ _2442_ _2443_ VGND VGND VPWR VPWR _2444_ sky130_fd_sc_hd__xnor2_1
X_5932_ _1170_ _1172_ _1171_ VGND VGND VPWR VPWR _1297_ sky130_fd_sc_hd__o21ba_1
XTAP_TAPCELL_ROW_0_228 VGND VPWR sky130_fd_sc_hd__tapvpwrvgnd_1
XTAP_TAPCELL_ROW_0_239 VGND VPWR sky130_fd_sc_hd__tapvpwrvgnd_1
XFILLER_0_87_140 VPWR VGND VPWR VGND sky130_ef_sc_hd__decap_12
XTAP_TAPCELL_ROW_64_978 VGND VPWR sky130_fd_sc_hd__tapvpwrvgnd_1
XTAP_TAPCELL_ROW_64_967 VGND VPWR sky130_fd_sc_hd__tapvpwrvgnd_1
XTAP_TAPCELL_ROW_36_647 VGND VPWR sky130_fd_sc_hd__tapvpwrvgnd_1
X_5863_ _3489_ _3352_ VGND VGND VPWR VPWR _1222_ sky130_fd_sc_hd__or2_1
XFILLER_0_75_335 VGND VGND VPWR VPWR sky130_fd_sc_hd__fill_1
XFILLER_0_8_613 VPWR VGND VPWR VGND sky130_ef_sc_hd__decap_12
XFILLER_0_90_305 VGND VGND VPWR VPWR sky130_fd_sc_hd__decap_3
X_4814_ _3797_ _3842_ _0076_ _0077_ VGND VGND VPWR VPWR _0078_ sky130_fd_sc_hd__or4_4
X_7602_ _1872_ _3305_ _0878_ _1086_ VGND VGND VPWR VPWR _3123_ sky130_fd_sc_hd__nand4_1
XFILLER_0_63_519 VGND VGND VPWR VPWR sky130_fd_sc_hd__decap_4
X_5794_ _1142_ _1145_ VGND VGND VPWR VPWR _1146_ sky130_fd_sc_hd__xnor2_1
X_4745_ _2397_ _2364_ VGND VGND VPWR VPWR _0006_ sky130_fd_sc_hd__or2b_1
X_7533_ _2844_ _2845_ VGND VGND VPWR VPWR _3048_ sky130_fd_sc_hd__nor2_1
XFILLER_0_43_221 VGND VGND VPWR VPWR sky130_fd_sc_hd__decap_3
XFILLER_0_98_41 VPWR VGND VPWR VGND sky130_ef_sc_hd__decap_12
X_7464_ _2047_ _1501_ _2735_ _2734_ VGND VGND VPWR VPWR _2972_ sky130_fd_sc_hd__a31o_1
XFILLER_0_43_276 VGND VGND VPWR VPWR sky130_fd_sc_hd__decap_4
X_4676_ _3778_ _3779_ _3780_ VGND VGND VPWR VPWR _3781_ sky130_fd_sc_hd__or3_1
X_7395_ _2714_ _0137_ VGND VGND VPWR VPWR _2896_ sky130_fd_sc_hd__nand2_1
XFILLER_0_98_85 VGND VGND VPWR VPWR sky130_fd_sc_hd__decap_4
X_6415_ _0900_ _1655_ _0976_ VGND VGND VPWR VPWR _1825_ sky130_fd_sc_hd__a21oi_1
XFILLER_0_31_438 VGND VGND VPWR VPWR sky130_fd_sc_hd__fill_1
XFILLER_0_98_96 VGND VGND VPWR VPWR sky130_fd_sc_hd__fill_2
X_6346_ _1746_ _1747_ _1726_ _1727_ VGND VGND VPWR VPWR _1749_ sky130_fd_sc_hd__a211o_1
XTAP_TAPCELL_ROW_8_328 VGND VPWR sky130_fd_sc_hd__tapvpwrvgnd_1
X_6277_ _1634_ VGND VGND VPWR VPWR _1673_ sky130_fd_sc_hd__inv_2
X_5228_ _3692_ _1796_ _1610_ _3621_ VGND VGND VPWR VPWR _0528_ sky130_fd_sc_hd__a22oi_2
XFILLER_0_98_405 VPWR VGND VPWR VGND sky130_ef_sc_hd__decap_12
X_5159_ _0448_ _0452_ VGND VGND VPWR VPWR _0454_ sky130_fd_sc_hd__xnor2_1
XFILLER_0_94_611 VPWR VGND VPWR VGND sky130_ef_sc_hd__decap_12
XFILLER_0_81_305 VGND VGND VPWR VPWR sky130_fd_sc_hd__decap_4
XFILLER_0_93_198 VGND VGND VPWR VPWR sky130_fd_sc_hd__decap_6
XFILLER_0_81_327 VGND VGND VPWR VPWR sky130_fd_sc_hd__decap_8
XFILLER_0_81_349 VPWR VGND VPWR VGND sky130_ef_sc_hd__decap_12
XFILLER_0_74_390 VGND VGND VPWR VPWR sky130_fd_sc_hd__decap_3
XFILLER_0_62_552 VGND VGND VPWR VPWR sky130_fd_sc_hd__fill_2
XFILLER_0_104_120 VPWR VGND VPWR VGND sky130_ef_sc_hd__decap_12
XFILLER_0_62_585 VGND VGND VPWR VPWR sky130_fd_sc_hd__decap_3
XFILLER_0_104_164 VGND VGND VPWR VPWR sky130_fd_sc_hd__decap_8
XFILLER_0_104_197 VGND VGND VPWR VPWR sky130_fd_sc_hd__fill_2
XFILLER_0_30_460 VGND VGND VPWR VPWR sky130_fd_sc_hd__decap_4
XFILLER_0_100_392 VGND VGND VPWR VPWR sky130_fd_sc_hd__decap_8
XFILLER_0_27_26 VGND VGND VPWR VPWR sky130_fd_sc_hd__fill_2
XFILLER_0_85_644 VGND VGND VPWR VPWR sky130_fd_sc_hd__decap_8
XTAP_TAPCELL_ROW_61_937 VGND VPWR sky130_fd_sc_hd__tapvpwrvgnd_1
XTAP_TAPCELL_ROW_33_617 VGND VPWR sky130_fd_sc_hd__tapvpwrvgnd_1
XPHY_EDGE_ROW_99_Left_209 VGND VGND VPWR VPWR sky130_fd_sc_hd__decap_3
XFILLER_0_72_305 VGND VGND VPWR VPWR sky130_fd_sc_hd__decap_3
XFILLER_0_84_187 VGND VGND VPWR VPWR sky130_fd_sc_hd__fill_1
XFILLER_0_84_165 VGND VGND VPWR VPWR sky130_fd_sc_hd__decap_6
XTAP_TAPCELL_ROW_13_385 VGND VPWR sky130_fd_sc_hd__tapvpwrvgnd_1
XFILLER_0_104_3 VPWR VGND VPWR VGND sky130_ef_sc_hd__decap_12
X_4530_ _3581_ _3584_ _3580_ VGND VGND VPWR VPWR _3637_ sky130_fd_sc_hd__a21o_1
XFILLER_0_5_649 VGND VGND VPWR VPWR sky130_fd_sc_hd__decap_3
XFILLER_0_13_405 VGND VGND VPWR VPWR sky130_fd_sc_hd__decap_8
XFILLER_0_53_585 VPWR VGND VPWR VGND sky130_ef_sc_hd__decap_12
X_4461_ _3141_ _3569_ VGND VGND VPWR VPWR _3570_ sky130_fd_sc_hd__nand2_1
XFILLER_0_68_11 VPWR VGND VPWR VGND sky130_ef_sc_hd__decap_12
XFILLER_0_13_449 VPWR VGND VPWR VGND sky130_ef_sc_hd__decap_12
X_7180_ _3602_ _0382_ _0385_ _1369_ _3489_ VGND VGND VPWR VPWR _2662_ sky130_fd_sc_hd__a221o_1
XFILLER_0_7_69 VGND VGND VPWR VPWR sky130_fd_sc_hd__decap_8
X_6200_ _1461_ _1480_ _1481_ VGND VGND VPWR VPWR _1590_ sky130_fd_sc_hd__nand3_2
X_4392_ _3501_ _3207_ _3290_ VGND VGND VPWR VPWR _3502_ sky130_fd_sc_hd__or3b_1
X_6131_ _3379_ _1360_ _0378_ _1514_ VGND VGND VPWR VPWR _1515_ sky130_fd_sc_hd__o22a_1
XFILLER_0_68_66 VGND VGND VPWR VPWR sky130_fd_sc_hd__decap_3
XFILLER_0_0_365 VPWR VGND VPWR VGND sky130_ef_sc_hd__decap_12
X_6062_ net3 _0465_ _1785_ net62 VGND VGND VPWR VPWR _1439_ sky130_fd_sc_hd__and4_1
X_5013_ _3747_ _0278_ _0294_ VGND VGND VPWR VPWR _0295_ sky130_fd_sc_hd__o21ai_1
XFILLER_0_108_83 VGND VGND VPWR VPWR sky130_fd_sc_hd__fill_1
XPHY_EDGE_ROW_5_Right_5 VGND VGND VPWR VPWR sky130_fd_sc_hd__decap_3
X_6964_ _2410_ _2423_ _2424_ VGND VGND VPWR VPWR _2425_ sky130_fd_sc_hd__nand3b_2
X_5915_ _3777_ net36 VGND VGND VPWR VPWR _1278_ sky130_fd_sc_hd__nand2_1
X_6895_ _2208_ _2210_ _2207_ VGND VGND VPWR VPWR _2349_ sky130_fd_sc_hd__o21ba_1
XFILLER_0_48_324 VGND VGND VPWR VPWR sky130_fd_sc_hd__fill_2
XFILLER_0_8_421 VGND VGND VPWR VPWR sky130_fd_sc_hd__fill_1
X_5846_ _1106_ _1202_ _1201_ VGND VGND VPWR VPWR _1203_ sky130_fd_sc_hd__or3_4
XFILLER_0_36_519 VPWR VGND VPWR VGND sky130_ef_sc_hd__decap_12
XFILLER_0_75_165 VGND VGND VPWR VPWR sky130_fd_sc_hd__decap_3
XFILLER_0_8_498 VGND VGND VPWR VPWR sky130_fd_sc_hd__decap_8
XFILLER_0_16_210 VPWR VGND VPWR VGND sky130_ef_sc_hd__decap_12
X_5777_ _1115_ _1116_ _1126_ VGND VGND VPWR VPWR _1127_ sky130_fd_sc_hd__a21o_2
X_7516_ _3027_ _3028_ VGND VGND VPWR VPWR _3029_ sky130_fd_sc_hd__nor2_1
XFILLER_0_16_276 VGND VGND VPWR VPWR sky130_fd_sc_hd__decap_6
X_4728_ _3829_ _3830_ _3831_ VGND VGND VPWR VPWR _3832_ sky130_fd_sc_hd__and3_4
X_7447_ _3271_ _0878_ _1086_ _1675_ VGND VGND VPWR VPWR _2953_ sky130_fd_sc_hd__a22o_1
XFILLER_0_71_393 VGND VGND VPWR VPWR sky130_fd_sc_hd__fill_1
XFILLER_0_31_213 VGND VGND VPWR VPWR sky130_fd_sc_hd__decap_8
X_4659_ _3414_ _3196_ _2353_ _2506_ VGND VGND VPWR VPWR _3764_ sky130_fd_sc_hd__and4_1
XFILLER_0_3_181 VPWR VGND VPWR VGND sky130_ef_sc_hd__decap_12
X_7378_ _2847_ _2848_ VGND VGND VPWR VPWR _2877_ sky130_fd_sc_hd__and2b_1
X_6329_ net34 _1555_ _0240_ _0634_ VGND VGND VPWR VPWR _1731_ sky130_fd_sc_hd__a22o_1
XTAP_TAPCELL_ROW_67_1003 VGND VPWR sky130_fd_sc_hd__tapvpwrvgnd_1
XFILLER_0_82_603 VGND VGND VPWR VPWR sky130_fd_sc_hd__decap_3
XFILLER_0_66_154 VPWR VGND VPWR VGND sky130_ef_sc_hd__decap_12
XFILLER_0_13_39 VPWR VGND VPWR VGND sky130_ef_sc_hd__decap_12
XFILLER_0_109_289 VGND VGND VPWR VPWR sky130_fd_sc_hd__fill_1
XFILLER_0_47_390 VGND VGND VPWR VPWR sky130_fd_sc_hd__fill_2
XTAP_TAPCELL_ROW_78_1132 VGND VPWR sky130_fd_sc_hd__tapvpwrvgnd_1
XTAP_TAPCELL_ROW_10_355 VGND VPWR sky130_fd_sc_hd__tapvpwrvgnd_1
XFILLER_0_105_473 VPWR VGND VPWR VGND sky130_ef_sc_hd__decap_12
XFILLER_0_38_25 VGND VGND VPWR VPWR sky130_fd_sc_hd__decap_3
XTAP_TAPCELL_ROW_89_1261 VGND VPWR sky130_fd_sc_hd__tapvpwrvgnd_1
XFILLER_0_54_57 VPWR VGND VPWR VGND sky130_ef_sc_hd__decap_12
XFILLER_0_89_279 VGND VGND VPWR VPWR sky130_fd_sc_hd__fill_1
XFILLER_0_54_79 VGND VGND VPWR VPWR sky130_fd_sc_hd__decap_4
X_3961_ _1315_ VGND VGND VPWR VPWR _1326_ sky130_fd_sc_hd__inv_2
XTAP_TAPCELL_ROW_18_444 VGND VPWR sky130_fd_sc_hd__tapvpwrvgnd_1
XTAP_TAPCELL_ROW_46_764 VGND VPWR sky130_fd_sc_hd__tapvpwrvgnd_1
XFILLER_0_9_218 VGND VGND VPWR VPWR sky130_fd_sc_hd__decap_6
X_5700_ net143 _2025_ net7 net140 VGND VGND VPWR VPWR _1044_ sky130_fd_sc_hd__a22oi_2
X_3892_ _0192_ _0213_ VGND VGND VPWR VPWR _0573_ sky130_fd_sc_hd__nand2_1
X_6680_ _2098_ _2099_ _2112_ VGND VGND VPWR VPWR _2115_ sky130_fd_sc_hd__and3_1
XFILLER_0_45_305 VPWR VGND VPWR VGND sky130_ef_sc_hd__decap_12
X_5631_ _0824_ _0097_ _0376_ _0780_ _0717_ VGND VGND VPWR VPWR _0969_ sky130_fd_sc_hd__o221a_1
XFILLER_0_72_179 VPWR VGND VPWR VGND sky130_ef_sc_hd__decap_12
XFILLER_0_72_157 VGND VGND VPWR VPWR sky130_fd_sc_hd__fill_1
X_5562_ _0332_ _1938_ VGND VGND VPWR VPWR _0893_ sky130_fd_sc_hd__nand2_2
XFILLER_0_5_446 VGND VGND VPWR VPWR sky130_fd_sc_hd__fill_2
XFILLER_0_26_563 VGND VGND VPWR VPWR sky130_fd_sc_hd__decap_8
XFILLER_0_79_43 VGND VGND VPWR VPWR sky130_fd_sc_hd__fill_1
X_7301_ _2554_ _2556_ _2793_ VGND VGND VPWR VPWR _2794_ sky130_fd_sc_hd__a21oi_1
X_4513_ net152 net11 _2660_ _2616_ VGND VGND VPWR VPWR _3620_ sky130_fd_sc_hd__and4_1
X_7232_ _2353_ _2506_ _0922_ _0856_ VGND VGND VPWR VPWR _2718_ sky130_fd_sc_hd__and4_1
XFILLER_0_79_65 VGND VGND VPWR VPWR sky130_fd_sc_hd__decap_3
X_5493_ _0815_ _0816_ _0695_ _0734_ VGND VGND VPWR VPWR _0818_ sky130_fd_sc_hd__o211ai_2
XFILLER_0_41_577 VPWR VGND VPWR VGND sky130_ef_sc_hd__decap_12
X_4444_ _3312_ _3338_ VGND VGND VPWR VPWR _3553_ sky130_fd_sc_hd__nand2_2
XFILLER_0_13_279 VGND VGND VPWR VPWR sky130_fd_sc_hd__fill_1
XFILLER_0_1_641 VGND VGND VPWR VPWR sky130_fd_sc_hd__decap_8
XFILLER_0_95_31 VPWR VGND VPWR VGND sky130_ef_sc_hd__decap_12
X_4375_ _1872_ _1894_ _1960_ _3316_ _3309_ _3314_ VGND VGND VPWR VPWR _3485_ sky130_fd_sc_hd__mux4_1
X_7163_ _2606_ _2607_ _2640_ _2641_ VGND VGND VPWR VPWR _2643_ sky130_fd_sc_hd__a22o_1
XFILLER_0_95_75 VGND VGND VPWR VPWR sky130_fd_sc_hd__decap_3
X_7094_ _2681_ net46 VGND VGND VPWR VPWR _2567_ sky130_fd_sc_hd__nand2_1
X_6114_ _1493_ _1494_ _1390_ VGND VGND VPWR VPWR _1496_ sky130_fd_sc_hd__a21o_1
X_6045_ _1405_ _1418_ _1419_ VGND VGND VPWR VPWR _1420_ sky130_fd_sc_hd__nor3_1
XFILLER_0_28_91 VGND VGND VPWR VPWR sky130_fd_sc_hd__decap_6
XFILLER_0_49_600 VGND VGND VPWR VPWR sky130_fd_sc_hd__decap_6
X_6947_ _2404_ _2405_ VGND VGND VPWR VPWR _2406_ sky130_fd_sc_hd__xnor2_1
XFILLER_0_48_121 VGND VGND VPWR VPWR sky130_fd_sc_hd__decap_4
X_6878_ _2878_ _2977_ _0137_ _0181_ VGND VGND VPWR VPWR _2330_ sky130_fd_sc_hd__nand4_2
XFILLER_0_64_614 VGND VGND VPWR VPWR sky130_fd_sc_hd__fill_1
XFILLER_0_36_327 VGND VGND VPWR VPWR sky130_fd_sc_hd__fill_1
XFILLER_0_48_165 VGND VGND VPWR VPWR sky130_fd_sc_hd__fill_2
XFILLER_0_63_124 VGND VGND VPWR VPWR sky130_fd_sc_hd__fill_1
X_5829_ _1175_ _1182_ _1183_ VGND VGND VPWR VPWR _1185_ sky130_fd_sc_hd__nand3_2
XFILLER_0_17_552 VGND VGND VPWR VPWR sky130_fd_sc_hd__decap_8
XFILLER_0_32_533 VPWR VGND VPWR VGND sky130_ef_sc_hd__decap_12
XFILLER_0_102_421 VGND VGND VPWR VPWR sky130_fd_sc_hd__decap_4
XTAP_TAPCELL_ROW_73_1073 VGND VPWR sky130_fd_sc_hd__tapvpwrvgnd_1
XFILLER_0_99_522 VPWR VGND VPWR VGND sky130_ef_sc_hd__decap_12
XFILLER_0_86_249 VGND VGND VPWR VPWR sky130_fd_sc_hd__decap_3
XTAP_TAPCELL_ROW_15_414 VGND VPWR sky130_fd_sc_hd__tapvpwrvgnd_1
XFILLER_0_39_143 VPWR VGND VPWR VGND sky130_ef_sc_hd__decap_12
XTAP_TAPCELL_ROW_43_734 VGND VPWR sky130_fd_sc_hd__tapvpwrvgnd_1
XFILLER_0_27_349 VPWR VGND VPWR VGND sky130_ef_sc_hd__decap_12
XFILLER_0_82_477 VGND VGND VPWR VPWR sky130_fd_sc_hd__fill_1
XFILLER_0_35_393 VPWR VGND VPWR VGND sky130_ef_sc_hd__decap_12
XFILLER_0_105_281 VPWR VGND VPWR VGND sky130_ef_sc_hd__decap_12
XFILLER_0_23_599 VPWR VGND VPWR VGND sky130_ef_sc_hd__decap_12
XFILLER_0_49_13 VPWR VGND VPWR VGND sky130_ef_sc_hd__decap_12
X_4160_ _3271_ _1752_ VGND VGND VPWR VPWR _3272_ sky130_fd_sc_hd__nor2_1
XFILLER_0_4_15 VPWR VGND VPWR VGND sky130_ef_sc_hd__decap_12
X_4091_ _2714_ _2681_ VGND VGND VPWR VPWR _2747_ sky130_fd_sc_hd__and2b_1
XFILLER_0_65_34 VPWR VGND VPWR VGND sky130_ef_sc_hd__decap_12
X_6801_ _2051_ _2052_ _2053_ VGND VGND VPWR VPWR _2247_ sky130_fd_sc_hd__nand3_2
XFILLER_0_105_51 VGND VGND VPWR VPWR sky130_fd_sc_hd__decap_4
X_4993_ _0206_ _0272_ VGND VGND VPWR VPWR _0273_ sky130_fd_sc_hd__xnor2_2
X_3944_ _1118_ _1129_ VGND VGND VPWR VPWR _1140_ sky130_fd_sc_hd__nor2b_2
XFILLER_0_58_474 VGND VGND VPWR VPWR sky130_fd_sc_hd__fill_2
XFILLER_0_18_305 VGND VGND VPWR VPWR sky130_fd_sc_hd__decap_3
X_6732_ _2169_ _2168_ _2166_ VGND VGND VPWR VPWR _2171_ sky130_fd_sc_hd__a21bo_1
X_3875_ _0300_ _0344_ _0355_ _0366_ _0377_ VGND VGND VPWR VPWR _0388_ sky130_fd_sc_hd__a2111o_1
XFILLER_0_85_293 VPWR VGND VPWR VGND sky130_ef_sc_hd__decap_12
XFILLER_0_73_422 VGND VGND VPWR VPWR sky130_fd_sc_hd__decap_8
X_6663_ _1929_ _2063_ _2094_ _2095_ VGND VGND VPWR VPWR _2096_ sky130_fd_sc_hd__a211oi_4
XFILLER_0_45_113 VPWR VGND VPWR VGND sky130_ef_sc_hd__decap_12
X_5614_ _0855_ _0832_ _0949_ VGND VGND VPWR VPWR _0950_ sky130_fd_sc_hd__or3_1
XFILLER_0_61_617 VPWR VGND VPWR VGND sky130_ef_sc_hd__decap_12
XFILLER_0_33_319 VPWR VGND VPWR VGND sky130_ef_sc_hd__decap_12
XFILLER_0_60_138 VGND VGND VPWR VPWR sky130_fd_sc_hd__fill_2
XFILLER_0_14_533 VGND VGND VPWR VPWR sky130_fd_sc_hd__decap_4
X_6594_ _1881_ _1884_ _2018_ VGND VGND VPWR VPWR _2020_ sky130_fd_sc_hd__nor3_1
XFILLER_0_60_149 VGND VGND VPWR VPWR sky130_fd_sc_hd__fill_1
X_5545_ _0870_ _0873_ VGND VGND VPWR VPWR _0874_ sky130_fd_sc_hd__xnor2_1
XFILLER_0_53_190 VGND VGND VPWR VPWR sky130_fd_sc_hd__fill_2
XFILLER_0_76_3 VGND VGND VPWR VPWR sky130_fd_sc_hd__fill_1
X_5476_ _0796_ _0795_ _0797_ VGND VGND VPWR VPWR _0799_ sky130_fd_sc_hd__a21o_1
XFILLER_0_41_363 VGND VGND VPWR VPWR sky130_fd_sc_hd__decap_4
X_4427_ _3394_ net24 VGND VGND VPWR VPWR _3536_ sky130_fd_sc_hd__nand2_2
X_7215_ _2878_ _3319_ net19 net18 VGND VGND VPWR VPWR _2699_ sky130_fd_sc_hd__and4_1
X_7146_ _2615_ _2623_ VGND VGND VPWR VPWR _2624_ sky130_fd_sc_hd__xnor2_1
X_4358_ _3377_ _3380_ _3312_ VGND VGND VPWR VPWR _3468_ sky130_fd_sc_hd__mux2_1
X_4289_ _3296_ _3369_ _3399_ _3400_ VGND VGND VPWR VPWR net69 sky130_fd_sc_hd__o31a_1
X_7077_ _2374_ _2377_ _2373_ VGND VGND VPWR VPWR _2548_ sky130_fd_sc_hd__o21ba_1
X_6028_ _3414_ _1020_ _1242_ _1241_ VGND VGND VPWR VPWR _1401_ sky130_fd_sc_hd__a31oi_1
XTAP_TAPCELL_ROW_107_1467 VGND VPWR sky130_fd_sc_hd__tapvpwrvgnd_1
XFILLER_0_76_260 VGND VGND VPWR VPWR sky130_fd_sc_hd__decap_8
XFILLER_0_64_400 VGND VGND VPWR VPWR sky130_fd_sc_hd__decap_8
XFILLER_0_37_603 VGND VGND VPWR VPWR sky130_fd_sc_hd__decap_6
XFILLER_0_36_135 VGND VGND VPWR VPWR sky130_fd_sc_hd__decap_4
XFILLER_0_37_647 VGND VGND VPWR VPWR sky130_fd_sc_hd__decap_4
XFILLER_0_64_477 VGND VGND VPWR VPWR sky130_fd_sc_hd__fill_2
XFILLER_0_107_557 VGND VGND VPWR VPWR sky130_fd_sc_hd__decap_3
XFILLER_0_51_138 VGND VGND VPWR VPWR sky130_fd_sc_hd__decap_8
XFILLER_0_10_29 VPWR VGND VPWR VGND sky130_ef_sc_hd__decap_12
XFILLER_0_17_393 VGND VGND VPWR VPWR sky130_fd_sc_hd__decap_8
XTAP_TAPCELL_ROW_20_461 VGND VPWR sky130_fd_sc_hd__tapvpwrvgnd_1
XTAP_TAPCELL_ROW_20_472 VGND VPWR sky130_fd_sc_hd__tapvpwrvgnd_1
XTAP_TAPCELL_ROW_75_1102 VGND VPWR sky130_fd_sc_hd__tapvpwrvgnd_1
XFILLER_0_19_27 VGND VGND VPWR VPWR sky130_fd_sc_hd__decap_6
XFILLER_0_20_569 VPWR VGND VPWR VGND sky130_ef_sc_hd__decap_12
XFILLER_0_99_330 VGND VGND VPWR VPWR sky130_fd_sc_hd__decap_6
XFILLER_0_99_363 VGND VGND VPWR VPWR sky130_fd_sc_hd__decap_4
XTAP_TAPCELL_ROW_86_1231 VGND VPWR sky130_fd_sc_hd__tapvpwrvgnd_1
XTAP_TAPCELL_ROW_86_1220 VGND VPWR sky130_fd_sc_hd__tapvpwrvgnd_1
XFILLER_0_87_558 VGND VGND VPWR VPWR sky130_fd_sc_hd__fill_2
XTAP_TAPCELL_ROW_56_881 VGND VPWR sky130_fd_sc_hd__tapvpwrvgnd_1
XTAP_TAPCELL_ROW_28_561 VGND VPWR sky130_fd_sc_hd__tapvpwrvgnd_1
XFILLER_0_55_400 VGND VGND VPWR VPWR sky130_fd_sc_hd__decap_6
XFILLER_0_28_625 VPWR VGND VPWR VGND sky130_ef_sc_hd__decap_12
XFILLER_0_51_25 VGND VGND VPWR VPWR sky130_fd_sc_hd__decap_8
XFILLER_0_43_617 VGND VGND VPWR VPWR sky130_fd_sc_hd__decap_6
XFILLER_0_42_105 VGND VGND VPWR VPWR sky130_fd_sc_hd__decap_8
XFILLER_0_43_628 VGND VGND VPWR VPWR sky130_fd_sc_hd__decap_6
XFILLER_0_11_503 VGND VGND VPWR VPWR sky130_fd_sc_hd__fill_1
XFILLER_0_2_224 VGND VGND VPWR VPWR sky130_fd_sc_hd__fill_1
X_5330_ _3692_ _1523_ VGND VGND VPWR VPWR _0640_ sky130_fd_sc_hd__nand2_1
XFILLER_0_11_547 VPWR VGND VPWR VGND sky130_ef_sc_hd__decap_12
X_5261_ _0555_ _0563_ _0564_ VGND VGND VPWR VPWR _0565_ sky130_fd_sc_hd__nand3_2
X_4212_ _2583_ VGND VGND VPWR VPWR _3324_ sky130_fd_sc_hd__clkbuf_4
XFILLER_0_76_11 VPWR VGND VPWR VGND sky130_ef_sc_hd__decap_12
X_7000_ _2325_ _2326_ _2462_ _2464_ VGND VGND VPWR VPWR _2465_ sky130_fd_sc_hd__a211oi_2
X_5192_ _0360_ _0421_ _0488_ _0489_ VGND VGND VPWR VPWR _0490_ sky130_fd_sc_hd__a211oi_2
XFILLER_0_76_77 VGND VGND VPWR VPWR sky130_fd_sc_hd__decap_3
X_4143_ _1938_ _3254_ VGND VGND VPWR VPWR _3255_ sky130_fd_sc_hd__nand2_2
X_4074_ _2550_ VGND VGND VPWR VPWR _2561_ sky130_fd_sc_hd__clkbuf_4
XFILLER_0_78_569 VGND VGND VPWR VPWR sky130_fd_sc_hd__decap_4
XFILLER_0_93_528 VGND VGND VPWR VPWR sky130_fd_sc_hd__decap_4
XFILLER_0_25_92 VGND VGND VPWR VPWR sky130_fd_sc_hd__decap_3
X_6715_ _3445_ _2148_ _2152_ _1985_ VGND VGND VPWR VPWR _2153_ sky130_fd_sc_hd__a211oi_1
XFILLER_0_18_102 VPWR VGND VPWR VGND sky130_ef_sc_hd__decap_12
X_4976_ _0251_ _0252_ _0253_ VGND VGND VPWR VPWR _0254_ sky130_fd_sc_hd__nand3_2
XFILLER_0_46_433 VPWR VGND VPWR VGND sky130_ef_sc_hd__decap_12
X_7695_ _3224_ VGND VGND VPWR VPWR net93 sky130_fd_sc_hd__clkbuf_2
X_3927_ _0933_ _0944_ VGND VGND VPWR VPWR _0955_ sky130_fd_sc_hd__nor2_1
XFILLER_0_46_477 VPWR VGND VPWR VGND sky130_ef_sc_hd__decap_12
X_3858_ _0159_ _0148_ VGND VGND VPWR VPWR _0203_ sky130_fd_sc_hd__and2b_1
X_6646_ _2075_ _2076_ VGND VGND VPWR VPWR _2077_ sky130_fd_sc_hd__xnor2_1
X_6577_ _0562_ _2000_ VGND VGND VPWR VPWR _2001_ sky130_fd_sc_hd__nor2_1
X_5528_ _0583_ _0705_ _0706_ _0823_ VGND VGND VPWR VPWR _0855_ sky130_fd_sc_hd__and4_1
X_5459_ _0777_ _0778_ _0019_ VGND VGND VPWR VPWR _0781_ sky130_fd_sc_hd__o21ai_1
XTAP_TAPCELL_ROW_70_1043 VGND VPWR sky130_fd_sc_hd__tapvpwrvgnd_1
X_7129_ _2602_ _2603_ _2604_ VGND VGND VPWR VPWR _2606_ sky130_fd_sc_hd__nand3_1
XTAP_TAPCELL_ROW_109_1507 VGND VPWR sky130_fd_sc_hd__tapvpwrvgnd_1
XFILLER_0_69_525 VGND VGND VPWR VPWR sky130_fd_sc_hd__decap_4
XFILLER_0_69_569 VPWR VGND VPWR VGND sky130_ef_sc_hd__decap_12
XTAP_TAPCELL_ROW_25_520 VGND VPWR sky130_fd_sc_hd__tapvpwrvgnd_1
XFILLER_0_49_260 VGND VGND VPWR VPWR sky130_fd_sc_hd__decap_3
XTAP_TAPCELL_ROW_53_851 VGND VPWR sky130_fd_sc_hd__tapvpwrvgnd_1
XTAP_TAPCELL_ROW_81_1172 VGND VPWR sky130_fd_sc_hd__tapvpwrvgnd_1
XFILLER_0_25_617 VPWR VGND VPWR VGND sky130_ef_sc_hd__decap_12
XFILLER_0_21_39 VGND VGND VPWR VPWR sky130_fd_sc_hd__decap_8
XFILLER_0_52_403 VGND VGND VPWR VPWR sky130_fd_sc_hd__decap_8
XFILLER_0_20_333 VPWR VGND VPWR VGND sky130_ef_sc_hd__decap_12
XTAP_TAPCELL_ROW_92_1290 VGND VPWR sky130_fd_sc_hd__tapvpwrvgnd_1
XFILLER_0_20_377 VGND VGND VPWR VPWR sky130_fd_sc_hd__decap_3
XFILLER_0_1_27 VPWR VGND VPWR VGND sky130_ef_sc_hd__decap_12
XFILLER_0_87_377 VGND VGND VPWR VPWR sky130_fd_sc_hd__fill_2
XFILLER_0_75_517 VPWR VGND VPWR VGND sky130_ef_sc_hd__decap_12
X_4830_ _3305_ _1632_ VGND VGND VPWR VPWR _0096_ sky130_fd_sc_hd__nor2_1
XFILLER_0_75_539 VGND VGND VPWR VPWR sky130_fd_sc_hd__fill_1
XFILLER_0_7_305 VPWR VGND VPWR VGND sky130_ef_sc_hd__decap_12
XFILLER_0_90_509 VPWR VGND VPWR VGND sky130_ef_sc_hd__decap_12
XFILLER_0_83_561 VGND VGND VPWR VPWR sky130_fd_sc_hd__decap_6
X_4761_ _3667_ _0017_ _0020_ _0021_ VGND VGND VPWR VPWR _0022_ sky130_fd_sc_hd__o211a_1
XFILLER_0_28_444 VPWR VGND VPWR VGND sky130_ef_sc_hd__decap_12
X_7480_ _2748_ _2750_ _2987_ VGND VGND VPWR VPWR _2990_ sky130_fd_sc_hd__nand3_1
XFILLER_0_70_211 VGND VGND VPWR VPWR sky130_fd_sc_hd__fill_1
X_4692_ _3762_ _3795_ _3796_ VGND VGND VPWR VPWR _3797_ sky130_fd_sc_hd__nand3_2
XFILLER_0_55_274 VGND VGND VPWR VPWR sky130_fd_sc_hd__decap_6
X_6500_ _1914_ _1915_ _1917_ VGND VGND VPWR VPWR _1918_ sky130_fd_sc_hd__nand3_1
XFILLER_0_102_41 VPWR VGND VPWR VGND sky130_ef_sc_hd__decap_12
XFILLER_0_70_233 VPWR VGND VPWR VGND sky130_ef_sc_hd__decap_12
XTAP_TAPCELL_ROW_31_589 VGND VPWR sky130_fd_sc_hd__tapvpwrvgnd_1
X_6431_ _1677_ _1841_ VGND VGND VPWR VPWR _1842_ sky130_fd_sc_hd__xnor2_1
XFILLER_0_43_447 VGND VGND VPWR VPWR sky130_fd_sc_hd__fill_1
XFILLER_0_70_277 VPWR VGND VPWR VGND sky130_ef_sc_hd__decap_12
X_6362_ net132 net14 VGND VGND VPWR VPWR _1767_ sky130_fd_sc_hd__nand2_1
XFILLER_0_23_193 VPWR VGND VPWR VGND sky130_ef_sc_hd__decap_12
X_5313_ _0521_ _0524_ _0522_ VGND VGND VPWR VPWR _0621_ sky130_fd_sc_hd__o21ba_1
X_6293_ _2649_ net26 net41 net40 VGND VGND VPWR VPWR _1691_ sky130_fd_sc_hd__and4_1
X_5244_ _3749_ _0545_ VGND VGND VPWR VPWR _0546_ sky130_fd_sc_hd__xor2_1
X_5175_ _0468_ _0469_ _0470_ VGND VGND VPWR VPWR _0471_ sky130_fd_sc_hd__nand3_1
XFILLER_0_39_3 VPWR VGND VPWR VGND sky130_ef_sc_hd__decap_12
X_4126_ _3119_ VGND VGND VPWR VPWR _3130_ sky130_fd_sc_hd__buf_6
X_4057_ net29 VGND VGND VPWR VPWR _2375_ sky130_fd_sc_hd__clkbuf_4
XFILLER_0_36_80 VGND VGND VPWR VPWR sky130_fd_sc_hd__decap_4
XFILLER_0_78_333 VPWR VGND VPWR VGND sky130_ef_sc_hd__decap_12
XTAP_TAPCELL_ROW_39_689 VGND VPWR sky130_fd_sc_hd__tapvpwrvgnd_1
XTAP_TAPCELL_ROW_104_1437 VGND VPWR sky130_fd_sc_hd__tapvpwrvgnd_1
XTAP_TAPCELL_ROW_50_810 VGND VPWR sky130_fd_sc_hd__tapvpwrvgnd_1
XFILLER_0_93_369 VGND VGND VPWR VPWR sky130_fd_sc_hd__decap_4
X_4959_ net152 _3772_ _2616_ _1555_ VGND VGND VPWR VPWR _0236_ sky130_fd_sc_hd__and4_1
X_7678_ _3069_ _3205_ VGND VGND VPWR VPWR _3206_ sky130_fd_sc_hd__xnor2_1
XFILLER_0_34_414 VGND VGND VPWR VPWR sky130_fd_sc_hd__decap_6
XFILLER_0_46_274 VGND VGND VPWR VPWR sky130_fd_sc_hd__decap_8
XFILLER_0_22_609 VPWR VGND VPWR VGND sky130_ef_sc_hd__decap_12
X_6629_ _1906_ _1908_ _2056_ _2057_ VGND VGND VPWR VPWR _2059_ sky130_fd_sc_hd__o211a_1
XFILLER_0_46_296 VGND VGND VPWR VPWR sky130_fd_sc_hd__decap_4
XFILLER_0_14_193 VGND VGND VPWR VPWR sky130_fd_sc_hd__decap_3
XFILLER_0_100_530 VGND VGND VPWR VPWR sky130_fd_sc_hd__fill_2
XFILLER_0_100_563 VPWR VGND VPWR VGND sky130_ef_sc_hd__decap_12
XFILLER_0_96_141 VPWR VGND VPWR VGND sky130_ef_sc_hd__decap_12
XFILLER_0_69_366 VPWR VGND VPWR VGND sky130_ef_sc_hd__decap_12
XFILLER_0_57_517 VPWR VGND VPWR VGND sky130_ef_sc_hd__decap_12
XFILLER_0_84_347 VGND VGND VPWR VPWR sky130_fd_sc_hd__fill_1
XFILLER_0_32_27 VGND VGND VPWR VPWR sky130_fd_sc_hd__fill_1
XFILLER_0_37_252 VPWR VGND VPWR VGND sky130_ef_sc_hd__decap_12
XFILLER_0_25_425 VGND VGND VPWR VPWR sky130_fd_sc_hd__decap_3
XFILLER_0_107_162 VGND VGND VPWR VPWR sky130_fd_sc_hd__decap_6
XFILLER_0_107_151 VGND VGND VPWR VPWR sky130_fd_sc_hd__fill_2
XFILLER_0_80_531 VGND VGND VPWR VPWR sky130_fd_sc_hd__fill_1
XFILLER_0_80_575 VPWR VGND VPWR VGND sky130_ef_sc_hd__decap_12
XFILLER_0_12_108 VGND VGND VPWR VPWR sky130_fd_sc_hd__decap_4
XFILLER_0_13_609 VGND VGND VPWR VPWR sky130_fd_sc_hd__decap_6
XFILLER_0_52_277 VPWR VGND VPWR VGND sky130_ef_sc_hd__decap_12
XFILLER_0_33_480 VPWR VGND VPWR VGND sky130_ef_sc_hd__decap_12
XFILLER_0_20_141 VPWR VGND VPWR VGND sky130_ef_sc_hd__decap_12
XFILLER_0_57_13 VPWR VGND VPWR VGND sky130_ef_sc_hd__decap_12
XFILLER_0_0_558 VGND VGND VPWR VPWR sky130_fd_sc_hd__fill_2
X_6980_ _3331_ net49 VGND VGND VPWR VPWR _2443_ sky130_fd_sc_hd__nand2_1
X_5931_ _1163_ _1166_ _1164_ VGND VGND VPWR VPWR _1296_ sky130_fd_sc_hd__o21ba_1
XTAP_TAPCELL_ROW_0_229 VGND VPWR sky130_fd_sc_hd__tapvpwrvgnd_1
XFILLER_0_87_152 VGND VGND VPWR VPWR sky130_fd_sc_hd__decap_4
XTAP_TAPCELL_ROW_64_968 VGND VPWR sky130_fd_sc_hd__tapvpwrvgnd_1
XTAP_TAPCELL_ROW_36_648 VGND VPWR sky130_fd_sc_hd__tapvpwrvgnd_1
X_5862_ _3376_ _1304_ _3512_ _3542_ _0960_ VGND VGND VPWR VPWR _1221_ sky130_fd_sc_hd__a32o_1
X_7601_ _1872_ _1031_ _2960_ _2959_ VGND VGND VPWR VPWR _3122_ sky130_fd_sc_hd__a31o_1
X_4813_ _0074_ _0075_ _3840_ VGND VGND VPWR VPWR _0077_ sky130_fd_sc_hd__a21boi_1
XFILLER_0_8_625 VPWR VGND VPWR VGND sky130_ef_sc_hd__decap_12
XFILLER_0_7_113 VPWR VGND VPWR VGND sky130_ef_sc_hd__decap_12
X_5793_ _1143_ _1144_ VGND VGND VPWR VPWR _1145_ sky130_fd_sc_hd__nor2_1
X_4744_ _3711_ _3805_ _0003_ _0004_ VGND VGND VPWR VPWR _0005_ sky130_fd_sc_hd__a2bb2o_1
X_7532_ _3044_ _3045_ _2837_ _2839_ VGND VGND VPWR VPWR _3047_ sky130_fd_sc_hd__a211o_1
XFILLER_0_7_146 VGND VGND VPWR VPWR sky130_fd_sc_hd__fill_1
XFILLER_0_16_425 VGND VGND VPWR VPWR sky130_fd_sc_hd__fill_1
XFILLER_0_71_520 VPWR VGND VPWR VGND sky130_ef_sc_hd__decap_12
XFILLER_0_16_436 VGND VGND VPWR VPWR sky130_fd_sc_hd__decap_4
XFILLER_0_22_71 VPWR VGND VPWR VGND sky130_ef_sc_hd__decap_12
XFILLER_0_98_53 VPWR VGND VPWR VGND sky130_ef_sc_hd__decap_12
X_7463_ _2091_ _1468_ _1391_ _0715_ VGND VGND VPWR VPWR _2971_ sky130_fd_sc_hd__and4_1
X_4675_ _3521_ _2660_ _3692_ _3518_ VGND VGND VPWR VPWR _3780_ sky130_fd_sc_hd__a22oi_2
X_7394_ _2893_ _2894_ VGND VGND VPWR VPWR _2895_ sky130_fd_sc_hd__nand2_1
X_6414_ _3300_ _3746_ _3758_ _0961_ VGND VGND VPWR VPWR _1824_ sky130_fd_sc_hd__a2bb2o_1
X_6345_ _1726_ _1727_ _1746_ _1747_ VGND VGND VPWR VPWR _1748_ sky130_fd_sc_hd__o211ai_2
XTAP_TAPCELL_ROW_8_329 VGND VPWR sky130_fd_sc_hd__tapvpwrvgnd_1
X_6276_ _1640_ _1497_ _1641_ VGND VGND VPWR VPWR _1672_ sky130_fd_sc_hd__and3_1
X_5227_ _2660_ _2550_ _0433_ _1599_ VGND VGND VPWR VPWR _0527_ sky130_fd_sc_hd__and4_1
X_5158_ _0449_ _0451_ VGND VGND VPWR VPWR _0452_ sky130_fd_sc_hd__xnor2_1
X_4109_ _2878_ VGND VGND VPWR VPWR _2944_ sky130_fd_sc_hd__inv_2
XFILLER_0_98_439 VPWR VGND VPWR VGND sky130_ef_sc_hd__decap_12
XFILLER_0_98_417 VGND VGND VPWR VPWR sky130_fd_sc_hd__decap_3
X_5089_ _3747_ VGND VGND VPWR VPWR _0378_ sky130_fd_sc_hd__clkbuf_4
XFILLER_0_78_152 VGND VGND VPWR VPWR sky130_fd_sc_hd__fill_1
XFILLER_0_94_645 VGND VGND VPWR VPWR sky130_fd_sc_hd__decap_6
XFILLER_0_94_623 VPWR VGND VPWR VGND sky130_ef_sc_hd__decap_12
XFILLER_0_19_263 VPWR VGND VPWR VGND sky130_ef_sc_hd__decap_12
XFILLER_0_47_561 VGND VGND VPWR VPWR sky130_fd_sc_hd__decap_4
XFILLER_0_47_583 VGND VGND VPWR VPWR sky130_fd_sc_hd__decap_6
XFILLER_0_105_600 VPWR VGND VPWR VGND sky130_ef_sc_hd__decap_12
XFILLER_0_62_531 VGND VGND VPWR VPWR sky130_fd_sc_hd__fill_1
XFILLER_0_104_110 VGND VGND VPWR VPWR sky130_fd_sc_hd__decap_4
XFILLER_0_34_277 VGND VGND VPWR VPWR sky130_fd_sc_hd__decap_6
XFILLER_0_104_154 VGND VGND VPWR VPWR sky130_fd_sc_hd__fill_1
XFILLER_0_104_132 VGND VGND VPWR VPWR sky130_fd_sc_hd__fill_1
XFILLER_0_22_428 VPWR VGND VPWR VGND sky130_ef_sc_hd__decap_12
XFILLER_0_43_15 VPWR VGND VPWR VGND sky130_ef_sc_hd__decap_12
XFILLER_0_84_100 VPWR VGND VPWR VGND sky130_ef_sc_hd__decap_12
XTAP_TAPCELL_ROW_33_618 VGND VPWR sky130_fd_sc_hd__tapvpwrvgnd_1
XTAP_TAPCELL_ROW_61_938 VGND VPWR sky130_fd_sc_hd__tapvpwrvgnd_1
XFILLER_0_5_617 VPWR VGND VPWR VGND sky130_ef_sc_hd__decap_12
XFILLER_0_4_105 VPWR VGND VPWR VGND sky130_ef_sc_hd__decap_12
XTAP_TAPCELL_ROW_13_386 VGND VPWR sky130_fd_sc_hd__tapvpwrvgnd_1
X_4460_ _3501_ _3505_ _3509_ VGND VGND VPWR VPWR _3569_ sky130_fd_sc_hd__o21bai_1
XFILLER_0_80_372 VGND VGND VPWR VPWR sky130_fd_sc_hd__fill_2
XFILLER_0_7_15 VPWR VGND VPWR VGND sky130_ef_sc_hd__decap_12
XFILLER_0_53_597 VPWR VGND VPWR VGND sky130_ef_sc_hd__decap_12
X_4391_ _3334_ _3319_ VGND VGND VPWR VPWR _3501_ sky130_fd_sc_hd__xnor2_1
XFILLER_0_68_23 VGND VGND VPWR VPWR sky130_fd_sc_hd__decap_4
XFILLER_0_0_300 VGND VGND VPWR VPWR sky130_fd_sc_hd__decap_4
X_6130_ _3379_ _1086_ VGND VGND VPWR VPWR _1514_ sky130_fd_sc_hd__nand2_1
XFILLER_0_0_377 VPWR VGND VPWR VGND sky130_ef_sc_hd__decap_12
X_6061_ _0465_ _1785_ _0093_ net144 VGND VGND VPWR VPWR _1438_ sky130_fd_sc_hd__a22oi_1
X_5012_ _3279_ _3751_ _0291_ _0293_ VGND VGND VPWR VPWR _0294_ sky130_fd_sc_hd__o211a_1
XFILLER_0_84_88 VPWR VGND VPWR VGND sky130_ef_sc_hd__decap_12
XFILLER_0_84_77 VGND VGND VPWR VPWR sky130_fd_sc_hd__decap_6
XTAP_TAPCELL_ROW_49_795 VGND VPWR sky130_fd_sc_hd__tapvpwrvgnd_1
X_6963_ _2411_ _2412_ _2422_ VGND VGND VPWR VPWR _2424_ sky130_fd_sc_hd__nand3_2
XFILLER_0_76_645 VGND VGND VPWR VPWR sky130_fd_sc_hd__decap_6
XFILLER_0_75_100 VPWR VGND VPWR VGND sky130_ef_sc_hd__decap_12
X_6894_ _2344_ _2345_ _2346_ VGND VGND VPWR VPWR _2348_ sky130_fd_sc_hd__a21o_1
X_5914_ _1275_ _1276_ VGND VGND VPWR VPWR _1277_ sky130_fd_sc_hd__nor2_1
X_5845_ _1200_ net120 _1062_ _1108_ VGND VGND VPWR VPWR _1202_ sky130_fd_sc_hd__a211oi_4
XFILLER_0_29_550 VGND VGND VPWR VPWR sky130_fd_sc_hd__fill_2
XFILLER_0_63_306 VPWR VGND VPWR VGND sky130_ef_sc_hd__decap_12
XFILLER_0_33_81 VGND VGND VPWR VPWR sky130_fd_sc_hd__decap_8
XFILLER_0_8_477 VGND VGND VPWR VPWR sky130_fd_sc_hd__fill_1
XFILLER_0_16_222 VGND VGND VPWR VPWR sky130_fd_sc_hd__decap_6
X_5776_ _1117_ _1125_ VGND VGND VPWR VPWR _1126_ sky130_fd_sc_hd__xnor2_1
XFILLER_0_44_520 VPWR VGND VPWR VGND sky130_ef_sc_hd__decap_12
X_7515_ _3018_ _3026_ VGND VGND VPWR VPWR _3028_ sky130_fd_sc_hd__nor2_1
X_4727_ _3776_ _3785_ _3784_ VGND VGND VPWR VPWR _3831_ sky130_fd_sc_hd__a21bo_1
X_7446_ _1675_ _3271_ _0878_ VGND VGND VPWR VPWR _2952_ sky130_fd_sc_hd__and3_1
X_4658_ _3699_ _3700_ _3701_ VGND VGND VPWR VPWR _3763_ sky130_fd_sc_hd__and3_1
XFILLER_0_31_203 VGND VGND VPWR VPWR sky130_fd_sc_hd__fill_1
XFILLER_0_44_597 VGND VGND VPWR VPWR sky130_fd_sc_hd__decap_3
XFILLER_0_101_113 VGND VGND VPWR VPWR sky130_fd_sc_hd__decap_4
X_7377_ _2695_ _2849_ VGND VGND VPWR VPWR _2876_ sky130_fd_sc_hd__and2_1
XFILLER_0_3_193 VPWR VGND VPWR VGND sky130_ef_sc_hd__decap_12
X_4589_ _3691_ _3693_ _3690_ VGND VGND VPWR VPWR _3695_ sky130_fd_sc_hd__a21o_1
X_6328_ _0634_ net34 _1555_ _0240_ VGND VGND VPWR VPWR _1729_ sky130_fd_sc_hd__and4_1
X_6259_ _1042_ _1380_ _1514_ _1513_ _0911_ VGND VGND VPWR VPWR _1655_ sky130_fd_sc_hd__a311o_1
XFILLER_0_98_247 VGND VGND VPWR VPWR sky130_fd_sc_hd__decap_4
XTAP_TAPCELL_ROW_67_1004 VGND VPWR sky130_fd_sc_hd__tapvpwrvgnd_1
XFILLER_0_79_461 VPWR VGND VPWR VGND sky130_ef_sc_hd__decap_12
XFILLER_0_67_601 VGND VGND VPWR VPWR sky130_fd_sc_hd__decap_3
XFILLER_0_67_623 VGND VGND VPWR VPWR sky130_fd_sc_hd__decap_8
XFILLER_0_66_100 VGND VGND VPWR VPWR sky130_fd_sc_hd__fill_1
XPHY_EDGE_ROW_11_Right_11 VGND VGND VPWR VPWR sky130_fd_sc_hd__decap_3
XFILLER_0_94_475 VGND VGND VPWR VPWR sky130_fd_sc_hd__fill_1
XFILLER_0_66_166 VGND VGND VPWR VPWR sky130_fd_sc_hd__decap_6
XFILLER_0_47_380 VGND VGND VPWR VPWR sky130_fd_sc_hd__decap_4
XFILLER_0_81_169 VGND VGND VPWR VPWR sky130_fd_sc_hd__decap_3
XTAP_TAPCELL_ROW_78_1133 VGND VPWR sky130_fd_sc_hd__tapvpwrvgnd_1
XFILLER_0_62_383 VGND VGND VPWR VPWR sky130_fd_sc_hd__decap_8
XTAP_TAPCELL_ROW_10_356 VGND VPWR sky130_fd_sc_hd__tapvpwrvgnd_1
XFILLER_0_105_485 VGND VGND VPWR VPWR sky130_fd_sc_hd__fill_1
XFILLER_0_22_269 VGND VGND VPWR VPWR sky130_fd_sc_hd__fill_1
XFILLER_0_50_589 VPWR VGND VPWR VGND sky130_ef_sc_hd__decap_12
XPHY_EDGE_ROW_20_Right_20 VGND VGND VPWR VPWR sky130_fd_sc_hd__decap_3
XFILLER_0_30_291 VPWR VGND VPWR VGND sky130_ef_sc_hd__decap_12
XFILLER_0_38_37 VGND VGND VPWR VPWR sky130_fd_sc_hd__decap_8
XTAP_TAPCELL_ROW_89_1262 VGND VPWR sky130_fd_sc_hd__tapvpwrvgnd_1
XFILLER_0_89_225 VPWR VGND VPWR VGND sky130_ef_sc_hd__decap_12
XFILLER_0_54_69 VGND VGND VPWR VPWR sky130_fd_sc_hd__decap_4
X_3960_ _1271_ _1304_ VGND VGND VPWR VPWR _1315_ sky130_fd_sc_hd__or2b_1
XTAP_TAPCELL_ROW_18_445 VGND VPWR sky130_fd_sc_hd__tapvpwrvgnd_1
XTAP_TAPCELL_ROW_46_765 VGND VPWR sky130_fd_sc_hd__tapvpwrvgnd_1
XFILLER_0_58_645 VGND VGND VPWR VPWR sky130_fd_sc_hd__decap_6
XFILLER_0_57_144 VGND VGND VPWR VPWR sky130_fd_sc_hd__decap_6
XFILLER_0_18_509 VGND VGND VPWR VPWR sky130_fd_sc_hd__decap_6
X_3891_ _0540_ _0551_ VGND VGND VPWR VPWR _0562_ sky130_fd_sc_hd__nor2_2
XFILLER_0_57_166 VGND VGND VPWR VPWR sky130_fd_sc_hd__fill_2
XFILLER_0_45_317 VPWR VGND VPWR VGND sky130_ef_sc_hd__decap_12
X_5630_ _3742_ _0109_ _0967_ VGND VGND VPWR VPWR _0968_ sky130_fd_sc_hd__a21o_1
X_5561_ net137 _0891_ VGND VGND VPWR VPWR _0892_ sky130_fd_sc_hd__xnor2_2
X_4512_ _2758_ _3355_ VGND VGND VPWR VPWR _3619_ sky130_fd_sc_hd__nor2_1
X_7300_ _2790_ _2792_ VGND VGND VPWR VPWR _2793_ sky130_fd_sc_hd__nand2_1
XFILLER_0_13_225 VGND VGND VPWR VPWR sky130_fd_sc_hd__decap_6
X_5492_ _0695_ _0734_ _0815_ _0816_ VGND VGND VPWR VPWR _0817_ sky130_fd_sc_hd__a211o_4
XFILLER_0_5_469 VGND VGND VPWR VPWR sky130_fd_sc_hd__decap_8
XFILLER_0_53_361 VGND VGND VPWR VPWR sky130_fd_sc_hd__fill_2
X_7231_ _2506_ _0922_ _0856_ _2364_ VGND VGND VPWR VPWR _2717_ sky130_fd_sc_hd__a22oi_1
XFILLER_0_79_55 VGND VGND VPWR VPWR sky130_fd_sc_hd__fill_1
XFILLER_0_78_7 VGND VGND VPWR VPWR sky130_fd_sc_hd__decap_4
X_4443_ _3338_ _3551_ VGND VGND VPWR VPWR _3552_ sky130_fd_sc_hd__or2_1
XFILLER_0_79_99 VGND VGND VPWR VPWR sky130_fd_sc_hd__fill_1
XFILLER_0_41_589 VPWR VGND VPWR VGND sky130_ef_sc_hd__decap_12
X_4374_ _3322_ _3352_ _3483_ VGND VGND VPWR VPWR _3484_ sky130_fd_sc_hd__nor3_1
XFILLER_0_0_141 VGND VGND VPWR VPWR sky130_fd_sc_hd__decap_8
X_7162_ _2606_ _2607_ _2640_ _2641_ VGND VGND VPWR VPWR _2642_ sky130_fd_sc_hd__nand4_1
XFILLER_0_95_43 VPWR VGND VPWR VGND sky130_ef_sc_hd__decap_12
X_7093_ _2564_ _2565_ VGND VGND VPWR VPWR _2566_ sky130_fd_sc_hd__nor2_1
X_6113_ _1390_ _1493_ _1494_ VGND VGND VPWR VPWR _1495_ sky130_fd_sc_hd__nand3_2
X_6044_ _1406_ _1407_ _1417_ VGND VGND VPWR VPWR _1419_ sky130_fd_sc_hd__and3_1
XFILLER_0_21_3 VPWR VGND VPWR VGND sky130_ef_sc_hd__decap_12
X_6946_ _2254_ _2257_ VGND VGND VPWR VPWR _2405_ sky130_fd_sc_hd__nor2_1
XFILLER_0_76_453 VPWR VGND VPWR VGND sky130_ef_sc_hd__decap_12
X_6877_ _2203_ _2204_ _2214_ VGND VGND VPWR VPWR _2329_ sky130_fd_sc_hd__nand3_1
XFILLER_0_76_497 VPWR VGND VPWR VGND sky130_ef_sc_hd__decap_12
XFILLER_0_8_263 VGND VGND VPWR VPWR sky130_fd_sc_hd__fill_1
X_5828_ _1180_ _1179_ _1181_ VGND VGND VPWR VPWR _1183_ sky130_fd_sc_hd__a21o_1
XFILLER_0_63_169 VGND VGND VPWR VPWR sky130_fd_sc_hd__decap_4
X_5759_ _1001_ _1062_ _1063_ VGND VGND VPWR VPWR _1108_ sky130_fd_sc_hd__nor3_2
X_7429_ _1544_ _1271_ VGND VGND VPWR VPWR _2934_ sky130_fd_sc_hd__nand2_1
XFILLER_0_102_477 VPWR VGND VPWR VGND sky130_ef_sc_hd__decap_12
XTAP_TAPCELL_ROW_73_1074 VGND VPWR sky130_fd_sc_hd__tapvpwrvgnd_1
XFILLER_0_99_512 VGND VGND VPWR VPWR sky130_fd_sc_hd__decap_6
XFILLER_0_99_534 VPWR VGND VPWR VGND sky130_ef_sc_hd__decap_12
XFILLER_0_67_420 VPWR VGND VPWR VGND sky130_ef_sc_hd__decap_12
XTAP_TAPCELL_ROW_15_404 VGND VPWR sky130_fd_sc_hd__tapvpwrvgnd_1
XTAP_TAPCELL_ROW_43_735 VGND VPWR sky130_fd_sc_hd__tapvpwrvgnd_1
XFILLER_0_94_261 VGND VGND VPWR VPWR sky130_fd_sc_hd__decap_3
XFILLER_0_82_401 VPWR VGND VPWR VGND sky130_ef_sc_hd__decap_12
XFILLER_0_55_615 VGND VGND VPWR VPWR sky130_fd_sc_hd__fill_1
XFILLER_0_55_604 VGND VGND VPWR VPWR sky130_fd_sc_hd__decap_4
XFILLER_0_39_155 VPWR VGND VPWR VGND sky130_ef_sc_hd__decap_12
XFILLER_0_82_467 VGND VGND VPWR VPWR sky130_fd_sc_hd__decap_3
XFILLER_0_40_38 VGND VGND VPWR VPWR sky130_fd_sc_hd__decap_4
XFILLER_0_42_309 VGND VGND VPWR VPWR sky130_fd_sc_hd__decap_8
XFILLER_0_82_489 VGND VGND VPWR VPWR sky130_fd_sc_hd__fill_1
XFILLER_0_23_501 VGND VGND VPWR VPWR sky130_fd_sc_hd__decap_3
XFILLER_0_2_417 VGND VGND VPWR VPWR sky130_fd_sc_hd__decap_3
XFILLER_0_23_556 VGND VGND VPWR VPWR sky130_fd_sc_hd__decap_4
XFILLER_0_105_293 VPWR VGND VPWR VGND sky130_ef_sc_hd__decap_12
XFILLER_0_49_25 VGND VGND VPWR VPWR sky130_fd_sc_hd__decap_8
XFILLER_0_4_27 VGND VGND VPWR VPWR sky130_fd_sc_hd__fill_1
X_4090_ _2594_ _2638_ _2725_ VGND VGND VPWR VPWR _2736_ sky130_fd_sc_hd__a21oi_1
XFILLER_0_65_57 VPWR VGND VPWR VGND sky130_ef_sc_hd__decap_12
XFILLER_0_65_46 VGND VGND VPWR VPWR sky130_fd_sc_hd__decap_8
X_6800_ _2242_ _2243_ _2096_ _2118_ VGND VGND VPWR VPWR _2246_ sky130_fd_sc_hd__a211oi_2
X_4992_ _0270_ _0271_ VGND VGND VPWR VPWR _0272_ sky130_fd_sc_hd__xnor2_1
XFILLER_0_92_209 VPWR VGND VPWR VGND sky130_ef_sc_hd__decap_12
X_3943_ _1107_ _1086_ VGND VGND VPWR VPWR _1129_ sky130_fd_sc_hd__or2b_1
X_6731_ _2166_ _2168_ _2169_ VGND VGND VPWR VPWR _2170_ sky130_fd_sc_hd__nand3b_1
X_3874_ net23 net54 VGND VGND VPWR VPWR _0377_ sky130_fd_sc_hd__and2b_1
XFILLER_0_58_497 VGND VGND VPWR VPWR sky130_fd_sc_hd__decap_3
XFILLER_0_14_83 VGND VGND VPWR VPWR sky130_fd_sc_hd__fill_1
X_6662_ _2082_ _2083_ _2093_ VGND VGND VPWR VPWR _2095_ sky130_fd_sc_hd__a21oi_1
XFILLER_0_45_125 VGND VGND VPWR VPWR sky130_fd_sc_hd__decap_6
XFILLER_0_45_136 VPWR VGND VPWR VGND sky130_ef_sc_hd__decap_12
XFILLER_0_73_478 VPWR VGND VPWR VGND sky130_ef_sc_hd__decap_12
X_5613_ _0947_ _0948_ VGND VGND VPWR VPWR _0949_ sky130_fd_sc_hd__and2_1
XFILLER_0_45_169 VGND VGND VPWR VPWR sky130_fd_sc_hd__fill_2
XFILLER_0_61_629 VPWR VGND VPWR VGND sky130_ef_sc_hd__decap_12
X_6593_ _1881_ _1884_ _2018_ VGND VGND VPWR VPWR _2019_ sky130_fd_sc_hd__o21a_1
X_5544_ _0871_ _0872_ VGND VGND VPWR VPWR _0873_ sky130_fd_sc_hd__nor2_1
X_5475_ _0795_ _0796_ _0797_ VGND VGND VPWR VPWR _0798_ sky130_fd_sc_hd__nand3_1
XFILLER_0_14_567 VPWR VGND VPWR VGND sky130_ef_sc_hd__decap_12
XFILLER_0_14_589 VGND VGND VPWR VPWR sky130_fd_sc_hd__decap_3
X_7214_ _3319_ net19 _0094_ _2878_ VGND VGND VPWR VPWR _2698_ sky130_fd_sc_hd__a22oi_1
X_4426_ _3534_ VGND VGND VPWR VPWR _3535_ sky130_fd_sc_hd__inv_2
X_7145_ _2617_ _2622_ VGND VGND VPWR VPWR _2623_ sky130_fd_sc_hd__xnor2_1
X_4357_ _3314_ _3321_ _3463_ _3466_ VGND VGND VPWR VPWR _3467_ sky130_fd_sc_hd__a31o_1
X_4288_ _3354_ _0039_ VGND VGND VPWR VPWR _3400_ sky130_fd_sc_hd__nand2_1
X_7076_ _2545_ _2546_ VGND VGND VPWR VPWR _2547_ sky130_fd_sc_hd__xnor2_1
X_6027_ _1398_ _1399_ VGND VGND VPWR VPWR _1400_ sky130_fd_sc_hd__xnor2_1
XFILLER_0_55_90 VGND VGND VPWR VPWR sky130_fd_sc_hd__decap_3
XTAP_TAPCELL_ROW_107_1468 VGND VPWR sky130_fd_sc_hd__tapvpwrvgnd_1
XFILLER_0_37_615 VGND VGND VPWR VPWR sky130_fd_sc_hd__fill_1
XFILLER_0_37_626 VGND VGND VPWR VPWR sky130_fd_sc_hd__fill_1
X_6929_ _2361_ _2362_ _2384_ _2385_ VGND VGND VPWR VPWR _2387_ sky130_fd_sc_hd__and4bb_1
XFILLER_0_64_434 VGND VGND VPWR VPWR sky130_fd_sc_hd__decap_6
XFILLER_0_107_525 VGND VGND VPWR VPWR sky130_fd_sc_hd__fill_1
XFILLER_0_24_309 VPWR VGND VPWR VGND sky130_ef_sc_hd__decap_12
XTAP_TAPCELL_ROW_20_462 VGND VPWR sky130_fd_sc_hd__tapvpwrvgnd_1
XTAP_TAPCELL_ROW_75_1103 VGND VPWR sky130_fd_sc_hd__tapvpwrvgnd_1
XTAP_TAPCELL_ROW_86_1221 VGND VPWR sky130_fd_sc_hd__tapvpwrvgnd_1
XFILLER_0_99_397 VGND VGND VPWR VPWR sky130_fd_sc_hd__fill_1
XTAP_TAPCELL_ROW_56_882 VGND VPWR sky130_fd_sc_hd__tapvpwrvgnd_1
XTAP_TAPCELL_ROW_28_562 VGND VPWR sky130_fd_sc_hd__tapvpwrvgnd_1
XFILLER_0_67_261 VPWR VGND VPWR VGND sky130_ef_sc_hd__decap_12
XFILLER_0_28_637 VGND VGND VPWR VPWR sky130_fd_sc_hd__decap_6
XFILLER_0_82_253 VGND VGND VPWR VPWR sky130_fd_sc_hd__fill_2
XFILLER_0_55_445 VGND VGND VPWR VPWR sky130_fd_sc_hd__decap_3
XFILLER_0_27_169 VPWR VGND VPWR VGND sky130_ef_sc_hd__decap_12
XFILLER_0_82_275 VPWR VGND VPWR VGND sky130_ef_sc_hd__decap_12
XFILLER_0_82_264 VGND VGND VPWR VPWR sky130_fd_sc_hd__decap_3
XTAP_TAPCELL_ROW_97_1350 VGND VPWR sky130_fd_sc_hd__tapvpwrvgnd_1
XFILLER_0_42_139 VGND VGND VPWR VPWR sky130_fd_sc_hd__fill_1
XFILLER_0_11_537 VGND VGND VPWR VPWR sky130_fd_sc_hd__decap_3
X_5260_ _0559_ _0560_ _0561_ VGND VGND VPWR VPWR _0564_ sky130_fd_sc_hd__a21o_1
X_4211_ _3315_ _3318_ _3322_ VGND VGND VPWR VPWR _3323_ sky130_fd_sc_hd__mux2_1
XFILLER_0_76_23 VGND VGND VPWR VPWR sky130_fd_sc_hd__decap_4
XFILLER_0_11_559 VGND VGND VPWR VPWR sky130_fd_sc_hd__fill_1
X_5191_ _0485_ _0487_ _0423_ VGND VGND VPWR VPWR _0489_ sky130_fd_sc_hd__o21a_1
X_4142_ _3253_ VGND VGND VPWR VPWR _3254_ sky130_fd_sc_hd__clkbuf_4
X_4073_ net26 VGND VGND VPWR VPWR _2550_ sky130_fd_sc_hd__clkbuf_4
XFILLER_0_92_88 VPWR VGND VPWR VGND sky130_ef_sc_hd__decap_12
XFILLER_0_19_615 VGND VGND VPWR VPWR sky130_fd_sc_hd__fill_1
X_4975_ _0142_ _0151_ _0150_ VGND VGND VPWR VPWR _0253_ sky130_fd_sc_hd__a21bo_1
XFILLER_0_46_401 VPWR VGND VPWR VGND sky130_ef_sc_hd__decap_12
X_6714_ _0382_ _0965_ _2151_ _1369_ VGND VGND VPWR VPWR _2152_ sky130_fd_sc_hd__a22o_1
XFILLER_0_18_114 VPWR VGND VPWR VGND sky130_ef_sc_hd__decap_12
X_3926_ net46 VGND VGND VPWR VPWR _0944_ sky130_fd_sc_hd__clkbuf_4
X_7694_ _3062_ _3066_ _3223_ VGND VGND VPWR VPWR _3224_ sky130_fd_sc_hd__or3_1
XFILLER_0_46_445 VPWR VGND VPWR VGND sky130_ef_sc_hd__decap_12
X_3857_ _0181_ VGND VGND VPWR VPWR _0192_ sky130_fd_sc_hd__buf_2
XFILLER_0_61_426 VGND VGND VPWR VPWR sky130_fd_sc_hd__fill_1
XFILLER_0_46_489 VGND VGND VPWR VPWR sky130_fd_sc_hd__decap_3
X_6645_ _2703_ _0998_ VGND VGND VPWR VPWR _2076_ sky130_fd_sc_hd__nand2_1
XFILLER_0_104_506 VPWR VGND VPWR VGND sky130_ef_sc_hd__decap_12
X_6576_ _0595_ _1990_ _0573_ VGND VGND VPWR VPWR _2000_ sky130_fd_sc_hd__o21ai_2
XFILLER_0_6_575 VPWR VGND VPWR VGND sky130_ef_sc_hd__decap_12
XFILLER_0_104_539 VPWR VGND VPWR VGND sky130_ef_sc_hd__decap_12
X_5527_ _0833_ _0854_ VGND VGND VPWR VPWR net76 sky130_fd_sc_hd__nand2_1
X_5458_ _0019_ _0777_ _0778_ VGND VGND VPWR VPWR _0779_ sky130_fd_sc_hd__or3_4
XFILLER_0_10_570 VGND VGND VPWR VPWR sky130_fd_sc_hd__fill_2
X_5389_ _0703_ VGND VGND VPWR VPWR _0705_ sky130_fd_sc_hd__buf_4
X_4409_ _2857_ VGND VGND VPWR VPWR _3518_ sky130_fd_sc_hd__buf_6
XTAP_TAPCELL_ROW_70_1044 VGND VPWR sky130_fd_sc_hd__tapvpwrvgnd_1
XFILLER_0_5_81 VPWR VGND VPWR VGND sky130_ef_sc_hd__decap_12
X_7128_ _2389_ _2432_ VGND VGND VPWR VPWR _2604_ sky130_fd_sc_hd__or2b_1
X_7059_ _2518_ _2527_ VGND VGND VPWR VPWR _2529_ sky130_fd_sc_hd__xnor2_1
XFILLER_0_84_518 VGND VGND VPWR VPWR sky130_fd_sc_hd__decap_4
XFILLER_0_56_209 VPWR VGND VPWR VGND sky130_ef_sc_hd__decap_12
XTAP_TAPCELL_ROW_25_521 VGND VPWR sky130_fd_sc_hd__tapvpwrvgnd_1
XTAP_TAPCELL_ROW_53_841 VGND VPWR sky130_fd_sc_hd__tapvpwrvgnd_1
XFILLER_0_37_412 VGND VGND VPWR VPWR sky130_fd_sc_hd__decap_6
XTAP_TAPCELL_ROW_81_1173 VGND VPWR sky130_fd_sc_hd__tapvpwrvgnd_1
XFILLER_0_64_253 VGND VGND VPWR VPWR sky130_fd_sc_hd__decap_6
XFILLER_0_37_445 VGND VGND VPWR VPWR sky130_fd_sc_hd__decap_3
XFILLER_0_107_322 VGND VGND VPWR VPWR sky130_fd_sc_hd__decap_6
XFILLER_0_25_629 VPWR VGND VPWR VGND sky130_ef_sc_hd__decap_12
XFILLER_0_52_426 VGND VGND VPWR VPWR sky130_fd_sc_hd__decap_4
XFILLER_0_20_345 VGND VGND VPWR VPWR sky130_fd_sc_hd__decap_6
XTAP_TAPCELL_ROW_92_1291 VGND VPWR sky130_fd_sc_hd__tapvpwrvgnd_1
XTAP_TAPCELL_ROW_5_290 VGND VPWR sky130_fd_sc_hd__tapvpwrvgnd_1
XFILLER_0_1_39 VPWR VGND VPWR VGND sky130_ef_sc_hd__decap_12
XFILLER_0_87_367 VGND VGND VPWR VPWR sky130_fd_sc_hd__fill_1
XFILLER_0_75_529 VGND VGND VPWR VPWR sky130_fd_sc_hd__decap_6
X_4760_ _3271_ _3358_ _3405_ _3273_ VGND VGND VPWR VPWR _0021_ sky130_fd_sc_hd__o22a_1
XFILLER_0_7_317 VGND VGND VPWR VPWR sky130_fd_sc_hd__decap_4
XFILLER_0_28_456 VGND VGND VPWR VPWR sky130_fd_sc_hd__decap_6
XFILLER_0_28_467 VGND VGND VPWR VPWR sky130_fd_sc_hd__fill_1
X_4691_ _3793_ _3794_ _3682_ VGND VGND VPWR VPWR _3796_ sky130_fd_sc_hd__a21o_1
XFILLER_0_28_489 VGND VGND VPWR VPWR sky130_fd_sc_hd__decap_3
XFILLER_0_102_53 VPWR VGND VPWR VGND sky130_ef_sc_hd__decap_12
XFILLER_0_70_245 VGND VGND VPWR VPWR sky130_fd_sc_hd__decap_6
XFILLER_0_11_51 VGND VGND VPWR VPWR sky130_fd_sc_hd__decap_4
XFILLER_0_24_640 VGND VGND VPWR VPWR sky130_fd_sc_hd__decap_4
X_6430_ _1838_ _1840_ VGND VGND VPWR VPWR _1841_ sky130_fd_sc_hd__and2_1
XFILLER_0_43_459 VPWR VGND VPWR VGND sky130_ef_sc_hd__decap_12
X_6361_ _3520_ _1097_ _0987_ _0242_ VGND VGND VPWR VPWR _1766_ sky130_fd_sc_hd__a22oi_2
XFILLER_0_24_651 VGND VGND VPWR VPWR sky130_fd_sc_hd__fill_1
XFILLER_0_70_289 VGND VGND VPWR VPWR sky130_fd_sc_hd__decap_8
X_5312_ _0495_ _0494_ _0586_ VGND VGND VPWR VPWR _0620_ sky130_fd_sc_hd__and3_1
XFILLER_0_3_578 VPWR VGND VPWR VGND sky130_ef_sc_hd__decap_12
XFILLER_0_23_172 VGND VGND VPWR VPWR sky130_fd_sc_hd__decap_8
XPHY_EDGE_ROW_49_Right_49 VGND VGND VPWR VPWR sky130_fd_sc_hd__decap_3
XFILLER_0_87_55 VGND VGND VPWR VPWR sky130_fd_sc_hd__fill_1
X_6292_ _1688_ _1689_ VGND VGND VPWR VPWR _1690_ sky130_fd_sc_hd__xnor2_1
X_5243_ _2495_ _3267_ VGND VGND VPWR VPWR _0545_ sky130_fd_sc_hd__nand2_1
X_5174_ _0339_ _0341_ _0340_ VGND VGND VPWR VPWR _0470_ sky130_fd_sc_hd__o21bai_1
X_4125_ net25 VGND VGND VPWR VPWR _3119_ sky130_fd_sc_hd__clkbuf_4
X_4056_ _2353_ VGND VGND VPWR VPWR _2364_ sky130_fd_sc_hd__clkbuf_4
XPHY_EDGE_ROW_58_Right_58 VGND VGND VPWR VPWR sky130_fd_sc_hd__decap_3
XFILLER_0_36_70 VGND VGND VPWR VPWR sky130_fd_sc_hd__fill_2
XFILLER_0_78_345 VGND VGND VPWR VPWR sky130_fd_sc_hd__decap_8
XTAP_TAPCELL_ROW_104_1438 VGND VPWR sky130_fd_sc_hd__tapvpwrvgnd_1
XTAP_TAPCELL_ROW_104_1427 VGND VPWR sky130_fd_sc_hd__tapvpwrvgnd_1
XFILLER_0_93_337 VGND VGND VPWR VPWR sky130_fd_sc_hd__decap_8
XFILLER_0_74_540 VPWR VGND VPWR VGND sky130_ef_sc_hd__decap_12
X_4958_ _2474_ _2692_ VGND VGND VPWR VPWR _0234_ sky130_fd_sc_hd__nand2_1
XTAP_TAPCELL_ROW_50_811 VGND VPWR sky130_fd_sc_hd__tapvpwrvgnd_1
XFILLER_0_52_91 VGND VGND VPWR VPWR sky130_fd_sc_hd__fill_1
X_7677_ _3072_ _3204_ VGND VGND VPWR VPWR _3205_ sky130_fd_sc_hd__xnor2_1
X_3909_ net8 VGND VGND VPWR VPWR _0758_ sky130_fd_sc_hd__clkbuf_4
XFILLER_0_19_478 VGND VGND VPWR VPWR sky130_fd_sc_hd__fill_2
X_4889_ _0065_ _0067_ _0157_ _0158_ VGND VGND VPWR VPWR _0160_ sky130_fd_sc_hd__a211o_1
XFILLER_0_61_223 VGND VGND VPWR VPWR sky130_fd_sc_hd__fill_1
X_6628_ _2054_ _2055_ _2041_ VGND VGND VPWR VPWR _2057_ sky130_fd_sc_hd__o21ai_1
XPHY_EDGE_ROW_67_Right_67 VGND VGND VPWR VPWR sky130_fd_sc_hd__decap_3
X_6559_ _1980_ _1214_ _1981_ VGND VGND VPWR VPWR _1983_ sky130_fd_sc_hd__and3b_1
XFILLER_0_61_289 VGND VGND VPWR VPWR sky130_fd_sc_hd__fill_2
XFILLER_0_14_161 VPWR VGND VPWR VGND sky130_ef_sc_hd__decap_12
XFILLER_0_42_481 VPWR VGND VPWR VGND sky130_ef_sc_hd__decap_12
XFILLER_0_100_575 VPWR VGND VPWR VGND sky130_ef_sc_hd__decap_12
XTAP_TAPCELL_ROW_58_900 VGND VPWR sky130_fd_sc_hd__tapvpwrvgnd_1
XPHY_EDGE_ROW_76_Right_76 VGND VGND VPWR VPWR sky130_fd_sc_hd__decap_3
XTAP_TAPCELL_ROW_2_260 VGND VPWR sky130_fd_sc_hd__tapvpwrvgnd_1
XFILLER_0_96_153 VPWR VGND VPWR VGND sky130_ef_sc_hd__decap_12
XFILLER_0_69_378 VPWR VGND VPWR VGND sky130_ef_sc_hd__decap_12
XFILLER_0_57_529 VGND VGND VPWR VPWR sky130_fd_sc_hd__decap_8
XFILLER_0_37_264 VPWR VGND VPWR VGND sky130_ef_sc_hd__decap_12
XPHY_EDGE_ROW_85_Right_85 VGND VGND VPWR VPWR sky130_fd_sc_hd__decap_3
XFILLER_0_4_309 VPWR VGND VPWR VGND sky130_ef_sc_hd__decap_12
XFILLER_0_37_297 VGND VGND VPWR VPWR sky130_fd_sc_hd__fill_1
XFILLER_0_52_234 VGND VGND VPWR VPWR sky130_fd_sc_hd__fill_1
XFILLER_0_80_587 VGND VGND VPWR VPWR sky130_fd_sc_hd__fill_1
XFILLER_0_40_407 VPWR VGND VPWR VGND sky130_ef_sc_hd__decap_12
XTAP_TAPCELL_ROW_94_1320 VGND VPWR sky130_fd_sc_hd__tapvpwrvgnd_1
XFILLER_0_33_492 VPWR VGND VPWR VGND sky130_ef_sc_hd__decap_12
XFILLER_0_52_289 VPWR VGND VPWR VGND sky130_ef_sc_hd__decap_12
XFILLER_0_103_391 VGND VGND VPWR VPWR sky130_fd_sc_hd__fill_1
XFILLER_0_57_25 VGND VGND VPWR VPWR sky130_fd_sc_hd__fill_1
XFILLER_0_20_153 VPWR VGND VPWR VGND sky130_ef_sc_hd__decap_12
XFILLER_0_20_197 VPWR VGND VPWR VGND sky130_ef_sc_hd__decap_12
XPHY_EDGE_ROW_94_Right_94 VGND VGND VPWR VPWR sky130_fd_sc_hd__decap_3
XFILLER_0_73_57 VGND VGND VPWR VPWR sky130_fd_sc_hd__decap_8
X_5930_ _1169_ _1188_ net136 VGND VGND VPWR VPWR _1295_ sky130_fd_sc_hd__nand3_2
XTAP_TAPCELL_ROW_64_969 VGND VPWR sky130_fd_sc_hd__tapvpwrvgnd_1
XTAP_TAPCELL_ROW_36_649 VGND VPWR sky130_fd_sc_hd__tapvpwrvgnd_1
X_5861_ _1348_ _1219_ VGND VGND VPWR VPWR _1220_ sky130_fd_sc_hd__xnor2_1
XFILLER_0_75_337 VPWR VGND VPWR VGND sky130_ef_sc_hd__decap_12
X_7600_ _3118_ _3120_ VGND VGND VPWR VPWR _3121_ sky130_fd_sc_hd__and2b_1
X_4812_ _3840_ _0075_ _0074_ VGND VGND VPWR VPWR _0076_ sky130_fd_sc_hd__and3b_2
XFILLER_0_8_637 VGND VGND VPWR VPWR sky130_fd_sc_hd__decap_6
X_5792_ _3777_ _1402_ _3253_ _2386_ VGND VGND VPWR VPWR _1144_ sky130_fd_sc_hd__a22oi_1
X_4743_ _3800_ _0001_ VGND VGND VPWR VPWR _0004_ sky130_fd_sc_hd__or2b_1
X_7531_ _2837_ _2839_ _3044_ _3045_ VGND VGND VPWR VPWR _3046_ sky130_fd_sc_hd__o211ai_2
XFILLER_0_7_125 VGND VGND VPWR VPWR sky130_fd_sc_hd__decap_6
XFILLER_0_28_253 VPWR VGND VPWR VGND sky130_ef_sc_hd__decap_12
XFILLER_0_71_532 VGND VGND VPWR VPWR sky130_fd_sc_hd__decap_8
X_7462_ _2777_ _2786_ VGND VGND VPWR VPWR _2970_ sky130_fd_sc_hd__nand2_1
XFILLER_0_7_169 VGND VGND VPWR VPWR sky130_fd_sc_hd__fill_1
XFILLER_0_22_83 VGND VGND VPWR VPWR sky130_fd_sc_hd__fill_1
XFILLER_0_28_286 VGND VGND VPWR VPWR sky130_fd_sc_hd__decap_8
XFILLER_0_43_212 VGND VGND VPWR VPWR sky130_fd_sc_hd__decap_3
X_6413_ _3353_ _1817_ _1819_ _1822_ VGND VGND VPWR VPWR _1823_ sky130_fd_sc_hd__a211o_1
XFILLER_0_71_576 VPWR VGND VPWR VGND sky130_ef_sc_hd__decap_12
X_4674_ _2857_ _2966_ _2660_ _2550_ VGND VGND VPWR VPWR _3779_ sky130_fd_sc_hd__and4_1
X_7393_ _2638_ _0094_ _3431_ VGND VGND VPWR VPWR _2894_ sky130_fd_sc_hd__a21o_1
XFILLER_0_98_65 VGND VGND VPWR VPWR sky130_fd_sc_hd__decap_8
XFILLER_0_3_353 VGND VGND VPWR VPWR sky130_fd_sc_hd__decap_8
XFILLER_0_3_331 VGND VGND VPWR VPWR sky130_fd_sc_hd__decap_4
XFILLER_0_12_643 VGND VGND VPWR VPWR sky130_fd_sc_hd__fill_1
X_6344_ _1744_ _1745_ _1728_ VGND VGND VPWR VPWR _1747_ sky130_fd_sc_hd__a21o_1
X_6275_ _0977_ _1650_ _1651_ _1671_ VGND VGND VPWR VPWR net83 sky130_fd_sc_hd__a31o_1
X_5226_ _2911_ _1523_ VGND VGND VPWR VPWR _0526_ sky130_fd_sc_hd__nand2_1
XFILLER_0_51_3 VPWR VGND VPWR VGND sky130_ef_sc_hd__decap_12
X_5157_ _2463_ _3749_ _0450_ VGND VGND VPWR VPWR _0451_ sky130_fd_sc_hd__o21a_1
X_5088_ _3358_ VGND VGND VPWR VPWR _0376_ sky130_fd_sc_hd__clkbuf_4
X_4108_ _2922_ VGND VGND VPWR VPWR _2933_ sky130_fd_sc_hd__buf_4
X_4039_ _1020_ VGND VGND VPWR VPWR _2178_ sky130_fd_sc_hd__inv_2
XFILLER_0_94_635 VGND VGND VPWR VPWR sky130_fd_sc_hd__decap_8
XFILLER_0_93_101 VGND VGND VPWR VPWR sky130_fd_sc_hd__fill_2
XFILLER_0_66_326 VPWR VGND VPWR VGND sky130_ef_sc_hd__decap_12
XFILLER_0_93_156 VGND VGND VPWR VPWR sky130_fd_sc_hd__fill_2
XFILLER_0_93_123 VPWR VGND VPWR VGND sky130_ef_sc_hd__decap_12
XFILLER_0_19_242 VGND VGND VPWR VPWR sky130_fd_sc_hd__decap_8
XFILLER_0_93_167 VGND VGND VPWR VPWR sky130_fd_sc_hd__fill_1
XFILLER_0_19_275 VGND VGND VPWR VPWR sky130_fd_sc_hd__decap_4
XFILLER_0_105_612 VGND VGND VPWR VPWR sky130_fd_sc_hd__decap_4
XFILLER_0_69_131 VPWR VGND VPWR VGND sky130_ef_sc_hd__decap_12
XFILLER_0_43_27 VPWR VGND VPWR VGND sky130_ef_sc_hd__decap_12
XFILLER_0_84_112 VPWR VGND VPWR VGND sky130_ef_sc_hd__decap_12
XFILLER_0_57_304 VPWR VGND VPWR VGND sky130_ef_sc_hd__decap_12
XTAP_TAPCELL_ROW_33_619 VGND VPWR sky130_fd_sc_hd__tapvpwrvgnd_1
XTAP_TAPCELL_ROW_61_939 VGND VPWR sky130_fd_sc_hd__tapvpwrvgnd_1
XFILLER_0_5_629 VPWR VGND VPWR VGND sky130_ef_sc_hd__decap_12
XFILLER_0_53_532 VGND VGND VPWR VPWR sky130_fd_sc_hd__fill_2
XFILLER_0_80_362 VGND VGND VPWR VPWR sky130_fd_sc_hd__fill_2
XFILLER_0_4_139 VGND VGND VPWR VPWR sky130_fd_sc_hd__fill_1
XFILLER_0_4_117 VPWR VGND VPWR VGND sky130_ef_sc_hd__decap_12
XTAP_TAPCELL_ROW_13_387 VGND VPWR sky130_fd_sc_hd__tapvpwrvgnd_1
XFILLER_0_7_27 VPWR VGND VPWR VGND sky130_ef_sc_hd__decap_12
XFILLER_0_40_204 VPWR VGND VPWR VGND sky130_ef_sc_hd__decap_12
X_4390_ _3413_ _3498_ VGND VGND VPWR VPWR _3500_ sky130_fd_sc_hd__nand2_1
XFILLER_0_40_259 VPWR VGND VPWR VGND sky130_ef_sc_hd__decap_12
XFILLER_0_0_389 VGND VGND VPWR VPWR sky130_fd_sc_hd__decap_3
X_6060_ _1434_ _1436_ VGND VGND VPWR VPWR _1437_ sky130_fd_sc_hd__xnor2_2
XFILLER_0_84_45 VPWR VGND VPWR VGND sky130_ef_sc_hd__decap_12
X_5011_ _1894_ _3358_ _0292_ _0097_ VGND VGND VPWR VPWR _0293_ sky130_fd_sc_hd__o22a_1
XFILLER_0_108_41 VPWR VGND VPWR VGND sky130_ef_sc_hd__decap_12
XFILLER_0_108_85 VPWR VGND VPWR VGND sky130_ef_sc_hd__decap_12
XTAP_TAPCELL_ROW_49_796 VGND VPWR sky130_fd_sc_hd__tapvpwrvgnd_1
X_6962_ _2411_ _2412_ _2422_ VGND VGND VPWR VPWR _2423_ sky130_fd_sc_hd__a21o_2
XFILLER_0_88_484 VPWR VGND VPWR VGND sky130_ef_sc_hd__decap_12
XFILLER_0_76_635 VGND VGND VPWR VPWR sky130_fd_sc_hd__decap_8
X_6893_ _2344_ _2345_ _2346_ VGND VGND VPWR VPWR _2347_ sky130_fd_sc_hd__nand3_2
X_5913_ _2375_ net35 net34 net129 VGND VGND VPWR VPWR _1276_ sky130_fd_sc_hd__and4_1
XFILLER_0_8_401 VGND VGND VPWR VPWR sky130_fd_sc_hd__decap_3
X_5844_ _1062_ _1108_ _1200_ _1199_ VGND VGND VPWR VPWR _1201_ sky130_fd_sc_hd__o211a_1
XFILLER_0_48_348 VPWR VGND VPWR VGND sky130_ef_sc_hd__decap_12
XFILLER_0_63_318 VGND VGND VPWR VPWR sky130_fd_sc_hd__fill_1
XFILLER_0_99_3 VPWR VGND VPWR VGND sky130_ef_sc_hd__decap_12
XFILLER_0_91_649 VGND VGND VPWR VPWR sky130_fd_sc_hd__decap_3
X_7514_ _3018_ _3026_ VGND VGND VPWR VPWR _3027_ sky130_fd_sc_hd__and2_1
XFILLER_0_8_456 VGND VGND VPWR VPWR sky130_fd_sc_hd__fill_2
X_5775_ _1119_ _1124_ VGND VGND VPWR VPWR _1125_ sky130_fd_sc_hd__xnor2_1
X_4726_ _3827_ _3828_ _3820_ VGND VGND VPWR VPWR _3830_ sky130_fd_sc_hd__a21o_1
X_4657_ _3707_ _3706_ VGND VGND VPWR VPWR _3762_ sky130_fd_sc_hd__and2b_1
X_7445_ _2774_ _2789_ _2788_ VGND VGND VPWR VPWR _2951_ sky130_fd_sc_hd__o21ba_1
XFILLER_0_4_651 VGND VGND VPWR VPWR sky130_fd_sc_hd__fill_1
XFILLER_0_44_587 VGND VGND VPWR VPWR sky130_fd_sc_hd__fill_1
X_7376_ _0344_ _2672_ _0355_ _0475_ VGND VGND VPWR VPWR _2875_ sky130_fd_sc_hd__a211oi_1
XFILLER_0_3_150 VPWR VGND VPWR VGND sky130_ef_sc_hd__decap_12
XFILLER_0_12_462 VGND VGND VPWR VPWR sky130_fd_sc_hd__decap_8
X_6327_ _1591_ _1598_ _1597_ VGND VGND VPWR VPWR _1728_ sky130_fd_sc_hd__a21bo_1
X_4588_ _3690_ _3691_ _3693_ VGND VGND VPWR VPWR _3694_ sky130_fd_sc_hd__nand3_1
X_6258_ _0911_ _1652_ VGND VGND VPWR VPWR _1653_ sky130_fd_sc_hd__nand2_1
X_5209_ _3364_ _0401_ _0419_ _0507_ VGND VGND VPWR VPWR net73 sky130_fd_sc_hd__a211o_1
X_6189_ net144 _0433_ _1599_ _0457_ VGND VGND VPWR VPWR _1578_ sky130_fd_sc_hd__a22oi_1
XFILLER_0_98_204 VGND VGND VPWR VPWR sky130_fd_sc_hd__decap_6
XTAP_TAPCELL_ROW_67_1005 VGND VPWR sky130_fd_sc_hd__tapvpwrvgnd_1
XFILLER_0_98_259 VPWR VGND VPWR VGND sky130_ef_sc_hd__decap_12
XFILLER_0_94_421 VPWR VGND VPWR VGND sky130_ef_sc_hd__decap_12
XFILLER_0_79_473 VPWR VGND VPWR VGND sky130_ef_sc_hd__decap_12
XFILLER_0_39_337 VPWR VGND VPWR VGND sky130_ef_sc_hd__decap_12
XFILLER_0_109_225 VPWR VGND VPWR VGND sky130_ef_sc_hd__decap_12
XFILLER_0_82_627 VPWR VGND VPWR VGND sky130_ef_sc_hd__decap_12
XFILLER_0_82_616 VGND VGND VPWR VPWR sky130_fd_sc_hd__fill_1
XFILLER_0_66_178 VPWR VGND VPWR VGND sky130_ef_sc_hd__decap_12
XFILLER_0_54_307 VGND VGND VPWR VPWR sky130_fd_sc_hd__fill_1
XFILLER_0_105_453 VGND VGND VPWR VPWR sky130_fd_sc_hd__fill_1
XTAP_TAPCELL_ROW_78_1134 VGND VPWR sky130_fd_sc_hd__tapvpwrvgnd_1
XTAP_TAPCELL_ROW_10_357 VGND VPWR sky130_fd_sc_hd__tapvpwrvgnd_1
XTAP_TAPCELL_ROW_10_346 VGND VPWR sky130_fd_sc_hd__tapvpwrvgnd_1
XFILLER_0_50_568 VGND VGND VPWR VPWR sky130_fd_sc_hd__fill_1
XTAP_TAPCELL_ROW_89_1263 VGND VPWR sky130_fd_sc_hd__tapvpwrvgnd_1
XFILLER_0_89_237 VPWR VGND VPWR VGND sky130_ef_sc_hd__decap_12
XFILLER_0_85_410 VPWR VGND VPWR VGND sky130_ef_sc_hd__decap_12
XTAP_TAPCELL_ROW_18_446 VGND VPWR sky130_fd_sc_hd__tapvpwrvgnd_1
XTAP_TAPCELL_ROW_46_766 VGND VPWR sky130_fd_sc_hd__tapvpwrvgnd_1
XFILLER_0_97_292 VGND VGND VPWR VPWR sky130_fd_sc_hd__decap_4
XFILLER_0_97_281 VGND VGND VPWR VPWR sky130_fd_sc_hd__fill_2
XFILLER_0_57_123 VGND VGND VPWR VPWR sky130_fd_sc_hd__fill_1
X_3890_ _0148_ _0159_ VGND VGND VPWR VPWR _0551_ sky130_fd_sc_hd__and2_1
XFILLER_0_45_329 VGND VGND VPWR VPWR sky130_fd_sc_hd__decap_6
X_5560_ _0884_ _0890_ VGND VGND VPWR VPWR _0891_ sky130_fd_sc_hd__xnor2_2
XFILLER_0_85_9 VGND VGND VPWR VPWR sky130_fd_sc_hd__fill_1
X_4511_ _3585_ _3587_ VGND VGND VPWR VPWR _3618_ sky130_fd_sc_hd__and2b_1
XFILLER_0_79_23 VPWR VGND VPWR VGND sky130_ef_sc_hd__decap_12
X_5491_ _0812_ _0814_ _0749_ VGND VGND VPWR VPWR _0816_ sky130_fd_sc_hd__a21oi_1
XFILLER_0_26_576 VPWR VGND VPWR VGND sky130_ef_sc_hd__decap_12
X_4442_ _3451_ _3457_ _3311_ VGND VGND VPWR VPWR _3551_ sky130_fd_sc_hd__mux2_1
X_7230_ _2714_ _0922_ _2510_ VGND VGND VPWR VPWR _2716_ sky130_fd_sc_hd__and3_1
XFILLER_0_41_557 VGND VGND VPWR VPWR sky130_fd_sc_hd__decap_3
X_4373_ _3346_ _3481_ _3482_ VGND VGND VPWR VPWR _3483_ sky130_fd_sc_hd__mux2_1
X_7161_ _2637_ _2639_ _2608_ _2609_ VGND VGND VPWR VPWR _2641_ sky130_fd_sc_hd__o211ai_1
XFILLER_0_21_281 VGND VGND VPWR VPWR sky130_fd_sc_hd__fill_1
XFILLER_0_95_55 VGND VGND VPWR VPWR sky130_fd_sc_hd__fill_1
X_7092_ _2397_ _2485_ _0867_ _1075_ VGND VGND VPWR VPWR _2565_ sky130_fd_sc_hd__and4_1
XPHY_EDGE_ROW_13_Left_123 VGND VGND VPWR VPWR sky130_fd_sc_hd__decap_3
XFILLER_0_0_197 VGND VGND VPWR VPWR sky130_fd_sc_hd__decap_8
X_6112_ _1491_ _1492_ _1332_ _1392_ VGND VGND VPWR VPWR _1494_ sky130_fd_sc_hd__o211ai_2
X_6043_ _1406_ _1407_ _1417_ VGND VGND VPWR VPWR _1418_ sky130_fd_sc_hd__a21oi_1
XFILLER_0_14_3 VPWR VGND VPWR VGND sky130_ef_sc_hd__decap_12
X_6945_ _2402_ _2403_ VGND VGND VPWR VPWR _2404_ sky130_fd_sc_hd__xnor2_1
XFILLER_0_76_421 VGND VGND VPWR VPWR sky130_fd_sc_hd__decap_4
XFILLER_0_48_112 VGND VGND VPWR VPWR sky130_fd_sc_hd__fill_2
XFILLER_0_91_402 VGND VGND VPWR VPWR sky130_fd_sc_hd__decap_8
XFILLER_0_76_465 VGND VGND VPWR VPWR sky130_fd_sc_hd__fill_1
XFILLER_0_64_627 VGND VGND VPWR VPWR sky130_fd_sc_hd__fill_1
XPHY_EDGE_ROW_22_Left_132 VGND VGND VPWR VPWR sky130_fd_sc_hd__decap_3
XFILLER_0_36_307 VGND VGND VPWR VPWR sky130_fd_sc_hd__fill_1
X_6876_ _2082_ _2184_ _2215_ _2216_ VGND VGND VPWR VPWR _2328_ sky130_fd_sc_hd__a211o_1
XFILLER_0_91_446 VGND VGND VPWR VPWR sky130_fd_sc_hd__fill_2
X_5827_ _1179_ _1180_ _1181_ VGND VGND VPWR VPWR _1182_ sky130_fd_sc_hd__nand3_1
X_5758_ _0982_ _1000_ _1105_ VGND VGND VPWR VPWR _1106_ sky130_fd_sc_hd__o21a_1
X_4709_ _3811_ _3812_ VGND VGND VPWR VPWR _3813_ sky130_fd_sc_hd__nor2_1
XFILLER_0_102_401 VGND VGND VPWR VPWR sky130_fd_sc_hd__decap_6
X_7428_ _1107_ _2930_ _2931_ VGND VGND VPWR VPWR _2932_ sky130_fd_sc_hd__a21bo_1
X_5689_ _1029_ _1030_ VGND VGND VPWR VPWR _1032_ sky130_fd_sc_hd__nor2_2
XFILLER_0_8_81 VGND VGND VPWR VPWR sky130_fd_sc_hd__decap_3
X_7359_ _2677_ _2682_ _2694_ _2856_ VGND VGND VPWR VPWR net90 sky130_fd_sc_hd__nand4_1
XPHY_EDGE_ROW_31_Left_141 VGND VGND VPWR VPWR sky130_fd_sc_hd__decap_3
XFILLER_0_102_489 VPWR VGND VPWR VGND sky130_ef_sc_hd__decap_12
XTAP_TAPCELL_ROW_73_1075 VGND VPWR sky130_fd_sc_hd__tapvpwrvgnd_1
XFILLER_0_99_546 VPWR VGND VPWR VGND sky130_ef_sc_hd__decap_12
XFILLER_0_79_281 VGND VGND VPWR VPWR sky130_fd_sc_hd__fill_2
XFILLER_0_67_432 VGND VGND VPWR VPWR sky130_fd_sc_hd__decap_8
XTAP_TAPCELL_ROW_15_405 VGND VPWR sky130_fd_sc_hd__tapvpwrvgnd_1
XPHY_EDGE_ROW_40_Left_150 VGND VGND VPWR VPWR sky130_fd_sc_hd__decap_3
XFILLER_0_39_123 VPWR VGND VPWR VGND sky130_ef_sc_hd__decap_12
XFILLER_0_94_251 VGND VGND VPWR VPWR sky130_fd_sc_hd__fill_1
XFILLER_0_39_167 VGND VGND VPWR VPWR sky130_fd_sc_hd__fill_1
XTAP_TAPCELL_ROW_43_736 VGND VPWR sky130_fd_sc_hd__tapvpwrvgnd_1
XFILLER_0_82_413 VGND VGND VPWR VPWR sky130_fd_sc_hd__decap_6
XFILLER_0_55_649 VGND VGND VPWR VPWR sky130_fd_sc_hd__decap_3
XFILLER_0_55_638 VGND VGND VPWR VPWR sky130_fd_sc_hd__fill_1
XFILLER_0_23_513 VPWR VGND VPWR VGND sky130_ef_sc_hd__decap_12
XFILLER_0_105_261 VPWR VGND VPWR VGND sky130_ef_sc_hd__decap_12
XFILLER_0_62_181 VGND VGND VPWR VPWR sky130_fd_sc_hd__decap_4
XFILLER_0_50_365 VGND VGND VPWR VPWR sky130_fd_sc_hd__fill_2
XFILLER_0_65_69 VPWR VGND VPWR VGND sky130_ef_sc_hd__decap_12
XFILLER_0_81_13 VPWR VGND VPWR VGND sky130_ef_sc_hd__decap_12
XFILLER_0_81_57 VGND VGND VPWR VPWR sky130_fd_sc_hd__decap_4
X_4991_ _0076_ _0169_ _0168_ VGND VGND VPWR VPWR _0271_ sky130_fd_sc_hd__a21o_1
X_6730_ _3331_ _3334_ net48 net47 VGND VGND VPWR VPWR _2169_ sky130_fd_sc_hd__nand4_1
X_3942_ _1086_ _1107_ VGND VGND VPWR VPWR _1118_ sky130_fd_sc_hd__and2b_1
X_3873_ net24 net55 VGND VGND VPWR VPWR _0366_ sky130_fd_sc_hd__and2b_1
XFILLER_0_85_273 VGND VGND VPWR VPWR sky130_fd_sc_hd__decap_6
X_6661_ _2082_ _2083_ _2093_ VGND VGND VPWR VPWR _2094_ sky130_fd_sc_hd__and3_1
XFILLER_0_5_212 VGND VGND VPWR VPWR sky130_fd_sc_hd__fill_1
X_6592_ _1838_ _2017_ VGND VGND VPWR VPWR _2018_ sky130_fd_sc_hd__xor2_1
XFILLER_0_45_148 VPWR VGND VPWR VGND sky130_ef_sc_hd__decap_12
X_5612_ _0943_ _0945_ _0857_ VGND VGND VPWR VPWR _0948_ sky130_fd_sc_hd__a21o_1
XFILLER_0_60_118 VGND VGND VPWR VPWR sky130_fd_sc_hd__decap_8
XFILLER_0_5_223 VGND VGND VPWR VPWR sky130_fd_sc_hd__fill_1
X_5543_ _3692_ _0634_ _3253_ _2660_ VGND VGND VPWR VPWR _0872_ sky130_fd_sc_hd__a22oi_1
XFILLER_0_30_83 VGND VGND VPWR VPWR sky130_fd_sc_hd__fill_1
X_5474_ _0674_ _0676_ _0675_ VGND VGND VPWR VPWR _0797_ sky130_fd_sc_hd__o21bai_1
XFILLER_0_14_579 VGND VGND VPWR VPWR sky130_fd_sc_hd__decap_8
X_4425_ _3338_ _3533_ VGND VGND VPWR VPWR _3534_ sky130_fd_sc_hd__nand2_1
X_7213_ _2507_ _2513_ VGND VGND VPWR VPWR _2697_ sky130_fd_sc_hd__nand2_1
X_4356_ _3339_ _3464_ _3465_ VGND VGND VPWR VPWR _3466_ sky130_fd_sc_hd__a21o_1
X_7144_ _2620_ _2621_ VGND VGND VPWR VPWR _2622_ sky130_fd_sc_hd__xnor2_1
X_4287_ _3370_ _3374_ _3397_ _3293_ _3398_ VGND VGND VPWR VPWR _3399_ sky130_fd_sc_hd__a32o_1
X_7075_ _1544_ _0769_ VGND VGND VPWR VPWR _2546_ sky130_fd_sc_hd__nand2_1
X_6026_ _3010_ net43 VGND VGND VPWR VPWR _1399_ sky130_fd_sc_hd__nand2_1
XFILLER_0_96_516 VGND VGND VPWR VPWR sky130_fd_sc_hd__fill_1
XTAP_TAPCELL_ROW_107_1469 VGND VPWR sky130_fd_sc_hd__tapvpwrvgnd_1
XFILLER_0_96_549 VPWR VGND VPWR VGND sky130_ef_sc_hd__decap_12
X_6928_ _2382_ _2383_ _2363_ _2365_ VGND VGND VPWR VPWR _2385_ sky130_fd_sc_hd__a211o_1
X_6859_ _0105_ _0148_ _1089_ VGND VGND VPWR VPWR _2311_ sky130_fd_sc_hd__mux2_1
XFILLER_0_36_115 VGND VGND VPWR VPWR sky130_fd_sc_hd__decap_8
XTAP_TAPCELL_ROW_20_463 VGND VPWR sky130_fd_sc_hd__tapvpwrvgnd_1
XTAP_TAPCELL_ROW_75_1104 VGND VPWR sky130_fd_sc_hd__tapvpwrvgnd_1
XFILLER_0_102_253 VGND VGND VPWR VPWR sky130_fd_sc_hd__decap_4
XFILLER_0_102_264 VPWR VGND VPWR VGND sky130_ef_sc_hd__decap_12
XFILLER_0_3_3 VPWR VGND VPWR VGND sky130_ef_sc_hd__decap_12
XFILLER_0_87_505 VGND VGND VPWR VPWR sky130_fd_sc_hd__decap_8
XTAP_TAPCELL_ROW_86_1222 VGND VPWR sky130_fd_sc_hd__tapvpwrvgnd_1
XTAP_TAPCELL_ROW_56_883 VGND VPWR sky130_fd_sc_hd__tapvpwrvgnd_1
XTAP_TAPCELL_ROW_28_563 VGND VPWR sky130_fd_sc_hd__tapvpwrvgnd_1
XFILLER_0_82_221 VPWR VGND VPWR VGND sky130_ef_sc_hd__decap_12
XFILLER_0_67_273 VGND VGND VPWR VPWR sky130_fd_sc_hd__decap_6
XFILLER_0_82_287 VGND VGND VPWR VPWR sky130_fd_sc_hd__decap_3
XFILLER_0_70_405 VGND VGND VPWR VPWR sky130_fd_sc_hd__fill_2
XTAP_TAPCELL_ROW_97_1351 VGND VPWR sky130_fd_sc_hd__tapvpwrvgnd_1
XFILLER_0_82_298 VGND VGND VPWR VPWR sky130_fd_sc_hd__decap_8
XFILLER_0_51_641 VGND VGND VPWR VPWR sky130_fd_sc_hd__decap_8
XFILLER_0_106_581 VGND VGND VPWR VPWR sky130_fd_sc_hd__decap_6
XFILLER_0_11_505 VPWR VGND VPWR VGND sky130_ef_sc_hd__decap_12
X_4210_ _3321_ VGND VGND VPWR VPWR _3322_ sky130_fd_sc_hd__clkbuf_4
XFILLER_0_50_195 VGND VGND VPWR VPWR sky130_fd_sc_hd__fill_1
X_5190_ _0423_ _0485_ _0487_ VGND VGND VPWR VPWR _0488_ sky130_fd_sc_hd__nor3_4
X_4141_ net34 VGND VGND VPWR VPWR _3253_ sky130_fd_sc_hd__buf_2
X_4072_ _2463_ _2528_ VGND VGND VPWR VPWR _2539_ sky130_fd_sc_hd__nand2_2
XFILLER_0_58_240 VGND VGND VPWR VPWR sky130_fd_sc_hd__decap_4
X_4974_ _0249_ _0250_ _0239_ VGND VGND VPWR VPWR _0252_ sky130_fd_sc_hd__a21o_1
X_6713_ _1508_ _2150_ _0402_ VGND VGND VPWR VPWR _2151_ sky130_fd_sc_hd__mux2_1
X_3925_ _0922_ VGND VGND VPWR VPWR _0933_ sky130_fd_sc_hd__clkbuf_4
X_7693_ _0977_ _3209_ _3210_ _3222_ VGND VGND VPWR VPWR _3223_ sky130_fd_sc_hd__a31o_1
XFILLER_0_18_126 VPWR VGND VPWR VGND sky130_ef_sc_hd__decap_12
XFILLER_0_19_649 VGND VGND VPWR VPWR sky130_fd_sc_hd__decap_3
XFILLER_0_46_413 VGND VGND VPWR VPWR sky130_fd_sc_hd__decap_6
XFILLER_0_73_221 VGND VGND VPWR VPWR sky130_fd_sc_hd__decap_3
XFILLER_0_46_457 VGND VGND VPWR VPWR sky130_fd_sc_hd__decap_6
X_6644_ _2073_ _2074_ VGND VGND VPWR VPWR _2075_ sky130_fd_sc_hd__nor2_1
X_3856_ net16 VGND VGND VPWR VPWR _0181_ sky130_fd_sc_hd__buf_2
XFILLER_0_61_405 VGND VGND VPWR VPWR sky130_fd_sc_hd__decap_8
XFILLER_0_104_518 VPWR VGND VPWR VGND sky130_ef_sc_hd__decap_12
XFILLER_0_81_3 VGND VGND VPWR VPWR sky130_fd_sc_hd__decap_3
X_6575_ _1999_ VGND VGND VPWR VPWR net85 sky130_fd_sc_hd__buf_6
XFILLER_0_14_321 VGND VGND VPWR VPWR sky130_fd_sc_hd__decap_8
XFILLER_0_6_587 VGND VGND VPWR VPWR sky130_fd_sc_hd__fill_1
X_5526_ _0596_ _0836_ _0840_ _0853_ VGND VGND VPWR VPWR _0854_ sky130_fd_sc_hd__o211a_1
XFILLER_0_14_354 VGND VGND VPWR VPWR sky130_fd_sc_hd__fill_1
X_5457_ _3748_ net59 _1829_ net31 VGND VGND VPWR VPWR _0778_ sky130_fd_sc_hd__and4_1
X_4408_ _3306_ _2933_ VGND VGND VPWR VPWR _3517_ sky130_fd_sc_hd__nand2_2
XFILLER_0_1_281 VGND VGND VPWR VPWR sky130_fd_sc_hd__fill_1
X_5388_ _0581_ _0701_ _0702_ VGND VGND VPWR VPWR _0703_ sky130_fd_sc_hd__or3_1
XTAP_TAPCELL_ROW_70_1045 VGND VPWR sky130_fd_sc_hd__tapvpwrvgnd_1
XFILLER_0_10_582 VGND VGND VPWR VPWR sky130_fd_sc_hd__decap_6
X_4339_ _3449_ _3268_ VGND VGND VPWR VPWR _3450_ sky130_fd_sc_hd__nand2_2
X_7127_ _2562_ _2563_ _2600_ _2601_ VGND VGND VPWR VPWR _2603_ sky130_fd_sc_hd__o22ai_1
X_7058_ _2525_ _2526_ VGND VGND VPWR VPWR _2527_ sky130_fd_sc_hd__and2_1
XFILLER_0_5_93 VGND VGND VPWR VPWR sky130_fd_sc_hd__fill_2
X_6009_ _0506_ _1380_ VGND VGND VPWR VPWR _1382_ sky130_fd_sc_hd__nand2_1
XTAP_TAPCELL_ROW_25_522 VGND VPWR sky130_fd_sc_hd__tapvpwrvgnd_1
XTAP_TAPCELL_ROW_53_842 VGND VPWR sky130_fd_sc_hd__tapvpwrvgnd_1
XFILLER_0_37_424 VGND VGND VPWR VPWR sky130_fd_sc_hd__decap_8
XTAP_TAPCELL_ROW_81_1163 VGND VPWR sky130_fd_sc_hd__tapvpwrvgnd_1
XFILLER_0_64_287 VGND VGND VPWR VPWR sky130_fd_sc_hd__decap_8
XTAP_TAPCELL_ROW_92_1292 VGND VPWR sky130_fd_sc_hd__tapvpwrvgnd_1
XTAP_TAPCELL_ROW_5_291 VGND VPWR sky130_fd_sc_hd__tapvpwrvgnd_1
XFILLER_0_87_346 VGND VGND VPWR VPWR sky130_fd_sc_hd__decap_4
XFILLER_0_87_324 VGND VGND VPWR VPWR sky130_fd_sc_hd__decap_3
XFILLER_0_62_15 VPWR VGND VPWR VGND sky130_ef_sc_hd__decap_12
XFILLER_0_68_571 VGND VGND VPWR VPWR sky130_fd_sc_hd__decap_8
XFILLER_0_55_243 VGND VGND VPWR VPWR sky130_fd_sc_hd__fill_1
X_4690_ _3682_ _3793_ _3794_ VGND VGND VPWR VPWR _3795_ sky130_fd_sc_hd__nand3_2
XFILLER_0_43_405 VPWR VGND VPWR VGND sky130_ef_sc_hd__decap_12
XFILLER_0_43_449 VGND VGND VPWR VPWR sky130_fd_sc_hd__decap_4
XFILLER_0_102_65 VPWR VGND VPWR VGND sky130_ef_sc_hd__decap_12
X_6360_ _0463_ _2955_ _1097_ net12 VGND VGND VPWR VPWR _1765_ sky130_fd_sc_hd__and4_1
XFILLER_0_23_140 VPWR VGND VPWR VGND sky130_ef_sc_hd__decap_12
XFILLER_0_87_23 VPWR VGND VPWR VGND sky130_ef_sc_hd__decap_12
X_5311_ _3647_ _0591_ _0592_ _0619_ VGND VGND VPWR VPWR net74 sky130_fd_sc_hd__o31ai_1
XFILLER_0_3_557 VGND VGND VPWR VPWR sky130_fd_sc_hd__decap_3
XFILLER_0_51_460 VPWR VGND VPWR VGND sky130_ef_sc_hd__decap_12
XFILLER_0_11_346 VGND VGND VPWR VPWR sky130_fd_sc_hd__decap_4
X_6291_ _3414_ net46 VGND VGND VPWR VPWR _1689_ sky130_fd_sc_hd__nand2_1
X_5242_ _2474_ _1730_ VGND VGND VPWR VPWR _0544_ sky130_fd_sc_hd__nand2_1
X_5173_ _0466_ _0467_ _0462_ VGND VGND VPWR VPWR _0469_ sky130_fd_sc_hd__o21ai_1
X_4124_ net149 _3097_ VGND VGND VPWR VPWR _3108_ sky130_fd_sc_hd__and2b_1
Xinput1 A[0] VGND VGND VPWR VPWR net1 sky130_fd_sc_hd__buf_1
X_4055_ _2342_ VGND VGND VPWR VPWR _2353_ sky130_fd_sc_hd__buf_4
XFILLER_0_36_93 VGND VGND VPWR VPWR sky130_fd_sc_hd__decap_3
XTAP_TAPCELL_ROW_104_1428 VGND VPWR sky130_fd_sc_hd__tapvpwrvgnd_1
XFILLER_0_108_109 VGND VGND VPWR VPWR sky130_fd_sc_hd__decap_8
XFILLER_0_86_390 VPWR VGND VPWR VGND sky130_ef_sc_hd__decap_12
XFILLER_0_74_552 VGND VGND VPWR VPWR sky130_fd_sc_hd__decap_8
XFILLER_0_19_435 VPWR VGND VPWR VGND sky130_ef_sc_hd__decap_12
X_4957_ _0222_ _0232_ VGND VGND VPWR VPWR _0233_ sky130_fd_sc_hd__xor2_1
XFILLER_0_46_243 VGND VGND VPWR VPWR sky130_fd_sc_hd__decap_8
XTAP_TAPCELL_ROW_50_812 VGND VPWR sky130_fd_sc_hd__tapvpwrvgnd_1
X_3908_ _0726_ _0736_ VGND VGND VPWR VPWR _0747_ sky130_fd_sc_hd__nand2_2
X_7676_ _3074_ _3203_ VGND VGND VPWR VPWR _3204_ sky130_fd_sc_hd__xnor2_1
X_4888_ _0155_ _0156_ _0138_ VGND VGND VPWR VPWR _0158_ sky130_fd_sc_hd__a21oi_1
XFILLER_0_6_362 VGND VGND VPWR VPWR sky130_fd_sc_hd__fill_2
X_6627_ _2041_ _2054_ _2055_ VGND VGND VPWR VPWR _2056_ sky130_fd_sc_hd__or3_4
X_6558_ _0595_ _1977_ _1978_ _1979_ VGND VGND VPWR VPWR _1981_ sky130_fd_sc_hd__or4_1
XFILLER_0_61_279 VGND VGND VPWR VPWR sky130_fd_sc_hd__fill_1
XFILLER_0_15_641 VGND VGND VPWR VPWR sky130_fd_sc_hd__decap_8
XTAP_TAPCELL_ROW_30_580 VGND VPWR sky130_fd_sc_hd__tapvpwrvgnd_1
XFILLER_0_14_173 VGND VGND VPWR VPWR sky130_fd_sc_hd__decap_8
X_5509_ _0747_ _0834_ VGND VGND VPWR VPWR _0836_ sky130_fd_sc_hd__xor2_1
XPHY_EDGE_ROW_5_Left_115 VGND VGND VPWR VPWR sky130_fd_sc_hd__decap_3
X_6489_ _1887_ _1903_ _1904_ VGND VGND VPWR VPWR _1906_ sky130_fd_sc_hd__and3_1
XFILLER_0_42_493 VPWR VGND VPWR VGND sky130_ef_sc_hd__decap_12
XFILLER_0_100_598 VPWR VGND VPWR VGND sky130_ef_sc_hd__decap_12
XFILLER_0_100_587 VGND VGND VPWR VPWR sky130_fd_sc_hd__fill_1
XTAP_TAPCELL_ROW_58_901 VGND VPWR sky130_fd_sc_hd__tapvpwrvgnd_1
XFILLER_0_69_302 VPWR VGND VPWR VGND sky130_ef_sc_hd__decap_12
XTAP_TAPCELL_ROW_2_261 VGND VPWR sky130_fd_sc_hd__tapvpwrvgnd_1
XFILLER_0_96_132 VGND VGND VPWR VPWR sky130_fd_sc_hd__decap_8
XFILLER_0_69_357 VGND VGND VPWR VPWR sky130_fd_sc_hd__fill_1
XFILLER_0_96_165 VGND VGND VPWR VPWR sky130_fd_sc_hd__decap_4
XFILLER_0_32_29 VPWR VGND VPWR VGND sky130_ef_sc_hd__decap_12
XFILLER_0_65_530 VGND VGND VPWR VPWR sky130_fd_sc_hd__decap_8
XFILLER_0_37_221 VGND VGND VPWR VPWR sky130_fd_sc_hd__decap_3
XFILLER_0_108_643 VGND VGND VPWR VPWR sky130_fd_sc_hd__fill_1
XFILLER_0_65_574 VGND VGND VPWR VPWR sky130_fd_sc_hd__fill_2
XFILLER_0_37_276 VGND VGND VPWR VPWR sky130_fd_sc_hd__decap_4
XFILLER_0_25_438 VGND VGND VPWR VPWR sky130_fd_sc_hd__decap_6
XFILLER_0_52_213 VPWR VGND VPWR VGND sky130_ef_sc_hd__decap_12
XTAP_TAPCELL_ROW_94_1321 VGND VPWR sky130_fd_sc_hd__tapvpwrvgnd_1
XFILLER_0_40_419 VGND VGND VPWR VPWR sky130_fd_sc_hd__fill_1
XFILLER_0_0_527 VGND VGND VPWR VPWR sky130_fd_sc_hd__fill_1
XFILLER_0_20_132 VGND VGND VPWR VPWR sky130_fd_sc_hd__decap_8
XFILLER_0_20_165 VGND VGND VPWR VPWR sky130_fd_sc_hd__decap_8
XFILLER_0_88_622 VGND VGND VPWR VPWR sky130_fd_sc_hd__decap_6
XPHY_EDGE_ROW_69_Left_179 VGND VGND VPWR VPWR sky130_fd_sc_hd__decap_3
XFILLER_0_87_132 VGND VGND VPWR VPWR sky130_fd_sc_hd__decap_4
X_5860_ _1249_ _1083_ _1228_ VGND VGND VPWR VPWR _1219_ sky130_fd_sc_hd__o21ai_1
XFILLER_0_87_165 VGND VGND VPWR VPWR sky130_fd_sc_hd__decap_3
XFILLER_0_75_305 VPWR VGND VPWR VGND sky130_ef_sc_hd__decap_12
X_4811_ _0071_ _0073_ _3836_ _3838_ VGND VGND VPWR VPWR _0075_ sky130_fd_sc_hd__a211o_1
XFILLER_0_75_349 VPWR VGND VPWR VGND sky130_ef_sc_hd__decap_12
XFILLER_0_68_390 VGND VGND VPWR VPWR sky130_fd_sc_hd__fill_2
X_5791_ _3772_ _3777_ _0634_ _3253_ VGND VGND VPWR VPWR _1143_ sky130_fd_sc_hd__and4_1
X_4742_ _3710_ _3799_ _0001_ VGND VGND VPWR VPWR _0003_ sky130_fd_sc_hd__or3_1
X_7530_ _2879_ _2880_ _3042_ VGND VGND VPWR VPWR _3045_ sky130_fd_sc_hd__nand3_1
XFILLER_0_28_265 VPWR VGND VPWR VGND sky130_ef_sc_hd__decap_12
X_7461_ _2778_ _2783_ _2784_ VGND VGND VPWR VPWR _2969_ sky130_fd_sc_hd__or3_1
X_4673_ _3032_ _3777_ VGND VGND VPWR VPWR _3778_ sky130_fd_sc_hd__nand2_1
X_6412_ _0729_ _0845_ _1821_ _0848_ VGND VGND VPWR VPWR _1822_ sky130_fd_sc_hd__a211o_1
XPHY_EDGE_ROW_78_Left_188 VGND VGND VPWR VPWR sky130_fd_sc_hd__decap_3
X_7392_ _2638_ _0094_ _3431_ VGND VGND VPWR VPWR _2893_ sky130_fd_sc_hd__nand3_1
XFILLER_0_71_588 VPWR VGND VPWR VGND sky130_ef_sc_hd__decap_12
XFILLER_0_101_307 VGND VGND VPWR VPWR sky130_fd_sc_hd__decap_3
X_6343_ _1728_ _1744_ _1745_ VGND VGND VPWR VPWR _1746_ sky130_fd_sc_hd__nand3_2
X_6274_ _0506_ _1653_ _1655_ _1664_ _1670_ VGND VGND VPWR VPWR _1671_ sky130_fd_sc_hd__a311o_1
X_5225_ _0523_ _0524_ VGND VGND VPWR VPWR _0525_ sky130_fd_sc_hd__xnor2_2
X_5156_ _3748_ net28 _2452_ net29 VGND VGND VPWR VPWR _0450_ sky130_fd_sc_hd__a22o_1
XFILLER_0_47_81 VPWR VGND VPWR VGND sky130_ef_sc_hd__decap_12
XPHY_EDGE_ROW_87_Left_197 VGND VGND VPWR VPWR sky130_fd_sc_hd__decap_3
X_5087_ _0305_ _0373_ _3647_ VGND VGND VPWR VPWR _0375_ sky130_fd_sc_hd__a21o_1
X_4107_ _2911_ VGND VGND VPWR VPWR _2922_ sky130_fd_sc_hd__clkbuf_4
X_4038_ _0878_ VGND VGND VPWR VPWR _2167_ sky130_fd_sc_hd__inv_2
XFILLER_0_78_132 VGND VGND VPWR VPWR sky130_fd_sc_hd__decap_8
XFILLER_0_2_83 VGND VGND VPWR VPWR sky130_fd_sc_hd__fill_1
XFILLER_0_93_113 VGND VGND VPWR VPWR sky130_fd_sc_hd__decap_6
XFILLER_0_63_80 VGND VGND VPWR VPWR sky130_fd_sc_hd__decap_6
X_5989_ _0376_ VGND VGND VPWR VPWR _1360_ sky130_fd_sc_hd__buf_2
XFILLER_0_93_135 VGND VGND VPWR VPWR sky130_fd_sc_hd__fill_1
XFILLER_0_66_338 VGND VGND VPWR VPWR sky130_fd_sc_hd__decap_6
XFILLER_0_59_390 VGND VGND VPWR VPWR sky130_fd_sc_hd__fill_2
XFILLER_0_62_533 VGND VGND VPWR VPWR sky130_fd_sc_hd__decap_4
X_7659_ _3324_ _0116_ _3023_ _3022_ VGND VGND VPWR VPWR _3186_ sky130_fd_sc_hd__a31o_1
XFILLER_0_62_577 VGND VGND VPWR VPWR sky130_fd_sc_hd__decap_8
XFILLER_0_62_544 VGND VGND VPWR VPWR sky130_fd_sc_hd__decap_8
XFILLER_0_22_419 VGND VGND VPWR VPWR sky130_fd_sc_hd__fill_1
XTAP_TAPCELL_ROW_7_320 VGND VPWR sky130_fd_sc_hd__tapvpwrvgnd_1
XFILLER_0_100_362 VGND VGND VPWR VPWR sky130_fd_sc_hd__fill_2
XFILLER_0_69_143 VPWR VGND VPWR VGND sky130_ef_sc_hd__decap_12
XFILLER_0_57_316 VGND VGND VPWR VPWR sky130_fd_sc_hd__fill_2
XFILLER_0_43_39 VPWR VGND VPWR VGND sky130_ef_sc_hd__decap_12
XFILLER_0_84_124 VPWR VGND VPWR VGND sky130_ef_sc_hd__decap_12
XFILLER_0_38_530 VGND VGND VPWR VPWR sky130_fd_sc_hd__fill_2
XFILLER_0_108_440 VGND VGND VPWR VPWR sky130_fd_sc_hd__decap_8
XFILLER_0_65_371 VPWR VGND VPWR VGND sky130_ef_sc_hd__decap_12
XTAP_TAPCELL_ROW_13_388 VGND VPWR sky130_fd_sc_hd__tapvpwrvgnd_1
XFILLER_0_25_279 VGND VGND VPWR VPWR sky130_fd_sc_hd__fill_1
XFILLER_0_40_216 VGND VGND VPWR VPWR sky130_fd_sc_hd__decap_4
XFILLER_0_7_39 VPWR VGND VPWR VGND sky130_ef_sc_hd__decap_12
X_5010_ _1894_ _1544_ VGND VGND VPWR VPWR _0292_ sky130_fd_sc_hd__nor2_1
XFILLER_0_108_53 VPWR VGND VPWR VGND sky130_ef_sc_hd__decap_12
XFILLER_0_84_57 VGND VGND VPWR VPWR sky130_fd_sc_hd__decap_4
XFILLER_0_108_97 VPWR VGND VPWR VGND sky130_ef_sc_hd__decap_12
X_6961_ _2413_ _2421_ VGND VGND VPWR VPWR _2422_ sky130_fd_sc_hd__xnor2_1
XTAP_TAPCELL_ROW_49_797 VGND VPWR sky130_fd_sc_hd__tapvpwrvgnd_1
XFILLER_0_88_496 VGND VGND VPWR VPWR sky130_fd_sc_hd__decap_8
XFILLER_0_88_474 VGND VGND VPWR VPWR sky130_fd_sc_hd__fill_2
XFILLER_0_76_603 VGND VGND VPWR VPWR sky130_fd_sc_hd__decap_3
X_5912_ _2375_ _0634_ _1971_ _1708_ VGND VGND VPWR VPWR _1275_ sky130_fd_sc_hd__o2bb2a_1
XFILLER_0_48_316 VGND VGND VPWR VPWR sky130_fd_sc_hd__decap_8
X_6892_ _2193_ _2198_ _2192_ VGND VGND VPWR VPWR _2346_ sky130_fd_sc_hd__a21bo_1
XFILLER_0_75_113 VPWR VGND VPWR VGND sky130_ef_sc_hd__decap_12
X_5843_ _1134_ _1135_ _1197_ _1198_ VGND VGND VPWR VPWR _1200_ sky130_fd_sc_hd__a2bb2o_1
XFILLER_0_91_617 VPWR VGND VPWR VGND sky130_ef_sc_hd__decap_12
X_7513_ _3019_ _3025_ VGND VGND VPWR VPWR _3026_ sky130_fd_sc_hd__xor2_1
X_5774_ _1122_ _1123_ VGND VGND VPWR VPWR _1124_ sky130_fd_sc_hd__xnor2_1
XFILLER_0_44_533 VGND VGND VPWR VPWR sky130_fd_sc_hd__decap_4
XFILLER_0_44_544 VGND VGND VPWR VPWR sky130_fd_sc_hd__decap_3
X_4725_ _3820_ _3827_ _3828_ VGND VGND VPWR VPWR _3829_ sky130_fd_sc_hd__nand3_1
X_7444_ _2948_ _2949_ VGND VGND VPWR VPWR _2950_ sky130_fd_sc_hd__xor2_1
X_4656_ _3364_ _3741_ _3757_ _3760_ VGND VGND VPWR VPWR _3761_ sky130_fd_sc_hd__a211o_1
XFILLER_0_44_577 VGND VGND VPWR VPWR sky130_fd_sc_hd__decap_3
X_7375_ _2858_ _2873_ VGND VGND VPWR VPWR _2874_ sky130_fd_sc_hd__nor2_1
XFILLER_0_3_162 VGND VGND VPWR VPWR sky130_fd_sc_hd__decap_6
X_4587_ _2911_ _3518_ _3521_ _3692_ VGND VGND VPWR VPWR _3693_ sky130_fd_sc_hd__a22o_1
XFILLER_0_101_126 VGND VGND VPWR VPWR sky130_fd_sc_hd__decap_6
X_6326_ _1576_ _1583_ VGND VGND VPWR VPWR _1727_ sky130_fd_sc_hd__and2_1
XFILLER_0_101_159 VGND VGND VPWR VPWR sky130_fd_sc_hd__fill_1
XPHY_EDGE_ROW_95_Left_205 VGND VGND VPWR VPWR sky130_fd_sc_hd__decap_3
X_6257_ _1042_ _1380_ _1514_ _1513_ VGND VGND VPWR VPWR _1652_ sky130_fd_sc_hd__a31o_1
X_5208_ _0499_ _0500_ _0502_ _0505_ _0506_ VGND VGND VPWR VPWR _0507_ sky130_fd_sc_hd__a32o_1
X_6188_ _1574_ _1575_ VGND VGND VPWR VPWR _1576_ sky130_fd_sc_hd__xnor2_2
X_5139_ _3508_ _1523_ VGND VGND VPWR VPWR _0432_ sky130_fd_sc_hd__nand2_1
XFILLER_0_98_238 VGND VGND VPWR VPWR sky130_fd_sc_hd__fill_1
XFILLER_0_98_216 VGND VGND VPWR VPWR sky130_fd_sc_hd__decap_6
XTAP_TAPCELL_ROW_67_1006 VGND VPWR sky130_fd_sc_hd__tapvpwrvgnd_1
XFILLER_0_79_430 VGND VGND VPWR VPWR sky130_fd_sc_hd__decap_3
XFILLER_0_79_485 VGND VGND VPWR VPWR sky130_fd_sc_hd__decap_3
XFILLER_0_39_305 VPWR VGND VPWR VGND sky130_ef_sc_hd__decap_12
XFILLER_0_94_433 VPWR VGND VPWR VGND sky130_ef_sc_hd__decap_12
XFILLER_0_67_647 VGND VGND VPWR VPWR sky130_fd_sc_hd__fill_1
XFILLER_0_39_349 VPWR VGND VPWR VGND sky130_ef_sc_hd__decap_12
XFILLER_0_109_237 VPWR VGND VPWR VGND sky130_ef_sc_hd__decap_12
XFILLER_0_94_477 VPWR VGND VPWR VGND sky130_ef_sc_hd__decap_12
XFILLER_0_82_639 VGND VGND VPWR VPWR sky130_fd_sc_hd__decap_4
XFILLER_0_81_138 VPWR VGND VPWR VGND sky130_ef_sc_hd__decap_12
XFILLER_0_35_500 VGND VGND VPWR VPWR sky130_fd_sc_hd__decap_4
XFILLER_0_105_410 VGND VGND VPWR VPWR sky130_fd_sc_hd__decap_8
XTAP_TAPCELL_ROW_78_1135 VGND VPWR sky130_fd_sc_hd__tapvpwrvgnd_1
XFILLER_0_62_363 VGND VGND VPWR VPWR sky130_fd_sc_hd__fill_1
XTAP_TAPCELL_ROW_10_347 VGND VPWR sky130_fd_sc_hd__tapvpwrvgnd_1
XFILLER_0_7_490 VGND VGND VPWR VPWR sky130_fd_sc_hd__decap_3
XFILLER_0_30_260 VPWR VGND VPWR VGND sky130_ef_sc_hd__decap_12
XFILLER_0_89_205 VGND VGND VPWR VPWR sky130_fd_sc_hd__fill_2
XTAP_TAPCELL_ROW_89_1264 VGND VPWR sky130_fd_sc_hd__tapvpwrvgnd_1
XFILLER_0_89_216 VGND VGND VPWR VPWR sky130_fd_sc_hd__decap_8
XFILLER_0_89_249 VGND VGND VPWR VPWR sky130_fd_sc_hd__decap_3
XFILLER_0_97_271 VGND VGND VPWR VPWR sky130_fd_sc_hd__fill_1
XTAP_TAPCELL_ROW_18_447 VGND VPWR sky130_fd_sc_hd__tapvpwrvgnd_1
XTAP_TAPCELL_ROW_46_767 VGND VPWR sky130_fd_sc_hd__tapvpwrvgnd_1
XFILLER_0_85_422 VPWR VGND VPWR VGND sky130_ef_sc_hd__decap_12
XFILLER_0_70_26 VGND VGND VPWR VPWR sky130_fd_sc_hd__fill_2
XFILLER_0_73_617 VGND VGND VPWR VPWR sky130_fd_sc_hd__decap_3
XFILLER_0_70_37 VGND VGND VPWR VPWR sky130_fd_sc_hd__decap_3
XFILLER_0_85_488 VPWR VGND VPWR VGND sky130_ef_sc_hd__decap_12
XFILLER_0_73_639 VGND VGND VPWR VPWR sky130_fd_sc_hd__fill_1
XFILLER_0_26_533 VPWR VGND VPWR VGND sky130_ef_sc_hd__decap_12
X_4510_ _3589_ _3590_ _3591_ _3617_ VGND VGND VPWR VPWR net95 sky130_fd_sc_hd__a31o_1
XFILLER_0_79_35 VGND VGND VPWR VPWR sky130_fd_sc_hd__decap_8
XFILLER_0_5_449 VGND VGND VPWR VPWR sky130_fd_sc_hd__decap_6
X_5490_ _0814_ _0812_ _0749_ VGND VGND VPWR VPWR _0815_ sky130_fd_sc_hd__and3_1
XFILLER_0_41_514 VGND VGND VPWR VPWR sky130_fd_sc_hd__decap_4
XFILLER_0_41_525 VPWR VGND VPWR VGND sky130_ef_sc_hd__decap_12
XFILLER_0_53_352 VGND VGND VPWR VPWR sky130_fd_sc_hd__decap_3
X_4441_ _3548_ _3549_ _3320_ VGND VGND VPWR VPWR _3550_ sky130_fd_sc_hd__mux2_1
XFILLER_0_102_3 VPWR VGND VPWR VGND sky130_ef_sc_hd__decap_12
XFILLER_0_79_57 VGND VGND VPWR VPWR sky130_fd_sc_hd__decap_8
XFILLER_0_13_249 VGND VGND VPWR VPWR sky130_fd_sc_hd__decap_3
X_7160_ _2608_ _2609_ _2637_ _2639_ VGND VGND VPWR VPWR _2640_ sky130_fd_sc_hd__a211o_1
XPHY_EDGE_ROW_9_Right_9 VGND VGND VPWR VPWR sky130_fd_sc_hd__decap_3
X_4372_ _3407_ VGND VGND VPWR VPWR _3482_ sky130_fd_sc_hd__clkbuf_4
X_6111_ _1332_ _1392_ _1491_ _1492_ VGND VGND VPWR VPWR _1493_ sky130_fd_sc_hd__a211o_4
X_7091_ _2485_ _0878_ _1075_ _2397_ VGND VGND VPWR VPWR _2564_ sky130_fd_sc_hd__a22oi_1
XPHY_EDGE_ROW_107_Right_107 VGND VGND VPWR VPWR sky130_fd_sc_hd__decap_3
X_6042_ _1408_ _1416_ VGND VGND VPWR VPWR _1417_ sky130_fd_sc_hd__xnor2_1
XFILLER_0_28_61 VGND VGND VPWR VPWR sky130_fd_sc_hd__fill_1
XFILLER_0_28_72 VGND VGND VPWR VPWR sky130_fd_sc_hd__decap_4
XFILLER_0_28_83 VGND VGND VPWR VPWR sky130_fd_sc_hd__fill_1
XFILLER_0_95_208 VPWR VGND VPWR VGND sky130_ef_sc_hd__decap_12
X_6944_ _2397_ _1031_ VGND VGND VPWR VPWR _2403_ sky130_fd_sc_hd__nand2_1
XFILLER_0_76_444 VGND VGND VPWR VPWR sky130_fd_sc_hd__decap_3
XFILLER_0_44_93 VGND VGND VPWR VPWR sky130_fd_sc_hd__fill_1
XFILLER_0_76_477 VGND VGND VPWR VPWR sky130_fd_sc_hd__decap_6
XFILLER_0_8_221 VGND VGND VPWR VPWR sky130_fd_sc_hd__decap_6
X_6875_ _2183_ _2286_ _2287_ VGND VGND VPWR VPWR _2327_ sky130_fd_sc_hd__nor3_1
XFILLER_0_91_414 VPWR VGND VPWR VGND sky130_ef_sc_hd__decap_12
X_5826_ _1041_ _1044_ _1043_ VGND VGND VPWR VPWR _1181_ sky130_fd_sc_hd__o21bai_1
XFILLER_0_17_500 VGND VGND VPWR VPWR sky130_fd_sc_hd__decap_4
X_5757_ _0983_ _0999_ VGND VGND VPWR VPWR _1105_ sky130_fd_sc_hd__nand2_1
XFILLER_0_8_298 VGND VGND VPWR VPWR sky130_fd_sc_hd__fill_2
XFILLER_0_44_363 VGND VGND VPWR VPWR sky130_fd_sc_hd__fill_1
X_4708_ _3010_ _3809_ _2506_ _3508_ VGND VGND VPWR VPWR _3812_ sky130_fd_sc_hd__a22oi_1
X_7427_ _1621_ _1107_ _0998_ _1807_ VGND VGND VPWR VPWR _2931_ sky130_fd_sc_hd__a22o_1
X_5688_ _2495_ _1927_ _1555_ _2342_ VGND VGND VPWR VPWR _1030_ sky130_fd_sc_hd__a22oi_1
X_4639_ _3322_ _3539_ VGND VGND VPWR VPWR _3744_ sky130_fd_sc_hd__or2_1
XFILLER_0_4_493 VGND VGND VPWR VPWR sky130_fd_sc_hd__decap_3
X_7358_ _3647_ _2852_ _2854_ _2855_ VGND VGND VPWR VPWR _2856_ sky130_fd_sc_hd__or4_2
XFILLER_0_12_271 VPWR VGND VPWR VGND sky130_ef_sc_hd__decap_12
XFILLER_0_12_260 VGND VGND VPWR VPWR sky130_fd_sc_hd__fill_1
X_7289_ _2091_ _1468_ _1391_ _0715_ VGND VGND VPWR VPWR _2781_ sky130_fd_sc_hd__nand4_1
X_6309_ _2375_ _2069_ _0018_ _0693_ VGND VGND VPWR VPWR _1709_ sky130_fd_sc_hd__nand4_1
XTAP_TAPCELL_ROW_73_1076 VGND VPWR sky130_fd_sc_hd__tapvpwrvgnd_1
XFILLER_0_99_558 VGND VGND VPWR VPWR sky130_fd_sc_hd__fill_2
XFILLER_0_86_219 VPWR VGND VPWR VGND sky130_ef_sc_hd__decap_12
XFILLER_0_86_208 VGND VGND VPWR VPWR sky130_fd_sc_hd__fill_2
XTAP_TAPCELL_ROW_15_406 VGND VPWR sky130_fd_sc_hd__tapvpwrvgnd_1
XFILLER_0_39_135 VGND VGND VPWR VPWR sky130_fd_sc_hd__fill_2
XTAP_TAPCELL_ROW_43_726 VGND VPWR sky130_fd_sc_hd__tapvpwrvgnd_1
XFILLER_0_27_308 VPWR VGND VPWR VGND sky130_ef_sc_hd__decap_12
XFILLER_0_82_447 VPWR VGND VPWR VGND sky130_ef_sc_hd__decap_12
XFILLER_0_63_650 VGND VGND VPWR VPWR sky130_fd_sc_hd__fill_2
XFILLER_0_62_160 VPWR VGND VPWR VGND sky130_ef_sc_hd__decap_12
XFILLER_0_23_525 VPWR VGND VPWR VGND sky130_ef_sc_hd__decap_12
XFILLER_0_105_273 VGND VGND VPWR VPWR sky130_fd_sc_hd__decap_6
XFILLER_0_50_377 VPWR VGND VPWR VGND sky130_ef_sc_hd__decap_12
XFILLER_0_49_49 VGND VGND VPWR VPWR sky130_fd_sc_hd__decap_6
XFILLER_0_4_29 VPWR VGND VPWR VGND sky130_ef_sc_hd__decap_12
XFILLER_0_81_25 VGND VGND VPWR VPWR sky130_fd_sc_hd__decap_6
XFILLER_0_98_580 VGND VGND VPWR VPWR sky130_fd_sc_hd__decap_8
XFILLER_0_81_69 VGND VGND VPWR VPWR sky130_fd_sc_hd__fill_2
X_4990_ _0267_ _0269_ VGND VGND VPWR VPWR _0270_ sky130_fd_sc_hd__and2_1
XFILLER_0_85_241 VGND VGND VPWR VPWR sky130_fd_sc_hd__decap_4
X_3941_ _1097_ VGND VGND VPWR VPWR _1107_ sky130_fd_sc_hd__clkbuf_4
XFILLER_0_58_477 VPWR VGND VPWR VGND sky130_ef_sc_hd__decap_12
XFILLER_0_14_63 VPWR VGND VPWR VGND sky130_ef_sc_hd__decap_12
X_3872_ _0322_ _0311_ VGND VGND VPWR VPWR _0355_ sky130_fd_sc_hd__nor2b_1
XFILLER_0_14_96 VGND VGND VPWR VPWR sky130_fd_sc_hd__fill_2
XFILLER_0_14_85 VGND VGND VPWR VPWR sky130_fd_sc_hd__decap_6
X_6660_ _2084_ _2092_ VGND VGND VPWR VPWR _2093_ sky130_fd_sc_hd__xnor2_1
XFILLER_0_46_639 VGND VGND VPWR VPWR sky130_fd_sc_hd__fill_1
XFILLER_0_73_458 VGND VGND VPWR VPWR sky130_fd_sc_hd__decap_6
XFILLER_0_73_447 VGND VGND VPWR VPWR sky130_fd_sc_hd__fill_1
X_5611_ _0946_ VGND VGND VPWR VPWR _0947_ sky130_fd_sc_hd__inv_2
X_6591_ _1835_ _2016_ VGND VGND VPWR VPWR _2017_ sky130_fd_sc_hd__xnor2_1
X_5542_ _2649_ _2550_ _0634_ net34 VGND VGND VPWR VPWR _0871_ sky130_fd_sc_hd__and4_1
XFILLER_0_5_279 VGND VGND VPWR VPWR sky130_fd_sc_hd__fill_1
XFILLER_0_5_257 VGND VGND VPWR VPWR sky130_fd_sc_hd__decap_4
XFILLER_0_30_51 VGND VGND VPWR VPWR sky130_fd_sc_hd__fill_1
X_5473_ _0793_ _0794_ _0792_ VGND VGND VPWR VPWR _0796_ sky130_fd_sc_hd__o21ai_1
X_4424_ _3435_ _3432_ _3310_ VGND VGND VPWR VPWR _3533_ sky130_fd_sc_hd__mux2_1
X_7212_ _2505_ _2504_ VGND VGND VPWR VPWR _2696_ sky130_fd_sc_hd__or2b_1
XFILLER_0_41_377 VGND VGND VPWR VPWR sky130_fd_sc_hd__decap_4
X_4355_ _3407_ _3321_ _3388_ VGND VGND VPWR VPWR _3465_ sky130_fd_sc_hd__and3_1
X_7143_ _3334_ _0116_ VGND VGND VPWR VPWR _2621_ sky130_fd_sc_hd__nand2_1
X_7074_ _2543_ _2544_ VGND VGND VPWR VPWR _2545_ sky130_fd_sc_hd__nor2_1
X_4286_ _3361_ _3298_ VGND VGND VPWR VPWR _3398_ sky130_fd_sc_hd__nor2_1
X_6025_ _1396_ _1397_ VGND VGND VPWR VPWR _1398_ sky130_fd_sc_hd__nor2_1
X_6927_ _2363_ _2365_ _2382_ _2383_ VGND VGND VPWR VPWR _2384_ sky130_fd_sc_hd__o211ai_2
X_6858_ _0627_ _2306_ _2308_ VGND VGND VPWR VPWR _2309_ sky130_fd_sc_hd__o21ai_1
XFILLER_0_76_285 VGND VGND VPWR VPWR sky130_fd_sc_hd__fill_2
XFILLER_0_107_505 VPWR VGND VPWR VGND sky130_ef_sc_hd__decap_12
X_5809_ _2452_ _0457_ net144 _2342_ VGND VGND VPWR VPWR _1163_ sky130_fd_sc_hd__a22oi_1
XFILLER_0_17_363 VPWR VGND VPWR VGND sky130_ef_sc_hd__decap_12
X_6789_ _2231_ _2232_ VGND VGND VPWR VPWR _2234_ sky130_fd_sc_hd__xnor2_1
XTAP_TAPCELL_ROW_20_464 VGND VPWR sky130_fd_sc_hd__tapvpwrvgnd_1
XFILLER_0_20_506 VPWR VGND VPWR VGND sky130_ef_sc_hd__decap_12
XFILLER_0_32_388 VPWR VGND VPWR VGND sky130_ef_sc_hd__decap_12
XFILLER_0_102_276 VPWR VGND VPWR VGND sky130_ef_sc_hd__decap_12
XFILLER_0_99_377 VGND VGND VPWR VPWR sky130_fd_sc_hd__fill_2
XTAP_TAPCELL_ROW_86_1223 VGND VPWR sky130_fd_sc_hd__tapvpwrvgnd_1
XTAP_TAPCELL_ROW_56_884 VGND VPWR sky130_fd_sc_hd__tapvpwrvgnd_1
XTAP_TAPCELL_ROW_28_553 VGND VPWR sky130_fd_sc_hd__tapvpwrvgnd_1
XTAP_TAPCELL_ROW_28_564 VGND VPWR sky130_fd_sc_hd__tapvpwrvgnd_1
XFILLER_0_95_561 VPWR VGND VPWR VGND sky130_ef_sc_hd__decap_12
XFILLER_0_55_425 VPWR VGND VPWR VGND sky130_ef_sc_hd__decap_12
XFILLER_0_27_105 VGND VGND VPWR VPWR sky130_fd_sc_hd__decap_6
XFILLER_0_82_233 VPWR VGND VPWR VGND sky130_ef_sc_hd__decap_12
XTAP_TAPCELL_ROW_97_1352 VGND VPWR sky130_fd_sc_hd__tapvpwrvgnd_1
XFILLER_0_35_193 VGND VGND VPWR VPWR sky130_fd_sc_hd__decap_6
XFILLER_0_11_517 VPWR VGND VPWR VGND sky130_ef_sc_hd__decap_12
XFILLER_0_23_388 VGND VGND VPWR VPWR sky130_fd_sc_hd__decap_4
X_4140_ _2430_ _2539_ _3238_ _3251_ VGND VGND VPWR VPWR _3252_ sky130_fd_sc_hd__a31o_1
X_4071_ _2485_ _2517_ VGND VGND VPWR VPWR _2528_ sky130_fd_sc_hd__or2_1
XFILLER_0_92_35 VGND VGND VPWR VPWR sky130_fd_sc_hd__decap_6
XFILLER_0_92_68 VGND VGND VPWR VPWR sky130_fd_sc_hd__decap_8
XFILLER_0_78_506 VPWR VGND VPWR VGND sky130_ef_sc_hd__decap_12
XFILLER_0_25_84 VGND VGND VPWR VPWR sky130_fd_sc_hd__decap_8
X_4973_ _0239_ _0249_ _0250_ VGND VGND VPWR VPWR _0251_ sky130_fd_sc_hd__nand3_1
X_6712_ _1815_ _2149_ _0842_ VGND VGND VPWR VPWR _2150_ sky130_fd_sc_hd__mux2_1
X_7692_ _3221_ VGND VGND VPWR VPWR _3222_ sky130_fd_sc_hd__inv_2
XFILLER_0_58_285 VPWR VGND VPWR VGND sky130_ef_sc_hd__decap_12
XFILLER_0_19_617 VPWR VGND VPWR VGND sky130_ef_sc_hd__decap_12
X_3924_ net15 VGND VGND VPWR VPWR _0922_ sky130_fd_sc_hd__buf_2
XFILLER_0_18_138 VGND VGND VPWR VPWR sky130_fd_sc_hd__fill_2
X_6643_ _3449_ _3623_ net17 _1097_ VGND VGND VPWR VPWR _2074_ sky130_fd_sc_hd__and4_1
X_3855_ _0148_ _0159_ VGND VGND VPWR VPWR _0170_ sky130_fd_sc_hd__or2b_1
XFILLER_0_73_277 VGND VGND VPWR VPWR sky130_fd_sc_hd__decap_3
XFILLER_0_6_533 VPWR VGND VPWR VGND sky130_ef_sc_hd__decap_12
X_6574_ _1998_ _1983_ _1976_ VGND VGND VPWR VPWR _1999_ sky130_fd_sc_hd__or3_4
XFILLER_0_61_439 VGND VGND VPWR VPWR sky130_fd_sc_hd__decap_3
X_5525_ _3304_ _3397_ _0852_ VGND VGND VPWR VPWR _0853_ sky130_fd_sc_hd__a21oi_1
XFILLER_0_41_130 VPWR VGND VPWR VGND sky130_ef_sc_hd__decap_12
X_5456_ _2495_ _1829_ _1643_ _2342_ VGND VGND VPWR VPWR _0777_ sky130_fd_sc_hd__a22oi_1
X_4407_ _3370_ _3475_ _3490_ _3516_ VGND VGND VPWR VPWR net91 sky130_fd_sc_hd__a211o_1
XFILLER_0_1_293 VGND VGND VPWR VPWR sky130_fd_sc_hd__decap_3
X_5387_ _0699_ _0700_ _0512_ VGND VGND VPWR VPWR _0702_ sky130_fd_sc_hd__o21a_1
XTAP_TAPCELL_ROW_70_1046 VGND VPWR sky130_fd_sc_hd__tapvpwrvgnd_1
X_4338_ _3448_ VGND VGND VPWR VPWR _3449_ sky130_fd_sc_hd__buf_4
X_7126_ _2562_ _2563_ _2600_ _2601_ VGND VGND VPWR VPWR _2602_ sky130_fd_sc_hd__or4_1
X_4269_ _2157_ _0933_ _3307_ VGND VGND VPWR VPWR _3381_ sky130_fd_sc_hd__mux2_2
X_7057_ _2339_ _2519_ _2524_ VGND VGND VPWR VPWR _2526_ sky130_fd_sc_hd__or3_1
X_6008_ _1376_ _1379_ _1064_ VGND VGND VPWR VPWR _1380_ sky130_fd_sc_hd__a21o_1
XFILLER_0_96_358 VGND VGND VPWR VPWR sky130_fd_sc_hd__decap_6
XFILLER_0_84_509 VGND VGND VPWR VPWR sky130_fd_sc_hd__fill_2
XTAP_TAPCELL_ROW_25_523 VGND VPWR sky130_fd_sc_hd__tapvpwrvgnd_1
XFILLER_0_49_241 VGND VGND VPWR VPWR sky130_fd_sc_hd__decap_6
XFILLER_0_77_561 VPWR VGND VPWR VGND sky130_ef_sc_hd__decap_12
XTAP_TAPCELL_ROW_53_843 VGND VPWR sky130_fd_sc_hd__tapvpwrvgnd_1
XFILLER_0_92_531 VGND VGND VPWR VPWR sky130_fd_sc_hd__fill_1
XTAP_TAPCELL_ROW_81_1164 VGND VPWR sky130_fd_sc_hd__tapvpwrvgnd_1
XFILLER_0_107_346 VGND VGND VPWR VPWR sky130_fd_sc_hd__decap_8
XFILLER_0_107_335 VGND VGND VPWR VPWR sky130_fd_sc_hd__fill_1
XFILLER_0_107_379 VGND VGND VPWR VPWR sky130_fd_sc_hd__fill_2
XFILLER_0_17_193 VGND VGND VPWR VPWR sky130_fd_sc_hd__fill_1
XFILLER_0_32_141 VPWR VGND VPWR VGND sky130_ef_sc_hd__decap_12
XFILLER_0_103_530 VGND VGND VPWR VPWR sky130_fd_sc_hd__decap_6
XFILLER_0_60_461 VGND VGND VPWR VPWR sky130_fd_sc_hd__fill_1
XTAP_TAPCELL_ROW_92_1293 VGND VPWR sky130_fd_sc_hd__tapvpwrvgnd_1
XTAP_TAPCELL_ROW_5_292 VGND VPWR sky130_fd_sc_hd__tapvpwrvgnd_1
XFILLER_0_62_27 VGND VGND VPWR VPWR sky130_fd_sc_hd__fill_1
XFILLER_0_55_200 VPWR VGND VPWR VGND sky130_ef_sc_hd__decap_12
XFILLER_0_95_380 VPWR VGND VPWR VGND sky130_ef_sc_hd__decap_12
XFILLER_0_43_417 VPWR VGND VPWR VGND sky130_ef_sc_hd__decap_12
XFILLER_0_3_503 VGND VGND VPWR VPWR sky130_fd_sc_hd__fill_1
X_5310_ _0593_ _0597_ _0601_ _0618_ VGND VGND VPWR VPWR _0619_ sky130_fd_sc_hd__o211a_1
XFILLER_0_23_152 VPWR VGND VPWR VGND sky130_ef_sc_hd__decap_12
X_6290_ _1685_ _1687_ VGND VGND VPWR VPWR _1688_ sky130_fd_sc_hd__and2b_1
XFILLER_0_51_472 VPWR VGND VPWR VGND sky130_ef_sc_hd__decap_12
XFILLER_0_87_57 VPWR VGND VPWR VGND sky130_ef_sc_hd__decap_12
XFILLER_0_87_35 VPWR VGND VPWR VGND sky130_ef_sc_hd__decap_12
XFILLER_0_11_369 VGND VGND VPWR VPWR sky130_fd_sc_hd__fill_1
X_5241_ _0456_ _0459_ _0458_ VGND VGND VPWR VPWR _0543_ sky130_fd_sc_hd__o21ba_1
X_5172_ _0462_ _0466_ _0467_ VGND VGND VPWR VPWR _0468_ sky130_fd_sc_hd__or3_4
XFILLER_0_46_7 VGND VGND VPWR VPWR sky130_fd_sc_hd__decap_6
X_4123_ net1 VGND VGND VPWR VPWR _3097_ sky130_fd_sc_hd__clkbuf_4
X_4054_ net60 VGND VGND VPWR VPWR _2342_ sky130_fd_sc_hd__buf_4
Xinput2 A[10] VGND VGND VPWR VPWR net2 sky130_fd_sc_hd__buf_1
XTAP_TAPCELL_ROW_104_1429 VGND VPWR sky130_fd_sc_hd__tapvpwrvgnd_1
XFILLER_0_59_561 VGND VGND VPWR VPWR sky130_fd_sc_hd__decap_4
XFILLER_0_19_447 VGND VGND VPWR VPWR sky130_fd_sc_hd__fill_1
X_4956_ _0230_ _0231_ VGND VGND VPWR VPWR _0232_ sky130_fd_sc_hd__nor2_1
XTAP_TAPCELL_ROW_50_813 VGND VPWR sky130_fd_sc_hd__tapvpwrvgnd_1
XFILLER_0_52_82 VGND VGND VPWR VPWR sky130_fd_sc_hd__fill_2
X_7675_ _3160_ _3202_ VGND VGND VPWR VPWR _3203_ sky130_fd_sc_hd__xnor2_1
X_3907_ _0682_ _0715_ VGND VGND VPWR VPWR _0736_ sky130_fd_sc_hd__or2_1
XFILLER_0_19_469 VGND VGND VPWR VPWR sky130_fd_sc_hd__fill_2
X_4887_ _0138_ _0155_ _0156_ VGND VGND VPWR VPWR _0157_ sky130_fd_sc_hd__and3_1
XFILLER_0_61_225 VPWR VGND VPWR VGND sky130_ef_sc_hd__decap_12
X_6626_ _2051_ _2052_ _2053_ VGND VGND VPWR VPWR _2055_ sky130_fd_sc_hd__a21oi_1
X_6557_ _1977_ _1978_ _1979_ _0595_ VGND VGND VPWR VPWR _1980_ sky130_fd_sc_hd__o31a_1
XFILLER_0_6_385 VGND VGND VPWR VPWR sky130_fd_sc_hd__decap_3
XTAP_TAPCELL_ROW_30_581 VGND VPWR sky130_fd_sc_hd__tapvpwrvgnd_1
XFILLER_0_104_338 VGND VGND VPWR VPWR sky130_fd_sc_hd__decap_4
X_5508_ _2135_ _0593_ _2113_ VGND VGND VPWR VPWR _0834_ sky130_fd_sc_hd__o21ai_1
XFILLER_0_30_601 VGND VGND VPWR VPWR sky130_fd_sc_hd__fill_1
X_6488_ _1901_ _1902_ _1893_ VGND VGND VPWR VPWR _1904_ sky130_fd_sc_hd__a21o_1
XFILLER_0_30_645 VGND VGND VPWR VPWR sky130_fd_sc_hd__decap_6
XFILLER_0_100_533 VGND VGND VPWR VPWR sky130_fd_sc_hd__decap_4
XFILLER_0_2_580 VGND VGND VPWR VPWR sky130_fd_sc_hd__decap_8
X_5439_ _0754_ _0757_ VGND VGND VPWR VPWR _0759_ sky130_fd_sc_hd__xnor2_2
X_7109_ _2368_ _2371_ _2369_ VGND VGND VPWR VPWR _2584_ sky130_fd_sc_hd__o21ba_1
XTAP_TAPCELL_ROW_58_902 VGND VPWR sky130_fd_sc_hd__tapvpwrvgnd_1
XFILLER_0_69_314 VGND VGND VPWR VPWR sky130_fd_sc_hd__decap_8
XTAP_TAPCELL_ROW_2_262 VGND VPWR sky130_fd_sc_hd__tapvpwrvgnd_1
XPHY_EDGE_ROW_106_Left_216 VGND VGND VPWR VPWR sky130_fd_sc_hd__decap_3
XTAP_TAPCELL_ROW_66_990 VGND VPWR sky130_fd_sc_hd__tapvpwrvgnd_1
XTAP_TAPCELL_ROW_38_670 VGND VPWR sky130_fd_sc_hd__tapvpwrvgnd_1
XFILLER_0_77_391 VGND VGND VPWR VPWR sky130_fd_sc_hd__fill_1
XFILLER_0_52_225 VGND VGND VPWR VPWR sky130_fd_sc_hd__fill_2
XTAP_TAPCELL_ROW_94_1322 VGND VPWR sky130_fd_sc_hd__tapvpwrvgnd_1
XFILLER_0_80_589 VPWR VGND VPWR VGND sky130_ef_sc_hd__decap_12
XFILLER_0_21_601 VGND VGND VPWR VPWR sky130_fd_sc_hd__fill_1
XFILLER_0_33_461 VPWR VGND VPWR VGND sky130_ef_sc_hd__decap_12
XFILLER_0_20_122 VGND VGND VPWR VPWR sky130_fd_sc_hd__decap_4
XFILLER_0_103_371 VPWR VGND VPWR VGND sky130_ef_sc_hd__decap_12
XFILLER_0_88_645 VGND VGND VPWR VPWR sky130_fd_sc_hd__decap_6
XFILLER_0_87_111 VGND VGND VPWR VPWR sky130_fd_sc_hd__fill_1
XFILLER_0_75_317 VPWR VGND VPWR VGND sky130_ef_sc_hd__decap_12
X_4810_ _3838_ _3836_ _0071_ _0073_ VGND VGND VPWR VPWR _0074_ sky130_fd_sc_hd__o211ai_2
XFILLER_0_56_542 VPWR VGND VPWR VGND sky130_ef_sc_hd__decap_12
X_5790_ _3621_ net36 VGND VGND VPWR VPWR _1142_ sky130_fd_sc_hd__nand2_1
XFILLER_0_90_309 VPWR VGND VPWR VGND sky130_ef_sc_hd__decap_12
X_4741_ _3711_ _3800_ _3804_ _0001_ VGND VGND VPWR VPWR _0002_ sky130_fd_sc_hd__or4_4
XFILLER_0_7_138 VGND VGND VPWR VPWR sky130_fd_sc_hd__decap_8
X_7460_ _2965_ _2967_ VGND VGND VPWR VPWR _2968_ sky130_fd_sc_hd__or2_1
XFILLER_0_22_85 VGND VGND VPWR VPWR sky130_fd_sc_hd__decap_4
XFILLER_0_28_277 VGND VGND VPWR VPWR sky130_fd_sc_hd__fill_2
X_4672_ net28 VGND VGND VPWR VPWR _3777_ sky130_fd_sc_hd__buf_2
X_6411_ _0955_ _0097_ _1094_ _0976_ _1820_ VGND VGND VPWR VPWR _1821_ sky130_fd_sc_hd__o221ai_2
XFILLER_0_22_96 VGND VGND VPWR VPWR sky130_fd_sc_hd__fill_2
X_7391_ _2890_ _2891_ VGND VGND VPWR VPWR _2892_ sky130_fd_sc_hd__and2_1
XFILLER_0_12_601 VPWR VGND VPWR VGND sky130_ef_sc_hd__decap_12
XFILLER_0_24_472 VGND VGND VPWR VPWR sky130_fd_sc_hd__decap_4
XFILLER_0_98_89 VGND VGND VPWR VPWR sky130_fd_sc_hd__fill_1
XFILLER_0_12_645 VGND VGND VPWR VPWR sky130_fd_sc_hd__fill_1
XFILLER_0_11_100 VGND VGND VPWR VPWR sky130_fd_sc_hd__decap_4
X_6342_ _1742_ _1743_ _1734_ VGND VGND VPWR VPWR _1745_ sky130_fd_sc_hd__a21o_1
X_6273_ _1668_ _1669_ VGND VGND VPWR VPWR _1670_ sky130_fd_sc_hd__nor2_1
X_5224_ _3414_ _1490_ VGND VGND VPWR VPWR _0524_ sky130_fd_sc_hd__nand2_1
X_5155_ _3621_ _1730_ VGND VGND VPWR VPWR _0449_ sky130_fd_sc_hd__nand2_1
XFILLER_0_37_3 VGND VGND VPWR VPWR sky130_fd_sc_hd__decap_4
X_5086_ _0305_ _0373_ VGND VGND VPWR VPWR _0374_ sky130_fd_sc_hd__nor2_1
X_4106_ net25 VGND VGND VPWR VPWR _2911_ sky130_fd_sc_hd__clkbuf_4
XFILLER_0_47_93 VGND VGND VPWR VPWR sky130_fd_sc_hd__decap_8
X_4037_ _0856_ VGND VGND VPWR VPWR _2157_ sky130_fd_sc_hd__clkbuf_4
XTAP_TAPCELL_ROW_35_640 VGND VPWR sky130_fd_sc_hd__tapvpwrvgnd_1
XFILLER_0_109_408 VGND VGND VPWR VPWR sky130_fd_sc_hd__decap_8
X_5988_ _1064_ _1356_ _1357_ VGND VGND VPWR VPWR _1358_ sky130_fd_sc_hd__o21ai_1
XTAP_TAPCELL_ROW_63_960 VGND VPWR sky130_fd_sc_hd__tapvpwrvgnd_1
XFILLER_0_19_233 VGND VGND VPWR VPWR sky130_fd_sc_hd__decap_4
XFILLER_0_81_309 VGND VGND VPWR VPWR sky130_fd_sc_hd__fill_1
X_4939_ _0209_ _0212_ VGND VGND VPWR VPWR _0214_ sky130_fd_sc_hd__xnor2_1
XFILLER_0_47_553 VGND VGND VPWR VPWR sky130_fd_sc_hd__decap_6
X_7658_ _3180_ _3183_ VGND VGND VPWR VPWR _3184_ sky130_fd_sc_hd__xnor2_1
XFILLER_0_62_567 VGND VGND VPWR VPWR sky130_fd_sc_hd__decap_3
X_6609_ _1847_ _1848_ _1846_ VGND VGND VPWR VPWR _2037_ sky130_fd_sc_hd__o21bai_1
X_7589_ _2941_ _2945_ VGND VGND VPWR VPWR _3109_ sky130_fd_sc_hd__nor2_1
XFILLER_0_15_472 VGND VGND VPWR VPWR sky130_fd_sc_hd__decap_3
XFILLER_0_15_483 VPWR VGND VPWR VGND sky130_ef_sc_hd__decap_12
XFILLER_0_30_464 VGND VGND VPWR VPWR sky130_fd_sc_hd__fill_1
XTAP_TAPCELL_ROW_7_321 VGND VPWR sky130_fd_sc_hd__tapvpwrvgnd_1
XFILLER_0_30_475 VGND VGND VPWR VPWR sky130_fd_sc_hd__fill_1
XFILLER_0_89_409 VGND VGND VPWR VPWR sky130_fd_sc_hd__decap_3
XFILLER_0_97_464 VGND VGND VPWR VPWR sky130_fd_sc_hd__fill_1
XFILLER_0_69_155 VPWR VGND VPWR VGND sky130_ef_sc_hd__decap_12
XFILLER_0_84_136 VGND VGND VPWR VPWR sky130_fd_sc_hd__decap_4
XFILLER_0_72_309 VPWR VGND VPWR VGND sky130_ef_sc_hd__decap_12
XFILLER_0_65_383 VGND VGND VPWR VPWR sky130_fd_sc_hd__decap_3
XFILLER_0_53_501 VGND VGND VPWR VPWR sky130_fd_sc_hd__decap_3
XFILLER_0_53_512 VGND VGND VPWR VPWR sky130_fd_sc_hd__fill_2
XTAP_TAPCELL_ROW_13_389 VGND VPWR sky130_fd_sc_hd__tapvpwrvgnd_1
XFILLER_0_21_475 VGND VGND VPWR VPWR sky130_fd_sc_hd__decap_6
XFILLER_0_108_65 VPWR VGND VPWR VGND sky130_ef_sc_hd__decap_12
X_6960_ _2414_ _2420_ VGND VGND VPWR VPWR _2421_ sky130_fd_sc_hd__xnor2_1
XFILLER_0_88_442 VPWR VGND VPWR VGND sky130_ef_sc_hd__decap_12
X_5911_ _1160_ _1168_ VGND VGND VPWR VPWR _1274_ sky130_fd_sc_hd__or2b_1
XTAP_TAPCELL_ROW_49_798 VGND VPWR sky130_fd_sc_hd__tapvpwrvgnd_1
X_6891_ _2336_ _2337_ _2343_ VGND VGND VPWR VPWR _2345_ sky130_fd_sc_hd__a21o_1
XFILLER_0_75_125 VGND VGND VPWR VPWR sky130_fd_sc_hd__decap_6
X_5842_ _1134_ _1135_ _1198_ _1197_ VGND VGND VPWR VPWR _1199_ sky130_fd_sc_hd__or4bb_4
XFILLER_0_29_531 VGND VGND VPWR VPWR sky130_fd_sc_hd__decap_8
XFILLER_0_91_629 VPWR VGND VPWR VGND sky130_ef_sc_hd__decap_12
XFILLER_0_75_169 VPWR VGND VPWR VGND sky130_ef_sc_hd__decap_12
XTAP_TAPCELL_ROW_60_930 VGND VPWR sky130_fd_sc_hd__tapvpwrvgnd_1
XFILLER_0_29_542 VGND VGND VPWR VPWR sky130_fd_sc_hd__decap_8
XTAP_TAPCELL_ROW_32_610 VGND VPWR sky130_fd_sc_hd__tapvpwrvgnd_1
X_5773_ _3508_ _0791_ VGND VGND VPWR VPWR _1123_ sky130_fd_sc_hd__nand2_1
XFILLER_0_90_139 VGND VGND VPWR VPWR sky130_fd_sc_hd__fill_1
X_7512_ _3023_ _3024_ VGND VGND VPWR VPWR _3025_ sky130_fd_sc_hd__xnor2_1
X_4724_ _3825_ _3824_ _3826_ VGND VGND VPWR VPWR _3828_ sky130_fd_sc_hd__a21o_1
XFILLER_0_71_342 VGND VGND VPWR VPWR sky130_fd_sc_hd__fill_2
X_4655_ _3370_ _3302_ _3758_ _3759_ _3304_ VGND VGND VPWR VPWR _3760_ sky130_fd_sc_hd__a32o_1
X_7443_ _2729_ _2752_ VGND VGND VPWR VPWR _2949_ sky130_fd_sc_hd__nor2_1
XFILLER_0_71_353 VPWR VGND VPWR VGND sky130_ef_sc_hd__decap_12
XFILLER_0_44_589 VGND VGND VPWR VPWR sky130_fd_sc_hd__decap_8
X_7374_ _0344_ _2672_ _0355_ VGND VGND VPWR VPWR _2873_ sky130_fd_sc_hd__a21oi_1
Xinput60 B[7] VGND VGND VPWR VPWR net60 sky130_fd_sc_hd__clkbuf_2
X_4586_ net26 VGND VGND VPWR VPWR _3692_ sky130_fd_sc_hd__clkbuf_4
X_6325_ _1582_ _1581_ VGND VGND VPWR VPWR _1726_ sky130_fd_sc_hd__and2b_1
X_6256_ _1647_ _1649_ VGND VGND VPWR VPWR _1651_ sky130_fd_sc_hd__nand2_1
X_5207_ _3403_ VGND VGND VPWR VPWR _0506_ sky130_fd_sc_hd__buf_4
X_6187_ net36 _0018_ VGND VGND VPWR VPWR _1575_ sky130_fd_sc_hd__nand2_1
X_5138_ _0428_ _0429_ VGND VGND VPWR VPWR _0430_ sky130_fd_sc_hd__or2_1
XTAP_TAPCELL_ROW_67_1007 VGND VPWR sky130_fd_sc_hd__tapvpwrvgnd_1
X_5069_ _0254_ _0321_ _0353_ _0354_ VGND VGND VPWR VPWR _0356_ sky130_fd_sc_hd__a211oi_2
XFILLER_0_67_615 VGND VGND VPWR VPWR sky130_fd_sc_hd__fill_1
XFILLER_0_39_317 VGND VGND VPWR VPWR sky130_fd_sc_hd__decap_8
XFILLER_0_94_445 VPWR VGND VPWR VGND sky130_ef_sc_hd__decap_12
XFILLER_0_67_637 VGND VGND VPWR VPWR sky130_fd_sc_hd__decap_3
XFILLER_0_66_114 VGND VGND VPWR VPWR sky130_fd_sc_hd__decap_4
XFILLER_0_39_328 VGND VGND VPWR VPWR sky130_fd_sc_hd__decap_8
XFILLER_0_54_309 VGND VGND VPWR VPWR sky130_fd_sc_hd__decap_6
XFILLER_0_109_249 VGND VGND VPWR VPWR sky130_fd_sc_hd__decap_3
XFILLER_0_94_489 VGND VGND VPWR VPWR sky130_fd_sc_hd__fill_2
XFILLER_0_90_651 VGND VGND VPWR VPWR sky130_fd_sc_hd__fill_1
XFILLER_0_105_433 VGND VGND VPWR VPWR sky130_fd_sc_hd__decap_8
XTAP_TAPCELL_ROW_78_1136 VGND VPWR sky130_fd_sc_hd__tapvpwrvgnd_1
XTAP_TAPCELL_ROW_10_348 VGND VPWR sky130_fd_sc_hd__tapvpwrvgnd_1
XFILLER_0_50_515 VGND VGND VPWR VPWR sky130_fd_sc_hd__fill_1
XFILLER_0_22_228 VGND VGND VPWR VPWR sky130_fd_sc_hd__decap_6
XTAP_TAPCELL_ROW_89_1265 VGND VPWR sky130_fd_sc_hd__tapvpwrvgnd_1
XTAP_TAPCELL_ROW_18_448 VGND VPWR sky130_fd_sc_hd__tapvpwrvgnd_1
XTAP_TAPCELL_ROW_46_768 VGND VPWR sky130_fd_sc_hd__tapvpwrvgnd_1
XFILLER_0_85_434 VPWR VGND VPWR VGND sky130_ef_sc_hd__decap_12
XFILLER_0_57_169 VGND VGND VPWR VPWR sky130_fd_sc_hd__fill_1
XFILLER_0_57_158 VGND VGND VPWR VPWR sky130_fd_sc_hd__decap_8
XFILLER_0_72_106 VPWR VGND VPWR VGND sky130_ef_sc_hd__decap_12
XFILLER_0_38_372 VGND VGND VPWR VPWR sky130_fd_sc_hd__decap_4
XFILLER_0_81_651 VGND VGND VPWR VPWR sky130_fd_sc_hd__fill_1
XFILLER_0_72_139 VGND VGND VPWR VPWR sky130_fd_sc_hd__fill_1
XFILLER_0_26_545 VGND VGND VPWR VPWR sky130_fd_sc_hd__decap_8
XFILLER_0_80_150 VGND VGND VPWR VPWR sky130_fd_sc_hd__fill_1
XFILLER_0_26_589 VPWR VGND VPWR VGND sky130_ef_sc_hd__decap_12
X_4440_ _3424_ _3455_ _3407_ VGND VGND VPWR VPWR _3549_ sky130_fd_sc_hd__mux2_1
XFILLER_0_41_537 VPWR VGND VPWR VGND sky130_ef_sc_hd__decap_12
X_4371_ _3480_ VGND VGND VPWR VPWR _3481_ sky130_fd_sc_hd__inv_2
X_6110_ _1425_ _1426_ _1488_ _1489_ VGND VGND VPWR VPWR _1492_ sky130_fd_sc_hd__a2bb2oi_1
XFILLER_0_95_57 VGND VGND VPWR VPWR sky130_fd_sc_hd__fill_2
X_7090_ _2558_ _2559_ _2560_ VGND VGND VPWR VPWR _2563_ sky130_fd_sc_hd__o21a_1
XFILLER_0_0_166 VGND VGND VPWR VPWR sky130_fd_sc_hd__fill_2
X_6041_ _1409_ _1415_ VGND VGND VPWR VPWR _1416_ sky130_fd_sc_hd__xnor2_1
XTAP_TAPCELL_ROW_109_1490 VGND VPWR sky130_fd_sc_hd__tapvpwrvgnd_1
XFILLER_0_49_615 VGND VGND VPWR VPWR sky130_fd_sc_hd__fill_1
X_6943_ _2400_ _2401_ VGND VGND VPWR VPWR _2402_ sky130_fd_sc_hd__nor2_1
XFILLER_0_88_294 VPWR VGND VPWR VGND sky130_ef_sc_hd__decap_12
X_6874_ _2160_ _2182_ VGND VGND VPWR VPWR _2326_ sky130_fd_sc_hd__nand2_1
XFILLER_0_44_83 VGND VGND VPWR VPWR sky130_fd_sc_hd__fill_1
X_5825_ _1177_ _1178_ _1176_ VGND VGND VPWR VPWR _1180_ sky130_fd_sc_hd__o21ai_1
XFILLER_0_36_309 VPWR VGND VPWR VGND sky130_ef_sc_hd__decap_12
XFILLER_0_91_426 VPWR VGND VPWR VGND sky130_ef_sc_hd__decap_12
XFILLER_0_72_651 VGND VGND VPWR VPWR sky130_fd_sc_hd__fill_1
XFILLER_0_17_534 VPWR VGND VPWR VGND sky130_ef_sc_hd__decap_12
X_5756_ _0980_ _1067_ _1068_ VGND VGND VPWR VPWR _1104_ sky130_fd_sc_hd__nor3_2
X_5687_ _3748_ net59 net3 _0465_ VGND VGND VPWR VPWR _1029_ sky130_fd_sc_hd__and4_1
X_4707_ _3185_ _3152_ _3809_ _3810_ VGND VGND VPWR VPWR _3811_ sky130_fd_sc_hd__and4_1
X_4638_ _3340_ VGND VGND VPWR VPWR _3743_ sky130_fd_sc_hd__clkbuf_4
X_7426_ _1807_ _1621_ _0998_ VGND VGND VPWR VPWR _2930_ sky130_fd_sc_hd__and3_1
XFILLER_0_71_183 VGND VGND VPWR VPWR sky130_fd_sc_hd__fill_2
XFILLER_0_32_526 VGND VGND VPWR VPWR sky130_fd_sc_hd__decap_6
XFILLER_0_102_425 VGND VGND VPWR VPWR sky130_fd_sc_hd__fill_1
X_4569_ _3646_ _3648_ _3675_ VGND VGND VPWR VPWR net96 sky130_fd_sc_hd__o21ai_1
X_7357_ _2851_ _2850_ VGND VGND VPWR VPWR _2855_ sky130_fd_sc_hd__and2_1
X_7288_ _2091_ _1468_ _1391_ _0715_ VGND VGND VPWR VPWR _2779_ sky130_fd_sc_hd__a22o_1
XFILLER_0_12_283 VGND VGND VPWR VPWR sky130_fd_sc_hd__decap_4
X_6308_ net37 _3267_ net38 _2375_ VGND VGND VPWR VPWR _1707_ sky130_fd_sc_hd__a22o_1
XTAP_TAPCELL_ROW_73_1077 VGND VPWR sky130_fd_sc_hd__tapvpwrvgnd_1
X_6239_ net109 _1565_ _1629_ _1630_ VGND VGND VPWR VPWR _1633_ sky130_fd_sc_hd__o22a_1
XTAP_TAPCELL_ROW_15_407 VGND VPWR sky130_fd_sc_hd__tapvpwrvgnd_1
XFILLER_0_94_253 VGND VGND VPWR VPWR sky130_fd_sc_hd__decap_8
XFILLER_0_94_231 VPWR VGND VPWR VGND sky130_ef_sc_hd__decap_12
XFILLER_0_67_456 VGND VGND VPWR VPWR sky130_fd_sc_hd__decap_6
XTAP_TAPCELL_ROW_43_727 VGND VPWR sky130_fd_sc_hd__tapvpwrvgnd_1
XFILLER_0_39_169 VPWR VGND VPWR VGND sky130_ef_sc_hd__decap_12
XFILLER_0_54_106 VPWR VGND VPWR VGND sky130_ef_sc_hd__decap_12
XFILLER_0_82_459 VGND VGND VPWR VPWR sky130_fd_sc_hd__decap_8
Xclone30 B[2] VGND VGND VPWR VPWR net148 sky130_fd_sc_hd__clkbuf_16
XFILLER_0_35_353 VGND VGND VPWR VPWR sky130_fd_sc_hd__decap_6
XFILLER_0_62_172 VGND VGND VPWR VPWR sky130_fd_sc_hd__decap_3
XFILLER_0_2_409 VGND VGND VPWR VPWR sky130_fd_sc_hd__decap_8
XFILLER_0_23_537 VGND VGND VPWR VPWR sky130_fd_sc_hd__fill_1
XFILLER_0_23_548 VGND VGND VPWR VPWR sky130_fd_sc_hd__decap_4
XFILLER_0_10_209 VGND VGND VPWR VPWR sky130_fd_sc_hd__decap_4
XFILLER_0_50_389 VPWR VGND VPWR VGND sky130_ef_sc_hd__decap_12
X_3940_ net13 VGND VGND VPWR VPWR _1097_ sky130_fd_sc_hd__buf_4
XFILLER_0_105_55 VGND VGND VPWR VPWR sky130_fd_sc_hd__fill_1
XFILLER_0_85_253 VGND VGND VPWR VPWR sky130_fd_sc_hd__fill_1
X_3871_ _0072_ _0083_ _0333_ VGND VGND VPWR VPWR _0344_ sky130_fd_sc_hd__a21oi_1
XFILLER_0_58_489 VGND VGND VPWR VPWR sky130_fd_sc_hd__decap_8
XFILLER_0_14_75 VGND VGND VPWR VPWR sky130_fd_sc_hd__decap_8
XFILLER_0_18_309 VGND VGND VPWR VPWR sky130_fd_sc_hd__decap_4
X_6590_ _2007_ _2015_ VGND VGND VPWR VPWR _2016_ sky130_fd_sc_hd__xnor2_1
X_5610_ _0857_ _0943_ _0945_ VGND VGND VPWR VPWR _0946_ sky130_fd_sc_hd__and3_1
XFILLER_0_5_225 VGND VGND VPWR VPWR sky130_fd_sc_hd__decap_4
XFILLER_0_14_504 VPWR VGND VPWR VGND sky130_ef_sc_hd__decap_12
X_5541_ _3130_ net36 VGND VGND VPWR VPWR _0870_ sky130_fd_sc_hd__nand2_1
XFILLER_0_54_651 VGND VGND VPWR VPWR sky130_fd_sc_hd__fill_1
XFILLER_0_41_323 VGND VGND VPWR VPWR sky130_fd_sc_hd__decap_8
X_7211_ _2651_ _2650_ VGND VGND VPWR VPWR _2695_ sky130_fd_sc_hd__and2b_1
X_5472_ _0792_ _0793_ _0794_ VGND VGND VPWR VPWR _0795_ sky130_fd_sc_hd__or3_4
XFILLER_0_30_85 VGND VGND VPWR VPWR sky130_fd_sc_hd__decap_4
XFILLER_0_41_345 VGND VGND VPWR VPWR sky130_fd_sc_hd__decap_8
X_4423_ _3529_ _3530_ _3500_ VGND VGND VPWR VPWR _3532_ sky130_fd_sc_hd__o21a_1
X_4354_ _3385_ _3390_ _3311_ VGND VGND VPWR VPWR _3464_ sky130_fd_sc_hd__mux2_1
X_7142_ _2618_ _2619_ VGND VGND VPWR VPWR _2620_ sky130_fd_sc_hd__nor2_1
X_7073_ _1807_ _1621_ _1260_ _1173_ VGND VGND VPWR VPWR _2544_ sky130_fd_sc_hd__and4_1
X_4285_ _3383_ _3393_ _3396_ VGND VGND VPWR VPWR _3397_ sky130_fd_sc_hd__mux2_1
X_6024_ _3119_ _2889_ _1282_ net40 VGND VGND VPWR VPWR _1397_ sky130_fd_sc_hd__and4_1
X_6926_ _2366_ _2367_ _2381_ VGND VGND VPWR VPWR _2383_ sky130_fd_sc_hd__nand3_1
X_6857_ _0596_ _2307_ VGND VGND VPWR VPWR _2308_ sky130_fd_sc_hd__nor2_1
XFILLER_0_71_81 VPWR VGND VPWR VGND sky130_ef_sc_hd__decap_12
XFILLER_0_107_517 VGND VGND VPWR VPWR sky130_fd_sc_hd__decap_8
XFILLER_0_91_223 VGND VGND VPWR VPWR sky130_fd_sc_hd__fill_1
X_5808_ _1036_ _1038_ _1037_ VGND VGND VPWR VPWR _1161_ sky130_fd_sc_hd__o21ba_1
X_6788_ _2036_ _1533_ VGND VGND VPWR VPWR _2232_ sky130_fd_sc_hd__nand2_1
XFILLER_0_36_139 VGND VGND VPWR VPWR sky130_fd_sc_hd__fill_1
X_5739_ _3474_ _1085_ _3483_ _3322_ _3352_ VGND VGND VPWR VPWR _1087_ sky130_fd_sc_hd__a2111o_1
XFILLER_0_91_278 VGND VGND VPWR VPWR sky130_fd_sc_hd__fill_2
XFILLER_0_17_353 VGND VGND VPWR VPWR sky130_fd_sc_hd__fill_1
XFILLER_0_91_289 VGND VGND VPWR VPWR sky130_fd_sc_hd__fill_1
XFILLER_0_17_375 VGND VGND VPWR VPWR sky130_fd_sc_hd__decap_4
XTAP_TAPCELL_ROW_20_465 VGND VPWR sky130_fd_sc_hd__tapvpwrvgnd_1
X_7409_ _2903_ _2904_ _2909_ VGND VGND VPWR VPWR _2912_ sky130_fd_sc_hd__nor3_1
XFILLER_0_20_518 VPWR VGND VPWR VGND sky130_ef_sc_hd__decap_12
XFILLER_0_102_288 VPWR VGND VPWR VGND sky130_ef_sc_hd__decap_12
XFILLER_0_99_345 VGND VGND VPWR VPWR sky130_fd_sc_hd__decap_3
XFILLER_0_35_19 VPWR VGND VPWR VGND sky130_ef_sc_hd__decap_12
XFILLER_0_99_367 VGND VGND VPWR VPWR sky130_fd_sc_hd__fill_1
XTAP_TAPCELL_ROW_86_1224 VGND VPWR sky130_fd_sc_hd__tapvpwrvgnd_1
XTAP_TAPCELL_ROW_28_554 VGND VPWR sky130_fd_sc_hd__tapvpwrvgnd_1
XTAP_TAPCELL_ROW_56_885 VGND VPWR sky130_fd_sc_hd__tapvpwrvgnd_1
XFILLER_0_95_573 VGND VGND VPWR VPWR sky130_fd_sc_hd__decap_4
XFILLER_0_82_245 VGND VGND VPWR VPWR sky130_fd_sc_hd__decap_3
XFILLER_0_55_437 VGND VGND VPWR VPWR sky130_fd_sc_hd__decap_8
XFILLER_0_36_651 VGND VGND VPWR VPWR sky130_fd_sc_hd__fill_1
XFILLER_0_106_550 VGND VGND VPWR VPWR sky130_fd_sc_hd__fill_1
XFILLER_0_23_323 VPWR VGND VPWR VGND sky130_ef_sc_hd__decap_12
XTAP_TAPCELL_ROW_97_1353 VGND VPWR sky130_fd_sc_hd__tapvpwrvgnd_1
XFILLER_0_11_529 VGND VGND VPWR VPWR sky130_fd_sc_hd__decap_8
X_4070_ _2506_ VGND VGND VPWR VPWR _2517_ sky130_fd_sc_hd__buf_4
XFILLER_0_78_518 VPWR VGND VPWR VGND sky130_ef_sc_hd__decap_12
XTAP_TAPCELL_ROW_106_1460 VGND VPWR sky130_fd_sc_hd__tapvpwrvgnd_1
X_4972_ _0245_ _0247_ _0248_ VGND VGND VPWR VPWR _0250_ sky130_fd_sc_hd__a21o_1
X_6711_ _0148_ _0192_ _1089_ VGND VGND VPWR VPWR _2149_ sky130_fd_sc_hd__mux2_1
X_7691_ _0730_ _1985_ _3220_ VGND VGND VPWR VPWR _3221_ sky130_fd_sc_hd__a21oi_2
XFILLER_0_86_584 VGND VGND VPWR VPWR sky130_fd_sc_hd__decap_4
X_3923_ _0889_ _0900_ VGND VGND VPWR VPWR _0911_ sky130_fd_sc_hd__nand2_2
XFILLER_0_58_253 VPWR VGND VPWR VGND sky130_ef_sc_hd__decap_12
XFILLER_0_19_629 VPWR VGND VPWR VGND sky130_ef_sc_hd__decap_12
X_3854_ net48 VGND VGND VPWR VPWR _0159_ sky130_fd_sc_hd__buf_2
XFILLER_0_6_501 VGND VGND VPWR VPWR sky130_fd_sc_hd__decap_8
X_6642_ _3086_ _0137_ _1097_ _2627_ VGND VGND VPWR VPWR _2073_ sky130_fd_sc_hd__a22oi_2
XFILLER_0_6_545 VPWR VGND VPWR VGND sky130_ef_sc_hd__decap_12
XFILLER_0_27_640 VGND VGND VPWR VPWR sky130_fd_sc_hd__decap_8
X_6573_ _1984_ _1989_ _1992_ _1997_ VGND VGND VPWR VPWR _1998_ sky130_fd_sc_hd__or4b_1
XFILLER_0_26_161 VGND VGND VPWR VPWR sky130_fd_sc_hd__decap_8
X_5524_ _3353_ _0844_ _0845_ _0014_ _0851_ VGND VGND VPWR VPWR _0852_ sky130_fd_sc_hd__a221o_1
XFILLER_0_14_334 VPWR VGND VPWR VGND sky130_ef_sc_hd__decap_12
XFILLER_0_6_589 VPWR VGND VPWR VGND sky130_ef_sc_hd__decap_12
XFILLER_0_26_194 VGND VGND VPWR VPWR sky130_fd_sc_hd__fill_2
XFILLER_0_41_142 VPWR VGND VPWR VGND sky130_ef_sc_hd__decap_12
XFILLER_0_42_643 VGND VGND VPWR VPWR sky130_fd_sc_hd__fill_1
X_5455_ _0658_ _0661_ VGND VGND VPWR VPWR _0776_ sky130_fd_sc_hd__nand2_1
XFILLER_0_41_164 VGND VGND VPWR VPWR sky130_fd_sc_hd__decap_4
X_4406_ _3492_ _3499_ _3500_ _3515_ VGND VGND VPWR VPWR _3516_ sky130_fd_sc_hd__a31o_1
XFILLER_0_1_261 VGND VGND VPWR VPWR sky130_fd_sc_hd__fill_2
XFILLER_0_41_186 VPWR VGND VPWR VGND sky130_ef_sc_hd__decap_12
X_5386_ _0512_ _0700_ _0699_ VGND VGND VPWR VPWR _0701_ sky130_fd_sc_hd__nor3_4
X_7125_ _2598_ _2599_ _2423_ _2425_ VGND VGND VPWR VPWR _2601_ sky130_fd_sc_hd__o211a_1
XTAP_TAPCELL_ROW_70_1047 VGND VPWR sky130_fd_sc_hd__tapvpwrvgnd_1
XTAP_TAPCELL_ROW_70_1036 VGND VPWR sky130_fd_sc_hd__tapvpwrvgnd_1
X_4337_ net32 VGND VGND VPWR VPWR _3448_ sky130_fd_sc_hd__clkbuf_4
XFILLER_0_5_51 VGND VGND VPWR VPWR sky130_fd_sc_hd__decap_4
X_4268_ _1009_ _3379_ _3307_ VGND VGND VPWR VPWR _3380_ sky130_fd_sc_hd__mux2_2
X_7056_ _2339_ _2519_ _2524_ VGND VGND VPWR VPWR _2525_ sky130_fd_sc_hd__o21ai_1
X_6007_ _0824_ _1082_ _1374_ _1378_ VGND VGND VPWR VPWR _1379_ sky130_fd_sc_hd__o31a_1
X_4199_ _3310_ VGND VGND VPWR VPWR _3311_ sky130_fd_sc_hd__clkbuf_4
XFILLER_0_96_304 VGND VGND VPWR VPWR sky130_fd_sc_hd__decap_4
XFILLER_0_69_529 VGND VGND VPWR VPWR sky130_fd_sc_hd__fill_1
XTAP_TAPCELL_ROW_25_524 VGND VPWR sky130_fd_sc_hd__tapvpwrvgnd_1
XFILLER_0_49_231 VGND VGND VPWR VPWR sky130_fd_sc_hd__decap_4
XFILLER_0_77_573 VPWR VGND VPWR VGND sky130_ef_sc_hd__decap_12
X_6909_ _2228_ _2236_ VGND VGND VPWR VPWR _2365_ sky130_fd_sc_hd__and2b_1
XTAP_TAPCELL_ROW_53_844 VGND VPWR sky130_fd_sc_hd__tapvpwrvgnd_1
XFILLER_0_107_303 VGND VGND VPWR VPWR sky130_fd_sc_hd__decap_6
XTAP_TAPCELL_ROW_81_1165 VGND VPWR sky130_fd_sc_hd__tapvpwrvgnd_1
XFILLER_0_37_437 VGND VGND VPWR VPWR sky130_fd_sc_hd__decap_8
XFILLER_0_92_587 VGND VGND VPWR VPWR sky130_fd_sc_hd__fill_1
XFILLER_0_18_651 VGND VGND VPWR VPWR sky130_fd_sc_hd__fill_1
XFILLER_0_24_109 VGND VGND VPWR VPWR sky130_fd_sc_hd__decap_6
XFILLER_0_52_418 VGND VGND VPWR VPWR sky130_fd_sc_hd__fill_2
XFILLER_0_60_473 VGND VGND VPWR VPWR sky130_fd_sc_hd__decap_3
XFILLER_0_32_153 VPWR VGND VPWR VGND sky130_ef_sc_hd__decap_12
XFILLER_0_32_197 VGND VGND VPWR VPWR sky130_fd_sc_hd__fill_2
XTAP_TAPCELL_ROW_92_1294 VGND VPWR sky130_fd_sc_hd__tapvpwrvgnd_1
XFILLER_0_46_29 VGND VGND VPWR VPWR sky130_fd_sc_hd__fill_2
XTAP_TAPCELL_ROW_5_293 VGND VPWR sky130_fd_sc_hd__tapvpwrvgnd_1
XFILLER_0_87_359 VGND VGND VPWR VPWR sky130_fd_sc_hd__decap_8
XFILLER_0_68_551 VGND VGND VPWR VPWR sky130_fd_sc_hd__decap_4
XFILLER_0_83_576 VPWR VGND VPWR VGND sky130_ef_sc_hd__decap_12
XFILLER_0_55_256 VGND VGND VPWR VPWR sky130_fd_sc_hd__decap_6
XFILLER_0_36_470 VGND VGND VPWR VPWR sky130_fd_sc_hd__decap_6
XFILLER_0_43_429 VPWR VGND VPWR VGND sky130_ef_sc_hd__decap_12
XFILLER_0_11_76 VPWR VGND VPWR VGND sky130_ef_sc_hd__decap_12
XFILLER_0_11_65 VGND VGND VPWR VPWR sky130_fd_sc_hd__fill_2
XFILLER_0_23_164 VGND VGND VPWR VPWR sky130_fd_sc_hd__decap_4
XFILLER_0_51_484 VGND VGND VPWR VPWR sky130_fd_sc_hd__decap_4
XFILLER_0_87_47 VGND VGND VPWR VPWR sky130_fd_sc_hd__decap_8
X_5240_ _2671_ _1741_ _0450_ _0541_ VGND VGND VPWR VPWR _0542_ sky130_fd_sc_hd__a31o_1
XFILLER_0_87_69 VPWR VGND VPWR VGND sky130_ef_sc_hd__decap_12
X_5171_ _3520_ _0465_ _1829_ _0242_ VGND VGND VPWR VPWR _0467_ sky130_fd_sc_hd__a22oi_2
XPHY_EDGE_ROW_18_Right_18 VGND VGND VPWR VPWR sky130_fd_sc_hd__decap_3
X_4122_ net152 VGND VGND VPWR VPWR _3086_ sky130_fd_sc_hd__buf_12
X_4053_ _0933_ _2310_ _2321_ VGND VGND VPWR VPWR _2331_ sky130_fd_sc_hd__a21o_1
Xinput3 A[12] VGND VGND VPWR VPWR net3 sky130_fd_sc_hd__clkbuf_2
XPHY_EDGE_ROW_27_Right_27 VGND VGND VPWR VPWR sky130_fd_sc_hd__decap_3
X_4955_ _0228_ _0229_ _0223_ VGND VGND VPWR VPWR _0231_ sky130_fd_sc_hd__a21oi_1
XFILLER_0_52_50 VPWR VGND VPWR VGND sky130_ef_sc_hd__decap_12
X_3906_ _0682_ _0715_ VGND VGND VPWR VPWR _0726_ sky130_fd_sc_hd__nand2_1
XFILLER_0_74_521 VGND VGND VPWR VPWR sky130_fd_sc_hd__decap_4
XFILLER_0_46_223 VGND VGND VPWR VPWR sky130_fd_sc_hd__decap_8
XTAP_TAPCELL_ROW_50_814 VGND VPWR sky130_fd_sc_hd__tapvpwrvgnd_1
X_7674_ _3164_ _3201_ VGND VGND VPWR VPWR _3202_ sky130_fd_sc_hd__xnor2_1
X_4886_ _0152_ _0153_ _0154_ VGND VGND VPWR VPWR _0156_ sky130_fd_sc_hd__a21o_1
XFILLER_0_46_267 VGND VGND VPWR VPWR sky130_fd_sc_hd__decap_3
XFILLER_0_74_587 VGND VGND VPWR VPWR sky130_fd_sc_hd__fill_1
XFILLER_0_61_215 VGND VGND VPWR VPWR sky130_fd_sc_hd__decap_8
XFILLER_0_27_470 VPWR VGND VPWR VGND sky130_ef_sc_hd__decap_12
X_6625_ _2051_ _2052_ _2053_ VGND VGND VPWR VPWR _2054_ sky130_fd_sc_hd__and3_1
XFILLER_0_104_306 VGND VGND VPWR VPWR sky130_fd_sc_hd__fill_2
X_6556_ _0911_ _0976_ _1666_ VGND VGND VPWR VPWR _1979_ sky130_fd_sc_hd__and3_1
XFILLER_0_61_237 VPWR VGND VPWR VGND sky130_ef_sc_hd__decap_12
XTAP_TAPCELL_ROW_30_582 VGND VPWR sky130_fd_sc_hd__tapvpwrvgnd_1
X_5507_ _0826_ _0831_ _0832_ _3647_ VGND VGND VPWR VPWR _0833_ sky130_fd_sc_hd__a211o_1
X_6487_ _1893_ _1901_ _1902_ VGND VGND VPWR VPWR _1903_ sky130_fd_sc_hd__nand3_1
X_5438_ _0755_ _0756_ VGND VGND VPWR VPWR _0757_ sky130_fd_sc_hd__and2b_1
XPHY_EDGE_ROW_36_Right_36 VGND VGND VPWR VPWR sky130_fd_sc_hd__decap_3
X_5369_ _0673_ _0680_ _0681_ VGND VGND VPWR VPWR _0683_ sky130_fd_sc_hd__nand3_2
X_7108_ _1850_ _0813_ _2417_ _2415_ VGND VGND VPWR VPWR _2582_ sky130_fd_sc_hd__a31o_1
X_7039_ _2504_ _2505_ VGND VGND VPWR VPWR _2507_ sky130_fd_sc_hd__xnor2_1
XTAP_TAPCELL_ROW_58_903 VGND VPWR sky130_fd_sc_hd__tapvpwrvgnd_1
XTAP_TAPCELL_ROW_2_263 VGND VPWR sky130_fd_sc_hd__tapvpwrvgnd_1
XFILLER_0_69_337 VGND VGND VPWR VPWR sky130_fd_sc_hd__decap_6
XTAP_TAPCELL_ROW_66_991 VGND VPWR sky130_fd_sc_hd__tapvpwrvgnd_1
XTAP_TAPCELL_ROW_38_671 VGND VPWR sky130_fd_sc_hd__tapvpwrvgnd_1
XPHY_EDGE_ROW_45_Right_45 VGND VGND VPWR VPWR sky130_fd_sc_hd__decap_3
XFILLER_0_108_601 VPWR VGND VPWR VGND sky130_ef_sc_hd__decap_12
XFILLER_0_107_111 VGND VGND VPWR VPWR sky130_fd_sc_hd__fill_1
XFILLER_0_92_340 VPWR VGND VPWR VGND sky130_ef_sc_hd__decap_12
XFILLER_0_65_554 VGND VGND VPWR VPWR sky130_fd_sc_hd__decap_6
XFILLER_0_108_645 VGND VGND VPWR VPWR sky130_fd_sc_hd__decap_6
XFILLER_0_107_133 VPWR VGND VPWR VGND sky130_ef_sc_hd__decap_12
XFILLER_0_33_440 VGND VGND VPWR VPWR sky130_fd_sc_hd__decap_8
XFILLER_0_52_259 VGND VGND VPWR VPWR sky130_fd_sc_hd__decap_4
XFILLER_0_107_199 VPWR VGND VPWR VGND sky130_ef_sc_hd__decap_12
XTAP_TAPCELL_ROW_94_1323 VGND VPWR sky130_fd_sc_hd__tapvpwrvgnd_1
XTAP_TAPCELL_ROW_94_1312 VGND VPWR sky130_fd_sc_hd__tapvpwrvgnd_1
XFILLER_0_33_473 VGND VGND VPWR VPWR sky130_fd_sc_hd__decap_3
XFILLER_0_0_518 VGND VGND VPWR VPWR sky130_fd_sc_hd__decap_3
XFILLER_0_20_101 VPWR VGND VPWR VGND sky130_ef_sc_hd__decap_12
XPHY_EDGE_ROW_54_Right_54 VGND VGND VPWR VPWR sky130_fd_sc_hd__decap_3
XFILLER_0_103_383 VGND VGND VPWR VPWR sky130_fd_sc_hd__decap_8
XFILLER_0_20_189 VGND VGND VPWR VPWR sky130_fd_sc_hd__decap_6
XFILLER_0_73_27 VGND VGND VPWR VPWR sky130_fd_sc_hd__fill_2
XFILLER_0_73_38 VGND VGND VPWR VPWR sky130_fd_sc_hd__decap_8
XPHY_EDGE_ROW_63_Right_63 VGND VGND VPWR VPWR sky130_fd_sc_hd__decap_3
XFILLER_0_87_156 VGND VGND VPWR VPWR sky130_fd_sc_hd__fill_1
XFILLER_0_75_329 VGND VGND VPWR VPWR sky130_fd_sc_hd__decap_6
X_4740_ _3842_ _0000_ VGND VGND VPWR VPWR _0001_ sky130_fd_sc_hd__xor2_1
XFILLER_0_56_554 VPWR VGND VPWR VGND sky130_ef_sc_hd__decap_12
XFILLER_0_83_362 VGND VGND VPWR VPWR sky130_fd_sc_hd__fill_1
XFILLER_0_71_502 VGND VGND VPWR VPWR sky130_fd_sc_hd__fill_2
XFILLER_0_56_587 VGND VGND VPWR VPWR sky130_fd_sc_hd__fill_1
XFILLER_0_43_204 VGND VGND VPWR VPWR sky130_fd_sc_hd__decap_8
X_4671_ _3771_ _3775_ VGND VGND VPWR VPWR _3776_ sky130_fd_sc_hd__xnor2_2
X_7390_ _2887_ _2888_ VGND VGND VPWR VPWR _2891_ sky130_fd_sc_hd__or2_1
X_6410_ _0933_ _1360_ _0378_ _0966_ VGND VGND VPWR VPWR _1820_ sky130_fd_sc_hd__o22a_1
XFILLER_0_71_557 VGND VGND VPWR VPWR sky130_fd_sc_hd__decap_3
XFILLER_0_71_546 VGND VGND VPWR VPWR sky130_fd_sc_hd__decap_8
XPHY_EDGE_ROW_72_Right_72 VGND VGND VPWR VPWR sky130_fd_sc_hd__decap_3
XFILLER_0_12_613 VPWR VGND VPWR VGND sky130_ef_sc_hd__decap_12
X_6341_ _1734_ _1742_ _1743_ VGND VGND VPWR VPWR _1744_ sky130_fd_sc_hd__nand3_2
XFILLER_0_51_281 VGND VGND VPWR VPWR sky130_fd_sc_hd__decap_4
X_6272_ _0911_ _1667_ _1214_ VGND VGND VPWR VPWR _1669_ sky130_fd_sc_hd__o21ai_1
XFILLER_0_11_156 VGND VGND VPWR VPWR sky130_fd_sc_hd__decap_4
XFILLER_0_11_145 VGND VGND VPWR VPWR sky130_fd_sc_hd__fill_1
X_5223_ _0521_ _0522_ VGND VGND VPWR VPWR _0523_ sky130_fd_sc_hd__nor2_1
X_5154_ _0334_ _0336_ _0335_ VGND VGND VPWR VPWR _0448_ sky130_fd_sc_hd__o21ba_1
X_4105_ _2889_ VGND VGND VPWR VPWR _2900_ sky130_fd_sc_hd__inv_2
XPHY_EDGE_ROW_81_Right_81 VGND VGND VPWR VPWR sky130_fd_sc_hd__decap_3
X_5085_ _0371_ _0372_ VGND VGND VPWR VPWR _0373_ sky130_fd_sc_hd__nand2_1
XFILLER_0_79_624 VGND VGND VPWR VPWR sky130_fd_sc_hd__decap_8
XFILLER_0_79_613 VGND VGND VPWR VPWR sky130_fd_sc_hd__decap_3
X_4036_ _1435_ _2124_ _2135_ _2113_ VGND VGND VPWR VPWR _2146_ sky130_fd_sc_hd__a22oi_2
XFILLER_0_2_41 VPWR VGND VPWR VGND sky130_ef_sc_hd__decap_12
XFILLER_0_78_112 VGND VGND VPWR VPWR sky130_fd_sc_hd__decap_3
XFILLER_0_2_85 VPWR VGND VPWR VGND sky130_ef_sc_hd__decap_12
XFILLER_0_78_178 VPWR VGND VPWR VGND sky130_ef_sc_hd__decap_12
XFILLER_0_78_156 VPWR VGND VPWR VGND sky130_ef_sc_hd__decap_12
XFILLER_0_66_307 VGND VGND VPWR VPWR sky130_fd_sc_hd__fill_1
XTAP_TAPCELL_ROW_35_641 VGND VPWR sky130_fd_sc_hd__tapvpwrvgnd_1
X_5987_ _1064_ _1356_ _0596_ VGND VGND VPWR VPWR _1357_ sky130_fd_sc_hd__a21oi_1
XTAP_TAPCELL_ROW_63_961 VGND VPWR sky130_fd_sc_hd__tapvpwrvgnd_1
XFILLER_0_19_223 VGND VGND VPWR VPWR sky130_fd_sc_hd__fill_1
XFILLER_0_93_148 VGND VGND VPWR VPWR sky130_fd_sc_hd__decap_8
X_4938_ _0210_ _0211_ VGND VGND VPWR VPWR _0212_ sky130_fd_sc_hd__nor2_1
X_7657_ _3181_ _3182_ VGND VGND VPWR VPWR _3183_ sky130_fd_sc_hd__xor2_1
XFILLER_0_62_502 VGND VGND VPWR VPWR sky130_fd_sc_hd__decap_8
XFILLER_0_19_289 VGND VGND VPWR VPWR sky130_fd_sc_hd__fill_2
X_4869_ _0129_ _0136_ VGND VGND VPWR VPWR _0138_ sky130_fd_sc_hd__xnor2_1
XFILLER_0_104_103 VGND VGND VPWR VPWR sky130_fd_sc_hd__fill_1
XPHY_EDGE_ROW_90_Right_90 VGND VGND VPWR VPWR sky130_fd_sc_hd__decap_3
XFILLER_0_34_259 VGND VGND VPWR VPWR sky130_fd_sc_hd__fill_1
X_6608_ _2031_ _2032_ _2033_ VGND VGND VPWR VPWR _2035_ sky130_fd_sc_hd__o21ai_1
X_7588_ _3095_ _3106_ VGND VGND VPWR VPWR _3107_ sky130_fd_sc_hd__xnor2_1
XFILLER_0_104_114 VGND VGND VPWR VPWR sky130_fd_sc_hd__fill_1
XFILLER_0_15_495 VGND VGND VPWR VPWR sky130_fd_sc_hd__decap_4
XFILLER_0_30_421 VPWR VGND VPWR VGND sky130_ef_sc_hd__decap_12
X_6539_ _1800_ _1802_ _1958_ _1959_ VGND VGND VPWR VPWR _1961_ sky130_fd_sc_hd__a211oi_2
XFILLER_0_100_320 VPWR VGND VPWR VGND sky130_ef_sc_hd__decap_12
XTAP_TAPCELL_ROW_7_322 VGND VPWR sky130_fd_sc_hd__tapvpwrvgnd_1
XFILLER_0_97_421 VPWR VGND VPWR VGND sky130_ef_sc_hd__decap_12
XFILLER_0_69_178 VPWR VGND VPWR VGND sky130_ef_sc_hd__decap_12
XFILLER_0_69_167 VGND VGND VPWR VPWR sky130_fd_sc_hd__fill_1
XFILLER_0_38_510 VGND VGND VPWR VPWR sky130_fd_sc_hd__decap_3
XFILLER_0_53_524 VGND VGND VPWR VPWR sky130_fd_sc_hd__decap_8
XFILLER_0_108_475 VGND VGND VPWR VPWR sky130_fd_sc_hd__fill_1
XFILLER_0_33_281 VPWR VGND VPWR VGND sky130_ef_sc_hd__decap_12
XFILLER_0_40_229 VGND VGND VPWR VPWR sky130_fd_sc_hd__decap_6
XFILLER_0_68_27 VGND VGND VPWR VPWR sky130_fd_sc_hd__fill_1
XFILLER_0_0_315 VGND VGND VPWR VPWR sky130_fd_sc_hd__fill_1
XFILLER_0_0_359 VGND VGND VPWR VPWR sky130_fd_sc_hd__fill_1
XFILLER_0_84_37 VGND VGND VPWR VPWR sky130_fd_sc_hd__fill_2
XFILLER_0_17_31 VGND VGND VPWR VPWR sky130_fd_sc_hd__fill_1
XFILLER_0_108_77 VGND VGND VPWR VPWR sky130_fd_sc_hd__decap_6
XFILLER_0_88_421 VPWR VGND VPWR VGND sky130_ef_sc_hd__decap_12
X_5910_ _1161_ _1167_ VGND VGND VPWR VPWR _1273_ sky130_fd_sc_hd__or2b_1
XTAP_TAPCELL_ROW_49_799 VGND VPWR sky130_fd_sc_hd__tapvpwrvgnd_1
XFILLER_0_88_454 VPWR VGND VPWR VGND sky130_ef_sc_hd__decap_12
X_6890_ _2336_ _2337_ _2343_ VGND VGND VPWR VPWR _2344_ sky130_fd_sc_hd__nand3_2
XFILLER_0_48_307 VGND VGND VPWR VPWR sky130_fd_sc_hd__fill_1
X_5841_ _1194_ _1196_ _1136_ net154 VGND VGND VPWR VPWR _1198_ sky130_fd_sc_hd__a211o_1
XTAP_TAPCELL_ROW_60_931 VGND VPWR sky130_fd_sc_hd__tapvpwrvgnd_1
XFILLER_0_8_437 VGND VGND VPWR VPWR sky130_fd_sc_hd__decap_3
XTAP_TAPCELL_ROW_32_600 VGND VPWR sky130_fd_sc_hd__tapvpwrvgnd_1
X_5772_ _1120_ _1121_ VGND VGND VPWR VPWR _1122_ sky130_fd_sc_hd__nor2_1
X_7511_ _3324_ _0116_ VGND VGND VPWR VPWR _3024_ sky130_fd_sc_hd__nand2_1
XFILLER_0_29_587 VPWR VGND VPWR VGND sky130_ef_sc_hd__decap_12
X_4723_ _3824_ _3825_ _3826_ VGND VGND VPWR VPWR _3827_ sky130_fd_sc_hd__nand3_1
X_7442_ _2920_ _2947_ VGND VGND VPWR VPWR _2948_ sky130_fd_sc_hd__xnor2_1
XFILLER_0_44_557 VPWR VGND VPWR VGND sky130_ef_sc_hd__decap_12
X_4654_ _3538_ _3548_ _3549_ _3551_ _3343_ _3743_ VGND VGND VPWR VPWR _3759_ sky130_fd_sc_hd__mux4_1
XFILLER_0_71_365 VPWR VGND VPWR VGND sky130_ef_sc_hd__decap_12
XFILLER_0_4_643 VGND VGND VPWR VPWR sky130_fd_sc_hd__fill_1
Xinput50 B[27] VGND VGND VPWR VPWR net50 sky130_fd_sc_hd__clkbuf_2
X_7373_ _0717_ _2865_ _2871_ VGND VGND VPWR VPWR _2872_ sky130_fd_sc_hd__and3_1
XFILLER_0_12_421 VPWR VGND VPWR VGND sky130_ef_sc_hd__decap_12
Xinput61 B[8] VGND VGND VPWR VPWR net61 sky130_fd_sc_hd__buf_1
X_4585_ _3130_ _2867_ _2977_ _2561_ VGND VGND VPWR VPWR _3691_ sky130_fd_sc_hd__nand4_1
XFILLER_0_101_117 VGND VGND VPWR VPWR sky130_fd_sc_hd__fill_1
X_6324_ _1587_ _1589_ _1625_ _1626_ VGND VGND VPWR VPWR _1725_ sky130_fd_sc_hd__nor4_2
X_6255_ _1647_ _1649_ VGND VGND VPWR VPWR _1650_ sky130_fd_sc_hd__or2_1
X_5206_ _3259_ _0504_ VGND VGND VPWR VPWR _0505_ sky130_fd_sc_hd__xnor2_1
X_6186_ _1572_ _1573_ VGND VGND VPWR VPWR _1574_ sky130_fd_sc_hd__nor2_1
X_5137_ _3097_ _3010_ _1413_ _3254_ VGND VGND VPWR VPWR _0429_ sky130_fd_sc_hd__and4_1
X_5068_ _0351_ _0352_ _0331_ VGND VGND VPWR VPWR _0354_ sky130_fd_sc_hd__a21oi_1
X_4019_ _1949_ VGND VGND VPWR VPWR _1960_ sky130_fd_sc_hd__buf_2
XTAP_TAPCELL_ROW_67_1008 VGND VPWR sky130_fd_sc_hd__tapvpwrvgnd_1
XFILLER_0_79_498 VGND VGND VPWR VPWR sky130_fd_sc_hd__decap_6
XPHY_EDGE_ROW_0_Right_0 VGND VGND VPWR VPWR sky130_fd_sc_hd__decap_3
XFILLER_0_94_457 VGND VGND VPWR VPWR sky130_fd_sc_hd__decap_6
X_7709_ _1214_ _3060_ _3061_ VGND VGND VPWR VPWR _3239_ sky130_fd_sc_hd__nand3_1
XFILLER_0_81_118 VPWR VGND VPWR VGND sky130_ef_sc_hd__decap_12
XFILLER_0_105_401 VGND VGND VPWR VPWR sky130_fd_sc_hd__fill_2
XFILLER_0_90_641 VGND VGND VPWR VPWR sky130_fd_sc_hd__decap_3
XFILLER_0_62_321 VPWR VGND VPWR VGND sky130_ef_sc_hd__decap_12
XFILLER_0_62_365 VGND VGND VPWR VPWR sky130_fd_sc_hd__fill_2
XTAP_TAPCELL_ROW_10_349 VGND VPWR sky130_fd_sc_hd__tapvpwrvgnd_1
XTAP_TAPCELL_ROW_78_1137 VGND VPWR sky130_fd_sc_hd__tapvpwrvgnd_1
XFILLER_0_100_194 VGND VGND VPWR VPWR sky130_fd_sc_hd__fill_2
XTAP_TAPCELL_ROW_89_1255 VGND VPWR sky130_fd_sc_hd__tapvpwrvgnd_1
XFILLER_0_97_251 VGND VGND VPWR VPWR sky130_fd_sc_hd__fill_1
XTAP_TAPCELL_ROW_18_438 VGND VPWR sky130_fd_sc_hd__tapvpwrvgnd_1
XTAP_TAPCELL_ROW_18_449 VGND VPWR sky130_fd_sc_hd__tapvpwrvgnd_1
XTAP_TAPCELL_ROW_46_769 VGND VPWR sky130_fd_sc_hd__tapvpwrvgnd_1
XFILLER_0_85_446 VGND VGND VPWR VPWR sky130_fd_sc_hd__fill_2
XFILLER_0_72_118 VGND VGND VPWR VPWR sky130_fd_sc_hd__decap_4
XFILLER_0_5_429 VGND VGND VPWR VPWR sky130_fd_sc_hd__fill_2
XFILLER_0_38_384 VPWR VGND VPWR VGND sky130_ef_sc_hd__decap_12
XFILLER_0_108_283 VGND VGND VPWR VPWR sky130_fd_sc_hd__decap_4
XFILLER_0_41_505 VGND VGND VPWR VPWR sky130_fd_sc_hd__fill_1
XFILLER_0_53_343 VGND VGND VPWR VPWR sky130_fd_sc_hd__decap_3
XFILLER_0_41_549 VGND VGND VPWR VPWR sky130_fd_sc_hd__decap_8
X_4370_ _3335_ _3333_ _3307_ VGND VGND VPWR VPWR _3480_ sky130_fd_sc_hd__mux2_1
X_6040_ _1412_ _1414_ VGND VGND VPWR VPWR _1415_ sky130_fd_sc_hd__xnor2_1
XTAP_TAPCELL_ROW_109_1491 VGND VPWR sky130_fd_sc_hd__tapvpwrvgnd_1
XFILLER_0_88_251 VGND VGND VPWR VPWR sky130_fd_sc_hd__fill_1
X_6942_ _3269_ _1293_ _1206_ _1665_ VGND VGND VPWR VPWR _2401_ sky130_fd_sc_hd__a22oi_1
X_6873_ _2181_ _2161_ VGND VGND VPWR VPWR _2325_ sky130_fd_sc_hd__or2b_1
XFILLER_0_48_104 VGND VGND VPWR VPWR sky130_fd_sc_hd__decap_8
XFILLER_0_49_649 VGND VGND VPWR VPWR sky130_fd_sc_hd__decap_3
XFILLER_0_8_212 VGND VGND VPWR VPWR sky130_fd_sc_hd__decap_4
X_5824_ _1176_ _1178_ _1177_ VGND VGND VPWR VPWR _1179_ sky130_fd_sc_hd__or3_4
XFILLER_0_48_148 VGND VGND VPWR VPWR sky130_fd_sc_hd__fill_2
XFILLER_0_63_107 VGND VGND VPWR VPWR sky130_fd_sc_hd__decap_4
XFILLER_0_8_234 VPWR VGND VPWR VGND sky130_ef_sc_hd__decap_12
XFILLER_0_91_449 VPWR VGND VPWR VGND sky130_ef_sc_hd__decap_12
XFILLER_0_91_438 VGND VGND VPWR VPWR sky130_fd_sc_hd__decap_8
XFILLER_0_56_181 VGND VGND VPWR VPWR sky130_fd_sc_hd__fill_1
XFILLER_0_17_524 VGND VGND VPWR VPWR sky130_fd_sc_hd__decap_4
X_5755_ _0941_ _1071_ _1072_ VGND VGND VPWR VPWR _1103_ sky130_fd_sc_hd__or3_4
X_5686_ _0240_ _1719_ VGND VGND VPWR VPWR _1028_ sky130_fd_sc_hd__nand2_1
X_4706_ _2495_ VGND VGND VPWR VPWR _3810_ sky130_fd_sc_hd__buf_4
X_4637_ _3396_ VGND VGND VPWR VPWR _3742_ sky130_fd_sc_hd__clkbuf_4
X_7425_ _2927_ _2928_ VGND VGND VPWR VPWR _2929_ sky130_fd_sc_hd__xor2_2
XFILLER_0_44_376 VGND VGND VPWR VPWR sky130_fd_sc_hd__fill_1
XFILLER_0_44_398 VGND VGND VPWR VPWR sky130_fd_sc_hd__fill_1
XFILLER_0_8_73 VGND VGND VPWR VPWR sky130_fd_sc_hd__decap_8
XFILLER_0_4_473 VGND VGND VPWR VPWR sky130_fd_sc_hd__decap_3
XFILLER_0_102_448 VPWR VGND VPWR VGND sky130_ef_sc_hd__decap_12
X_4568_ _3649_ _3652_ _3657_ _3674_ VGND VGND VPWR VPWR _3675_ sky130_fd_sc_hd__o211a_1
XFILLER_0_69_92 VPWR VGND VPWR VGND sky130_ef_sc_hd__decap_12
X_7356_ _2497_ _2494_ _2853_ VGND VGND VPWR VPWR _2854_ sky130_fd_sc_hd__a21oi_4
X_4499_ _3228_ _3604_ _2780_ VGND VGND VPWR VPWR _3607_ sky130_fd_sc_hd__a21boi_1
X_7287_ _3260_ _2538_ _2540_ VGND VGND VPWR VPWR _2778_ sky130_fd_sc_hd__o21ba_1
X_6307_ _2441_ net39 VGND VGND VPWR VPWR _1706_ sky130_fd_sc_hd__nand2_1
XTAP_TAPCELL_ROW_73_1078 VGND VPWR sky130_fd_sc_hd__tapvpwrvgnd_1
X_6238_ net109 _1565_ _1629_ _1630_ VGND VGND VPWR VPWR _1631_ sky130_fd_sc_hd__nor4_4
X_6169_ _1549_ _1554_ VGND VGND VPWR VPWR _1556_ sky130_fd_sc_hd__xnor2_1
XFILLER_0_67_402 VGND VGND VPWR VPWR sky130_fd_sc_hd__fill_1
XTAP_TAPCELL_ROW_15_408 VGND VPWR sky130_fd_sc_hd__tapvpwrvgnd_1
XFILLER_0_94_243 VGND VGND VPWR VPWR sky130_fd_sc_hd__decap_4
XTAP_TAPCELL_ROW_43_728 VGND VPWR sky130_fd_sc_hd__tapvpwrvgnd_1
XFILLER_0_54_118 VGND VGND VPWR VPWR sky130_fd_sc_hd__decap_6
XFILLER_0_35_321 VPWR VGND VPWR VGND sky130_ef_sc_hd__decap_12
Xclone31 _3075_ VGND VGND VPWR VPWR net149 sky130_fd_sc_hd__clkbuf_16
XTAP_TAPCELL_ROW_23_496 VGND VPWR sky130_fd_sc_hd__tapvpwrvgnd_1
XFILLER_0_90_471 VGND VGND VPWR VPWR sky130_fd_sc_hd__decap_4
XFILLER_0_62_195 VGND VGND VPWR VPWR sky130_fd_sc_hd__fill_1
XFILLER_0_31_571 VPWR VGND VPWR VGND sky130_ef_sc_hd__decap_12
XFILLER_0_58_468 VGND VGND VPWR VPWR sky130_fd_sc_hd__fill_2
X_3870_ _0311_ _0322_ VGND VGND VPWR VPWR _0333_ sky130_fd_sc_hd__and2b_1
XFILLER_0_73_416 VGND VGND VPWR VPWR sky130_fd_sc_hd__fill_1
XFILLER_0_73_449 VGND VGND VPWR VPWR sky130_fd_sc_hd__decap_3
X_5540_ _0864_ _0865_ _0866_ VGND VGND VPWR VPWR _0869_ sky130_fd_sc_hd__a21oi_1
XFILLER_0_5_237 VGND VGND VPWR VPWR sky130_fd_sc_hd__fill_2
XFILLER_0_38_192 VGND VGND VPWR VPWR sky130_fd_sc_hd__decap_4
X_5471_ _3520_ _1446_ _0457_ _2857_ VGND VGND VPWR VPWR _0794_ sky130_fd_sc_hd__a22oi_2
XFILLER_0_14_516 VPWR VGND VPWR VGND sky130_ef_sc_hd__decap_12
XFILLER_0_30_64 VGND VGND VPWR VPWR sky130_fd_sc_hd__fill_1
X_7210_ _0717_ _2687_ _2691_ _2693_ VGND VGND VPWR VPWR _2694_ sky130_fd_sc_hd__and4_1
X_4422_ _3500_ _3529_ _3530_ VGND VGND VPWR VPWR _3531_ sky130_fd_sc_hd__nor3_1
XFILLER_0_30_75 VGND VGND VPWR VPWR sky130_fd_sc_hd__decap_8
XFILLER_0_30_97 VGND VGND VPWR VPWR sky130_fd_sc_hd__fill_2
XFILLER_0_69_7 VPWR VGND VPWR VGND sky130_ef_sc_hd__decap_12
X_4353_ net24 VGND VGND VPWR VPWR _3463_ sky130_fd_sc_hd__clkbuf_4
X_7141_ _2933_ _2583_ _0159_ net47 VGND VGND VPWR VPWR _2619_ sky130_fd_sc_hd__and4_1
XFILLER_0_39_51 VGND VGND VPWR VPWR sky130_fd_sc_hd__decap_4
X_4284_ _3395_ VGND VGND VPWR VPWR _3396_ sky130_fd_sc_hd__buf_2
X_7072_ _1621_ _1260_ _1173_ _1807_ VGND VGND VPWR VPWR _2543_ sky130_fd_sc_hd__a22oi_1
X_6023_ _3152_ _1282_ _1195_ _2911_ VGND VGND VPWR VPWR _1396_ sky130_fd_sc_hd__a22oi_1
XFILLER_0_12_3 VPWR VGND VPWR VGND sky130_ef_sc_hd__decap_12
X_6925_ _2366_ _2367_ _2381_ VGND VGND VPWR VPWR _2382_ sky130_fd_sc_hd__a21o_1
XFILLER_0_76_221 VGND VGND VPWR VPWR sky130_fd_sc_hd__decap_6
XFILLER_0_49_446 VGND VGND VPWR VPWR sky130_fd_sc_hd__fill_2
X_6856_ _0203_ _1980_ _2141_ _0170_ _0627_ VGND VGND VPWR VPWR _2307_ sky130_fd_sc_hd__o311a_1
XFILLER_0_64_416 VGND VGND VPWR VPWR sky130_fd_sc_hd__decap_4
XFILLER_0_91_213 VGND VGND VPWR VPWR sky130_fd_sc_hd__fill_1
XFILLER_0_71_93 VPWR VGND VPWR VGND sky130_ef_sc_hd__decap_12
XFILLER_0_9_576 VPWR VGND VPWR VGND sky130_ef_sc_hd__decap_12
X_5807_ _1028_ _1030_ _1029_ VGND VGND VPWR VPWR _1160_ sky130_fd_sc_hd__o21ba_1
X_3999_ _1730_ VGND VGND VPWR VPWR _1741_ sky130_fd_sc_hd__buf_4
X_6787_ _2229_ _2230_ VGND VGND VPWR VPWR _2231_ sky130_fd_sc_hd__nor2_1
X_5738_ _0386_ _3351_ VGND VGND VPWR VPWR _1085_ sky130_fd_sc_hd__nand2_1
XFILLER_0_60_600 VGND VGND VPWR VPWR sky130_fd_sc_hd__fill_1
XFILLER_0_29_192 VGND VGND VPWR VPWR sky130_fd_sc_hd__fill_1
XFILLER_0_45_641 VGND VGND VPWR VPWR sky130_fd_sc_hd__decap_6
XTAP_TAPCELL_ROW_20_466 VGND VPWR sky130_fd_sc_hd__tapvpwrvgnd_1
XFILLER_0_32_324 VGND VGND VPWR VPWR sky130_fd_sc_hd__fill_1
X_5669_ _1007_ _1008_ VGND VGND VPWR VPWR _1010_ sky130_fd_sc_hd__nor2_1
X_7408_ _2903_ _2904_ _2909_ VGND VGND VPWR VPWR _2910_ sky130_fd_sc_hd__o21a_1
X_7339_ _2832_ _2833_ _2812_ VGND VGND VPWR VPWR _2836_ sky130_fd_sc_hd__o21ai_1
XTAP_TAPCELL_ROW_86_1225 VGND VPWR sky130_fd_sc_hd__tapvpwrvgnd_1
XTAP_TAPCELL_ROW_56_875 VGND VPWR sky130_fd_sc_hd__tapvpwrvgnd_1
XTAP_TAPCELL_ROW_28_555 VGND VPWR sky130_fd_sc_hd__tapvpwrvgnd_1
XFILLER_0_95_541 VPWR VGND VPWR VGND sky130_ef_sc_hd__decap_12
XFILLER_0_67_221 VGND VGND VPWR VPWR sky130_fd_sc_hd__decap_3
XTAP_TAPCELL_ROW_56_886 VGND VPWR sky130_fd_sc_hd__tapvpwrvgnd_1
XFILLER_0_95_585 VPWR VGND VPWR VGND sky130_ef_sc_hd__decap_12
XFILLER_0_55_449 VPWR VGND VPWR VGND sky130_ef_sc_hd__decap_12
XFILLER_0_70_419 VGND VGND VPWR VPWR sky130_fd_sc_hd__fill_1
XTAP_TAPCELL_ROW_97_1354 VGND VPWR sky130_fd_sc_hd__tapvpwrvgnd_1
XFILLER_0_23_335 VGND VGND VPWR VPWR sky130_fd_sc_hd__fill_1
XFILLER_0_23_357 VGND VGND VPWR VPWR sky130_fd_sc_hd__fill_2
XFILLER_0_76_27 VGND VGND VPWR VPWR sky130_fd_sc_hd__fill_1
XFILLER_0_25_53 VGND VGND VPWR VPWR sky130_fd_sc_hd__decap_3
XTAP_TAPCELL_ROW_106_1461 VGND VPWR sky130_fd_sc_hd__tapvpwrvgnd_1
XTAP_TAPCELL_ROW_106_1450 VGND VPWR sky130_fd_sc_hd__tapvpwrvgnd_1
XFILLER_0_25_75 VGND VGND VPWR VPWR sky130_fd_sc_hd__fill_2
X_4971_ _0245_ _0247_ _0248_ VGND VGND VPWR VPWR _0249_ sky130_fd_sc_hd__nand3_1
X_6710_ _0390_ _3489_ _3302_ VGND VGND VPWR VPWR _2148_ sky130_fd_sc_hd__and3_1
X_7690_ _0845_ _1817_ _3216_ _3219_ VGND VGND VPWR VPWR _3220_ sky130_fd_sc_hd__a211o_1
X_3922_ _0856_ _0878_ VGND VGND VPWR VPWR _0900_ sky130_fd_sc_hd__nand2_2
X_3853_ _0137_ VGND VGND VPWR VPWR _0148_ sky130_fd_sc_hd__buf_2
X_6641_ _2067_ _2068_ _2070_ VGND VGND VPWR VPWR _2072_ sky130_fd_sc_hd__a21o_1
XFILLER_0_73_257 VPWR VGND VPWR VGND sky130_ef_sc_hd__decap_12
X_6572_ _3303_ _0017_ _0717_ _1996_ VGND VGND VPWR VPWR _1997_ sky130_fd_sc_hd__o211a_1
XFILLER_0_6_557 VGND VGND VPWR VPWR sky130_fd_sc_hd__decap_4
XFILLER_0_41_85 VPWR VGND VPWR VGND sky130_ef_sc_hd__decap_12
X_5523_ _0386_ _3349_ _0110_ _0850_ VGND VGND VPWR VPWR _0851_ sky130_fd_sc_hd__a31o_1
XFILLER_0_14_346 VGND VGND VPWR VPWR sky130_fd_sc_hd__decap_8
X_5454_ _0667_ _0686_ _0687_ VGND VGND VPWR VPWR _0775_ sky130_fd_sc_hd__nand3_2
XFILLER_0_41_154 VGND VGND VPWR VPWR sky130_fd_sc_hd__decap_3
X_4405_ _3364_ _3502_ _3504_ _3514_ VGND VGND VPWR VPWR _3515_ sky130_fd_sc_hd__a31o_1
X_5385_ _0697_ _0698_ _0577_ _0579_ VGND VGND VPWR VPWR _0700_ sky130_fd_sc_hd__o211a_1
XFILLER_0_41_198 VPWR VGND VPWR VGND sky130_ef_sc_hd__decap_12
X_4336_ _2802_ _3325_ _3308_ VGND VGND VPWR VPWR _3447_ sky130_fd_sc_hd__mux2_1
XFILLER_0_10_541 VPWR VGND VPWR VGND sky130_ef_sc_hd__decap_12
X_7124_ _2423_ _2425_ _2598_ _2599_ VGND VGND VPWR VPWR _2600_ sky130_fd_sc_hd__a211oi_2
XTAP_TAPCELL_ROW_70_1037 VGND VPWR sky130_fd_sc_hd__tapvpwrvgnd_1
X_4267_ _1107_ VGND VGND VPWR VPWR _3379_ sky130_fd_sc_hd__clkbuf_4
X_7055_ _2522_ _2523_ VGND VGND VPWR VPWR _2524_ sky130_fd_sc_hd__xnor2_1
X_6006_ _3376_ _1304_ _1377_ VGND VGND VPWR VPWR _1378_ sky130_fd_sc_hd__a21oi_1
XFILLER_0_66_82 VGND VGND VPWR VPWR sky130_fd_sc_hd__fill_2
X_4198_ _3043_ VGND VGND VPWR VPWR _3310_ sky130_fd_sc_hd__buf_6
XFILLER_0_89_390 VGND VGND VPWR VPWR sky130_fd_sc_hd__fill_2
XFILLER_0_77_585 VPWR VGND VPWR VGND sky130_ef_sc_hd__decap_12
XTAP_TAPCELL_ROW_25_525 VGND VPWR sky130_fd_sc_hd__tapvpwrvgnd_1
X_6908_ _2235_ _2234_ VGND VGND VPWR VPWR _2363_ sky130_fd_sc_hd__and2b_1
XTAP_TAPCELL_ROW_53_845 VGND VPWR sky130_fd_sc_hd__tapvpwrvgnd_1
XTAP_TAPCELL_ROW_81_1166 VGND VPWR sky130_fd_sc_hd__tapvpwrvgnd_1
XFILLER_0_64_224 VGND VGND VPWR VPWR sky130_fd_sc_hd__decap_4
XFILLER_0_37_449 VPWR VGND VPWR VGND sky130_ef_sc_hd__decap_12
X_6839_ _2183_ _2286_ _2287_ VGND VGND VPWR VPWR _2289_ sky130_fd_sc_hd__or3_2
XFILLER_0_103_543 VPWR VGND VPWR VGND sky130_ef_sc_hd__decap_12
XFILLER_0_20_305 VGND VGND VPWR VPWR sky130_fd_sc_hd__decap_3
XFILLER_0_32_165 VPWR VGND VPWR VGND sky130_ef_sc_hd__decap_12
XFILLER_0_60_496 VPWR VGND VPWR VGND sky130_ef_sc_hd__decap_12
XTAP_TAPCELL_ROW_92_1295 VGND VPWR sky130_fd_sc_hd__tapvpwrvgnd_1
XFILLER_0_1_3 VPWR VGND VPWR VGND sky130_ef_sc_hd__decap_12
XTAP_TAPCELL_ROW_5_294 VGND VPWR sky130_fd_sc_hd__tapvpwrvgnd_1
XFILLER_0_87_316 VGND VGND VPWR VPWR sky130_fd_sc_hd__decap_8
XFILLER_0_87_305 VGND VGND VPWR VPWR sky130_fd_sc_hd__fill_2
XFILLER_0_62_29 VPWR VGND VPWR VGND sky130_ef_sc_hd__decap_12
XFILLER_0_83_533 VPWR VGND VPWR VGND sky130_ef_sc_hd__decap_12
XFILLER_0_83_511 VGND VGND VPWR VPWR sky130_fd_sc_hd__fill_1
XFILLER_0_68_585 VGND VGND VPWR VPWR sky130_fd_sc_hd__decap_3
XFILLER_0_83_588 VPWR VGND VPWR VGND sky130_ef_sc_hd__decap_12
XFILLER_0_70_205 VGND VGND VPWR VPWR sky130_fd_sc_hd__fill_1
XFILLER_0_11_55 VGND VGND VPWR VPWR sky130_fd_sc_hd__fill_1
XFILLER_0_3_505 VGND VGND VPWR VPWR sky130_fd_sc_hd__decap_3
XFILLER_0_51_441 VGND VGND VPWR VPWR sky130_fd_sc_hd__fill_1
XFILLER_0_11_88 VPWR VGND VPWR VGND sky130_ef_sc_hd__decap_12
XFILLER_0_11_316 VPWR VGND VPWR VGND sky130_ef_sc_hd__decap_12
X_5170_ net143 _2955_ _0465_ net2 VGND VGND VPWR VPWR _0466_ sky130_fd_sc_hd__and4_1
X_4121_ _3064_ VGND VGND VPWR VPWR _3075_ sky130_fd_sc_hd__buf_12
X_4052_ _2157_ _2167_ VGND VGND VPWR VPWR _2321_ sky130_fd_sc_hd__and2_1
Xinput4 A[13] VGND VGND VPWR VPWR net4 sky130_fd_sc_hd__clkbuf_2
XFILLER_0_36_52 VGND VGND VPWR VPWR sky130_fd_sc_hd__fill_1
XFILLER_0_36_85 VGND VGND VPWR VPWR sky130_fd_sc_hd__decap_8
XFILLER_0_19_405 VPWR VGND VPWR VGND sky130_ef_sc_hd__decap_12
X_4954_ _0223_ _0228_ _0229_ VGND VGND VPWR VPWR _0230_ sky130_fd_sc_hd__and3_1
X_3905_ _0704_ VGND VGND VPWR VPWR _0715_ sky130_fd_sc_hd__buf_2
XFILLER_0_19_449 VPWR VGND VPWR VGND sky130_ef_sc_hd__decap_12
XTAP_TAPCELL_ROW_50_815 VGND VPWR sky130_fd_sc_hd__tapvpwrvgnd_1
XFILLER_0_52_62 VPWR VGND VPWR VGND sky130_ef_sc_hd__decap_12
X_7673_ _3199_ _3200_ VGND VGND VPWR VPWR _3201_ sky130_fd_sc_hd__xnor2_1
X_4885_ _0152_ _0153_ _0154_ VGND VGND VPWR VPWR _0155_ sky130_fd_sc_hd__nand3_2
XFILLER_0_61_205 VGND VGND VPWR VPWR sky130_fd_sc_hd__decap_3
X_6624_ _1864_ _1873_ _1871_ VGND VGND VPWR VPWR _2053_ sky130_fd_sc_hd__a21bo_1
X_6555_ _1337_ _1215_ _1151_ _1315_ VGND VGND VPWR VPWR _1978_ sky130_fd_sc_hd__o211a_1
XFILLER_0_61_249 VPWR VGND VPWR VGND sky130_ef_sc_hd__decap_12
XFILLER_0_6_365 VPWR VGND VPWR VGND sky130_ef_sc_hd__decap_12
XFILLER_0_6_354 VGND VGND VPWR VPWR sky130_fd_sc_hd__decap_8
XFILLER_0_27_482 VPWR VGND VPWR VGND sky130_ef_sc_hd__decap_12
XFILLER_0_42_430 VGND VGND VPWR VPWR sky130_fd_sc_hd__fill_1
X_5506_ _0510_ _0829_ _0830_ _0826_ VGND VGND VPWR VPWR _0832_ sky130_fd_sc_hd__a211oi_1
XTAP_TAPCELL_ROW_30_583 VGND VPWR sky130_fd_sc_hd__tapvpwrvgnd_1
X_6486_ _1898_ _1899_ _1900_ VGND VGND VPWR VPWR _1902_ sky130_fd_sc_hd__a21o_1
X_5437_ _2911_ _1402_ _3253_ _3692_ VGND VGND VPWR VPWR _0756_ sky130_fd_sc_hd__a22o_1
XFILLER_0_10_360 VGND VGND VPWR VPWR sky130_fd_sc_hd__decap_4
X_5368_ _0677_ _0678_ _0679_ VGND VGND VPWR VPWR _0681_ sky130_fd_sc_hd__a21o_1
X_4319_ _3426_ _3429_ _3320_ VGND VGND VPWR VPWR _3430_ sky130_fd_sc_hd__mux2_1
X_5299_ _0383_ _0605_ _3482_ VGND VGND VPWR VPWR _0607_ sky130_fd_sc_hd__mux2_1
X_7107_ _2413_ _2421_ VGND VGND VPWR VPWR _2581_ sky130_fd_sc_hd__nand2_1
X_7038_ _2330_ _2333_ VGND VGND VPWR VPWR _2505_ sky130_fd_sc_hd__and2_1
XTAP_TAPCELL_ROW_58_904 VGND VPWR sky130_fd_sc_hd__tapvpwrvgnd_1
XTAP_TAPCELL_ROW_2_264 VGND VPWR sky130_fd_sc_hd__tapvpwrvgnd_1
XTAP_TAPCELL_ROW_38_672 VGND VPWR sky130_fd_sc_hd__tapvpwrvgnd_1
XFILLER_0_96_179 VPWR VGND VPWR VGND sky130_ef_sc_hd__decap_12
XTAP_TAPCELL_ROW_66_992 VGND VPWR sky130_fd_sc_hd__tapvpwrvgnd_1
XFILLER_0_77_371 VPWR VGND VPWR VGND sky130_ef_sc_hd__decap_12
XFILLER_0_65_511 VPWR VGND VPWR VGND sky130_ef_sc_hd__decap_12
XFILLER_0_108_613 VPWR VGND VPWR VGND sky130_ef_sc_hd__decap_12
XFILLER_0_92_352 VPWR VGND VPWR VGND sky130_ef_sc_hd__decap_12
XFILLER_0_80_503 VGND VGND VPWR VPWR sky130_fd_sc_hd__decap_3
XFILLER_0_9_181 VPWR VGND VPWR VGND sky130_ef_sc_hd__decap_12
XFILLER_0_107_178 VGND VGND VPWR VPWR sky130_fd_sc_hd__decap_4
XFILLER_0_33_430 VGND VGND VPWR VPWR sky130_fd_sc_hd__fill_1
XTAP_TAPCELL_ROW_94_1313 VGND VPWR sky130_fd_sc_hd__tapvpwrvgnd_1
XFILLER_0_21_614 VGND VGND VPWR VPWR sky130_fd_sc_hd__fill_2
XFILLER_0_20_113 VGND VGND VPWR VPWR sky130_fd_sc_hd__fill_2
XPHY_EDGE_ROW_29_Left_139 VGND VGND VPWR VPWR sky130_fd_sc_hd__decap_3
XFILLER_0_88_636 VGND VGND VPWR VPWR sky130_fd_sc_hd__decap_8
XFILLER_0_88_614 VGND VGND VPWR VPWR sky130_fd_sc_hd__fill_1
XFILLER_0_87_113 VPWR VGND VPWR VGND sky130_ef_sc_hd__decap_12
XTAP_TAPCELL_ROW_103_1420 VGND VPWR sky130_fd_sc_hd__tapvpwrvgnd_1
XPHY_EDGE_ROW_1_Left_111 VGND VGND VPWR VPWR sky130_fd_sc_hd__decap_3
XPHY_EDGE_ROW_38_Left_148 VGND VGND VPWR VPWR sky130_fd_sc_hd__decap_3
XFILLER_0_83_330 VGND VGND VPWR VPWR sky130_fd_sc_hd__fill_1
X_4670_ _3773_ _3774_ VGND VGND VPWR VPWR _3775_ sky130_fd_sc_hd__and2b_1
XFILLER_0_3_335 VGND VGND VPWR VPWR sky130_fd_sc_hd__fill_1
X_6340_ _1738_ _1739_ _1740_ VGND VGND VPWR VPWR _1743_ sky130_fd_sc_hd__a21o_1
XFILLER_0_12_625 VPWR VGND VPWR VGND sky130_ef_sc_hd__decap_12
XFILLER_0_51_271 VGND VGND VPWR VPWR sky130_fd_sc_hd__decap_8
X_6271_ _0911_ _1667_ VGND VGND VPWR VPWR _1668_ sky130_fd_sc_hd__and2_1
XPHY_EDGE_ROW_47_Left_157 VGND VGND VPWR VPWR sky130_fd_sc_hd__decap_3
XFILLER_0_51_293 VGND VGND VPWR VPWR sky130_fd_sc_hd__decap_3
XFILLER_0_11_179 VGND VGND VPWR VPWR sky130_fd_sc_hd__decap_8
X_5222_ _3010_ _3508_ _1402_ _3254_ VGND VGND VPWR VPWR _0522_ sky130_fd_sc_hd__and4_1
X_5153_ _2572_ _1741_ _0327_ _0326_ VGND VGND VPWR VPWR _0447_ sky130_fd_sc_hd__a31o_1
X_4104_ net22 VGND VGND VPWR VPWR _2889_ sky130_fd_sc_hd__buf_6
X_5084_ _0369_ _0370_ _0306_ VGND VGND VPWR VPWR _0372_ sky130_fd_sc_hd__a21o_1
X_4035_ _2058_ _2102_ _1479_ _1512_ VGND VGND VPWR VPWR _2135_ sky130_fd_sc_hd__a22o_1
XFILLER_0_2_53 VPWR VGND VPWR VGND sky130_ef_sc_hd__decap_12
XFILLER_0_78_168 VGND VGND VPWR VPWR sky130_fd_sc_hd__decap_3
XFILLER_0_78_146 VGND VGND VPWR VPWR sky130_fd_sc_hd__decap_6
XPHY_EDGE_ROW_56_Left_166 VGND VGND VPWR VPWR sky130_fd_sc_hd__decap_3
XFILLER_0_2_97 VPWR VGND VPWR VGND sky130_ef_sc_hd__decap_12
X_5986_ _1337_ _1215_ _1315_ VGND VGND VPWR VPWR _1356_ sky130_fd_sc_hd__o21a_1
XTAP_TAPCELL_ROW_63_962 VGND VPWR sky130_fd_sc_hd__tapvpwrvgnd_1
XFILLER_0_19_202 VGND VGND VPWR VPWR sky130_fd_sc_hd__decap_3
XTAP_TAPCELL_ROW_35_642 VGND VPWR sky130_fd_sc_hd__tapvpwrvgnd_1
XFILLER_0_59_393 VPWR VGND VPWR VGND sky130_ef_sc_hd__decap_12
X_4937_ _3196_ _1807_ _1621_ _3163_ VGND VGND VPWR VPWR _0211_ sky130_fd_sc_hd__a22oi_2
X_7656_ _3326_ _0213_ VGND VGND VPWR VPWR _3182_ sky130_fd_sc_hd__nand2_1
XFILLER_0_74_363 VGND VGND VPWR VPWR sky130_fd_sc_hd__fill_1
XFILLER_0_7_641 VGND VGND VPWR VPWR sky130_fd_sc_hd__decap_8
XFILLER_0_19_279 VGND VGND VPWR VPWR sky130_fd_sc_hd__fill_1
X_4868_ _0130_ _0135_ VGND VGND VPWR VPWR _0136_ sky130_fd_sc_hd__xnor2_1
XFILLER_0_47_599 VGND VGND VPWR VPWR sky130_fd_sc_hd__decap_8
XFILLER_0_34_227 VGND VGND VPWR VPWR sky130_fd_sc_hd__decap_6
X_6607_ _2031_ _2032_ _2033_ VGND VGND VPWR VPWR _2034_ sky130_fd_sc_hd__or3_1
X_7587_ _3098_ _3105_ VGND VGND VPWR VPWR _3106_ sky130_fd_sc_hd__xnor2_1
XFILLER_0_105_649 VGND VGND VPWR VPWR sky130_fd_sc_hd__decap_3
XFILLER_0_6_195 VGND VGND VPWR VPWR sky130_fd_sc_hd__fill_1
X_4799_ _0052_ _0059_ _0060_ VGND VGND VPWR VPWR _0062_ sky130_fd_sc_hd__nand3_1
XPHY_EDGE_ROW_65_Left_175 VGND VGND VPWR VPWR sky130_fd_sc_hd__decap_3
X_6538_ _1956_ _1957_ _1680_ VGND VGND VPWR VPWR _1959_ sky130_fd_sc_hd__o21a_1
XFILLER_0_42_260 VPWR VGND VPWR VGND sky130_ef_sc_hd__decap_12
XFILLER_0_88_80 VGND VGND VPWR VPWR sky130_fd_sc_hd__decap_4
X_6469_ _1844_ _1845_ _1881_ _1882_ VGND VGND VPWR VPWR _1884_ sky130_fd_sc_hd__a211oi_2
XFILLER_0_100_332 VPWR VGND VPWR VGND sky130_ef_sc_hd__decap_12
XTAP_TAPCELL_ROW_7_312 VGND VPWR sky130_fd_sc_hd__tapvpwrvgnd_1
XFILLER_0_30_477 VGND VGND VPWR VPWR sky130_fd_sc_hd__decap_4
XFILLER_0_100_365 VPWR VGND VPWR VGND sky130_ef_sc_hd__decap_12
XFILLER_0_100_354 VGND VGND VPWR VPWR sky130_fd_sc_hd__decap_8
XPHY_EDGE_ROW_102_Right_102 VGND VGND VPWR VPWR sky130_fd_sc_hd__decap_3
XFILLER_0_97_400 VGND VGND VPWR VPWR sky130_fd_sc_hd__fill_2
XFILLER_0_97_433 VPWR VGND VPWR VGND sky130_ef_sc_hd__decap_12
XPHY_EDGE_ROW_74_Left_184 VGND VGND VPWR VPWR sky130_fd_sc_hd__decap_3
XFILLER_0_69_113 VGND VGND VPWR VPWR sky130_fd_sc_hd__fill_1
XFILLER_0_65_330 VGND VGND VPWR VPWR sky130_fd_sc_hd__decap_6
XFILLER_0_38_533 VGND VGND VPWR VPWR sky130_fd_sc_hd__fill_1
XFILLER_0_38_599 VPWR VGND VPWR VGND sky130_ef_sc_hd__decap_12
XFILLER_0_53_547 VPWR VGND VPWR VGND sky130_ef_sc_hd__decap_12
XPHY_EDGE_ROW_83_Left_193 VGND VGND VPWR VPWR sky130_fd_sc_hd__decap_3
XFILLER_0_61_591 VGND VGND VPWR VPWR sky130_fd_sc_hd__decap_4
XFILLER_0_33_293 VGND VGND VPWR VPWR sky130_fd_sc_hd__decap_8
XFILLER_0_21_488 VPWR VGND VPWR VGND sky130_ef_sc_hd__decap_12
XFILLER_0_84_27 VGND VGND VPWR VPWR sky130_fd_sc_hd__fill_1
XFILLER_0_88_433 VGND VGND VPWR VPWR sky130_fd_sc_hd__decap_6
XFILLER_0_88_477 VGND VGND VPWR VPWR sky130_fd_sc_hd__fill_2
XFILLER_0_88_466 VGND VGND VPWR VPWR sky130_fd_sc_hd__decap_8
X_5840_ net112 net154 _1194_ _1196_ VGND VGND VPWR VPWR _1197_ sky130_fd_sc_hd__o211ai_4
XFILLER_0_68_190 VGND VGND VPWR VPWR sky130_fd_sc_hd__decap_6
XTAP_TAPCELL_ROW_60_932 VGND VPWR sky130_fd_sc_hd__tapvpwrvgnd_1
XTAP_TAPCELL_ROW_60_921 VGND VPWR sky130_fd_sc_hd__tapvpwrvgnd_1
XTAP_TAPCELL_ROW_32_601 VGND VPWR sky130_fd_sc_hd__tapvpwrvgnd_1
X_5771_ net25 _2550_ _2069_ _0693_ VGND VGND VPWR VPWR _1121_ sky130_fd_sc_hd__and4_1
X_7510_ _3020_ _3022_ VGND VGND VPWR VPWR _3023_ sky130_fd_sc_hd__nor2_1
XFILLER_0_16_205 VGND VGND VPWR VPWR sky130_fd_sc_hd__fill_1
XFILLER_0_29_599 VPWR VGND VPWR VGND sky130_ef_sc_hd__decap_12
X_4722_ _3778_ _3780_ _3779_ VGND VGND VPWR VPWR _3826_ sky130_fd_sc_hd__o21bai_1
X_7441_ _2945_ _2946_ VGND VGND VPWR VPWR _2947_ sky130_fd_sc_hd__nor2_1
X_4653_ _3396_ _3721_ _3443_ _3745_ VGND VGND VPWR VPWR _3758_ sky130_fd_sc_hd__a31o_1
XTAP_TAPCELL_ROW_12_380 VGND VPWR sky130_fd_sc_hd__tapvpwrvgnd_1
XFILLER_0_44_569 VGND VGND VPWR VPWR sky130_fd_sc_hd__decap_8
Xinput40 B[18] VGND VGND VPWR VPWR net40 sky130_fd_sc_hd__clkbuf_2
Xinput51 B[28] VGND VGND VPWR VPWR net51 sky130_fd_sc_hd__clkbuf_4
X_7372_ _3742_ _3303_ _0610_ _2870_ VGND VGND VPWR VPWR _2871_ sky130_fd_sc_hd__o31a_1
Xinput62 B[9] VGND VGND VPWR VPWR net62 sky130_fd_sc_hd__buf_1
XFILLER_0_24_271 VGND VGND VPWR VPWR sky130_fd_sc_hd__decap_4
X_4584_ _3032_ _3621_ VGND VGND VPWR VPWR _3690_ sky130_fd_sc_hd__and2_1
XFILLER_0_12_433 VGND VGND VPWR VPWR sky130_fd_sc_hd__fill_2
X_6323_ _1721_ _1722_ _1558_ _1683_ VGND VGND VPWR VPWR _1724_ sky130_fd_sc_hd__o211a_1
X_6254_ _1345_ _1353_ _1502_ _1648_ VGND VGND VPWR VPWR _1649_ sky130_fd_sc_hd__a31o_1
X_5205_ _3255_ _0503_ VGND VGND VPWR VPWR _0504_ sky130_fd_sc_hd__nand2_1
XFILLER_0_58_72 VPWR VGND VPWR VGND sky130_ef_sc_hd__decap_12
XFILLER_0_58_61 VGND VGND VPWR VPWR sky130_fd_sc_hd__decap_4
X_6185_ net35 net34 _1829_ net31 VGND VGND VPWR VPWR _1573_ sky130_fd_sc_hd__and4_1
XFILLER_0_42_3 VGND VGND VPWR VPWR sky130_fd_sc_hd__decap_4
X_5136_ _3097_ _1413_ _1971_ _3406_ VGND VGND VPWR VPWR _0428_ sky130_fd_sc_hd__o2bb2a_1
XFILLER_0_74_60 VGND VGND VPWR VPWR sky130_fd_sc_hd__decap_6
X_5067_ _0331_ _0351_ _0352_ VGND VGND VPWR VPWR _0353_ sky130_fd_sc_hd__and3_1
XFILLER_0_79_422 VGND VGND VPWR VPWR sky130_fd_sc_hd__decap_8
XTAP_TAPCELL_ROW_67_1009 VGND VPWR sky130_fd_sc_hd__tapvpwrvgnd_1
X_4018_ _1938_ VGND VGND VPWR VPWR _1949_ sky130_fd_sc_hd__clkbuf_4
XFILLER_0_94_403 VPWR VGND VPWR VGND sky130_ef_sc_hd__decap_12
XFILLER_0_94_469 VGND VGND VPWR VPWR sky130_fd_sc_hd__decap_6
X_5969_ _1334_ _1335_ _1197_ _1199_ VGND VGND VPWR VPWR _1338_ sky130_fd_sc_hd__o211a_1
X_7708_ _3062_ _3066_ _3223_ _3211_ VGND VGND VPWR VPWR _3237_ sky130_fd_sc_hd__o31a_1
XFILLER_0_47_363 VGND VGND VPWR VPWR sky130_fd_sc_hd__decap_4
XFILLER_0_74_193 VGND VGND VPWR VPWR sky130_fd_sc_hd__decap_3
XFILLER_0_62_333 VPWR VGND VPWR VGND sky130_ef_sc_hd__decap_12
XFILLER_0_105_424 VGND VGND VPWR VPWR sky130_fd_sc_hd__decap_6
X_7639_ _3161_ _3162_ VGND VGND VPWR VPWR _3164_ sky130_fd_sc_hd__xnor2_1
XFILLER_0_7_482 VGND VGND VPWR VPWR sky130_fd_sc_hd__fill_2
XFILLER_0_105_446 VGND VGND VPWR VPWR sky130_fd_sc_hd__fill_2
XTAP_TAPCELL_ROW_78_1138 VGND VPWR sky130_fd_sc_hd__tapvpwrvgnd_1
XFILLER_0_101_641 VGND VGND VPWR VPWR sky130_fd_sc_hd__decap_8
XFILLER_0_100_162 VPWR VGND VPWR VGND sky130_ef_sc_hd__decap_12
XTAP_TAPCELL_ROW_89_1256 VGND VPWR sky130_fd_sc_hd__tapvpwrvgnd_1
XFILLER_0_58_606 VPWR VGND VPWR VGND sky130_ef_sc_hd__decap_12
XTAP_TAPCELL_ROW_18_439 VGND VPWR sky130_fd_sc_hd__tapvpwrvgnd_1
XFILLER_0_85_469 VGND VGND VPWR VPWR sky130_fd_sc_hd__fill_1
XFILLER_0_70_29 VGND VGND VPWR VPWR sky130_fd_sc_hd__decap_8
XFILLER_0_26_503 VPWR VGND VPWR VGND sky130_ef_sc_hd__decap_12
XPHY_EDGE_ROW_91_Left_201 VGND VGND VPWR VPWR sky130_fd_sc_hd__decap_3
XFILLER_0_38_396 VPWR VGND VPWR VGND sky130_ef_sc_hd__decap_12
XFILLER_0_108_262 VGND VGND VPWR VPWR sky130_fd_sc_hd__fill_1
XFILLER_0_80_174 VPWR VGND VPWR VGND sky130_ef_sc_hd__decap_12
XFILLER_0_0_113 VPWR VGND VPWR VGND sky130_ef_sc_hd__decap_12
XFILLER_0_21_285 VPWR VGND VPWR VGND sky130_ef_sc_hd__decap_12
XFILLER_0_28_97 VGND VGND VPWR VPWR sky130_fd_sc_hd__fill_1
XFILLER_0_49_606 VGND VGND VPWR VPWR sky130_fd_sc_hd__fill_1
X_6941_ _1665_ _3269_ _1293_ _1195_ VGND VGND VPWR VPWR _2400_ sky130_fd_sc_hd__and4_1
XTAP_TAPCELL_ROW_109_1492 VGND VPWR sky130_fd_sc_hd__tapvpwrvgnd_1
XFILLER_0_76_425 VGND VGND VPWR VPWR sky130_fd_sc_hd__fill_1
X_6872_ _2019_ _2158_ _2291_ _2292_ VGND VGND VPWR VPWR _2324_ sky130_fd_sc_hd__o211ai_4
XFILLER_0_44_85 VGND VGND VPWR VPWR sky130_fd_sc_hd__decap_8
XFILLER_0_49_617 VPWR VGND VPWR VGND sky130_ef_sc_hd__decap_12
XFILLER_0_76_436 VGND VGND VPWR VPWR sky130_fd_sc_hd__decap_8
X_5823_ net8 net140 net7 net143 VGND VGND VPWR VPWR _1178_ sky130_fd_sc_hd__a22oi_4
XFILLER_0_60_62 VPWR VGND VPWR VGND sky130_ef_sc_hd__decap_12
XFILLER_0_8_246 VGND VGND VPWR VPWR sky130_fd_sc_hd__decap_6
X_5754_ _0943_ _1074_ VGND VGND VPWR VPWR _1102_ sky130_fd_sc_hd__or2b_1
X_5685_ _0893_ _0895_ _0894_ VGND VGND VPWR VPWR _1027_ sky130_fd_sc_hd__o21ba_4
X_4705_ _2342_ VGND VGND VPWR VPWR _3809_ sky130_fd_sc_hd__buf_4
X_4636_ _2430_ _3740_ VGND VGND VPWR VPWR _3741_ sky130_fd_sc_hd__xnor2_1
X_7424_ _1501_ _0671_ VGND VGND VPWR VPWR _2928_ sky130_fd_sc_hd__nand2_1
XFILLER_0_8_41 VPWR VGND VPWR VGND sky130_ef_sc_hd__decap_12
XFILLER_0_102_416 VGND VGND VPWR VPWR sky130_fd_sc_hd__decap_4
X_7355_ _2653_ _2850_ VGND VGND VPWR VPWR _2853_ sky130_fd_sc_hd__nand2_1
X_4567_ _3563_ _3660_ _3666_ _3673_ VGND VGND VPWR VPWR _3674_ sky130_fd_sc_hd__o211a_1
XFILLER_0_8_85 VPWR VGND VPWR VGND sky130_ef_sc_hd__decap_12
X_6306_ _1572_ _1575_ _1573_ VGND VGND VPWR VPWR _1705_ sky130_fd_sc_hd__o21bai_1
X_4498_ _3354_ _0039_ _3294_ VGND VGND VPWR VPWR _3606_ sky130_fd_sc_hd__or3_4
X_7286_ _1577_ _0813_ _2587_ _2586_ VGND VGND VPWR VPWR _2777_ sky130_fd_sc_hd__a31o_1
XTAP_TAPCELL_ROW_73_1079 VGND VPWR sky130_fd_sc_hd__tapvpwrvgnd_1
X_6237_ _1628_ _1627_ _1484_ _1567_ VGND VGND VPWR VPWR _1630_ sky130_fd_sc_hd__a211oi_4
X_6168_ _1552_ _1553_ VGND VGND VPWR VPWR _1554_ sky130_fd_sc_hd__xnor2_1
X_5119_ _3742_ _3322_ _3463_ VGND VGND VPWR VPWR _0410_ sky130_fd_sc_hd__o21a_1
X_6099_ _1476_ _1477_ _1478_ VGND VGND VPWR VPWR _1480_ sky130_fd_sc_hd__nand3_4
XFILLER_0_79_263 VPWR VGND VPWR VGND sky130_ef_sc_hd__decap_12
XTAP_TAPCELL_ROW_15_409 VGND VPWR sky130_fd_sc_hd__tapvpwrvgnd_1
XTAP_TAPCELL_ROW_43_729 VGND VPWR sky130_fd_sc_hd__tapvpwrvgnd_1
XTAP_TAPCELL_ROW_84_1197 VGND VPWR sky130_fd_sc_hd__tapvpwrvgnd_1
XFILLER_0_67_469 VPWR VGND VPWR VGND sky130_ef_sc_hd__decap_12
XFILLER_0_35_300 VPWR VGND VPWR VGND sky130_ef_sc_hd__decap_12
XFILLER_0_47_160 VGND VGND VPWR VPWR sky130_fd_sc_hd__decap_8
XFILLER_0_105_210 VPWR VGND VPWR VGND sky130_ef_sc_hd__decap_12
XTAP_TAPCELL_ROW_23_497 VGND VPWR sky130_fd_sc_hd__tapvpwrvgnd_1
XFILLER_0_35_333 VGND VGND VPWR VPWR sky130_fd_sc_hd__decap_3
XFILLER_0_50_336 VGND VGND VPWR VPWR sky130_fd_sc_hd__decap_8
XFILLER_0_31_561 VGND VGND VPWR VPWR sky130_fd_sc_hd__decap_6
XFILLER_0_31_583 VPWR VGND VPWR VGND sky130_ef_sc_hd__decap_12
XFILLER_0_65_18 VGND VGND VPWR VPWR sky130_fd_sc_hd__decap_3
XFILLER_0_105_57 VPWR VGND VPWR VGND sky130_ef_sc_hd__decap_12
XFILLER_0_14_55 VGND VGND VPWR VPWR sky130_fd_sc_hd__decap_4
XFILLER_0_46_609 VGND VGND VPWR VPWR sky130_fd_sc_hd__fill_2
XFILLER_0_38_171 VGND VGND VPWR VPWR sky130_fd_sc_hd__fill_1
XFILLER_0_54_620 VGND VGND VPWR VPWR sky130_fd_sc_hd__fill_1
XFILLER_0_54_631 VPWR VGND VPWR VGND sky130_ef_sc_hd__decap_12
XFILLER_0_109_571 VPWR VGND VPWR VGND sky130_ef_sc_hd__decap_12
XFILLER_0_26_333 VGND VGND VPWR VPWR sky130_fd_sc_hd__decap_4
XFILLER_0_81_461 VPWR VGND VPWR VGND sky130_ef_sc_hd__decap_12
X_5470_ _0242_ _3520_ _1446_ net4 VGND VGND VPWR VPWR _0793_ sky130_fd_sc_hd__and4_1
XFILLER_0_14_528 VGND VGND VPWR VPWR sky130_fd_sc_hd__decap_4
XFILLER_0_100_3 VPWR VGND VPWR VGND sky130_ef_sc_hd__decap_12
X_4421_ _3496_ _3528_ VGND VGND VPWR VPWR _3530_ sky130_fd_sc_hd__nor2_1
XFILLER_0_22_561 VGND VGND VPWR VPWR sky130_fd_sc_hd__decap_6
X_4352_ _3462_ VGND VGND VPWR VPWR net80 sky130_fd_sc_hd__clkbuf_1
X_7140_ _2933_ _0159_ _0213_ _2583_ VGND VGND VPWR VPWR _2618_ sky130_fd_sc_hd__a22oi_1
X_4283_ _3394_ VGND VGND VPWR VPWR _3395_ sky130_fd_sc_hd__clkbuf_4
X_7071_ _3260_ _2541_ VGND VGND VPWR VPWR _2542_ sky130_fd_sc_hd__xnor2_2
X_6022_ _1270_ _1272_ _1290_ _1291_ VGND VGND VPWR VPWR _1395_ sky130_fd_sc_hd__o211ai_2
XFILLER_0_89_550 VGND VGND VPWR VPWR sky130_fd_sc_hd__decap_8
XFILLER_0_89_561 VPWR VGND VPWR VGND sky130_ef_sc_hd__decap_12
X_6924_ _2372_ _2380_ VGND VGND VPWR VPWR _2381_ sky130_fd_sc_hd__xnor2_1
XFILLER_0_49_403 VGND VGND VPWR VPWR sky130_fd_sc_hd__decap_3
XFILLER_0_9_500 VGND VGND VPWR VPWR sky130_fd_sc_hd__decap_4
X_6855_ _0203_ _2142_ _0170_ VGND VGND VPWR VPWR _2306_ sky130_fd_sc_hd__o21a_1
XFILLER_0_76_277 VGND VGND VPWR VPWR sky130_fd_sc_hd__decap_8
XFILLER_0_37_609 VGND VGND VPWR VPWR sky130_fd_sc_hd__fill_1
XFILLER_0_49_469 VGND VGND VPWR VPWR sky130_fd_sc_hd__fill_2
X_3998_ _1719_ VGND VGND VPWR VPWR _1730_ sky130_fd_sc_hd__buf_4
XFILLER_0_9_555 VGND VGND VPWR VPWR sky130_fd_sc_hd__decap_4
X_5806_ _1035_ _1054_ net135 VGND VGND VPWR VPWR _1159_ sky130_fd_sc_hd__nand3_4
XFILLER_0_29_160 VGND VGND VPWR VPWR sky130_fd_sc_hd__decap_8
X_6786_ _1610_ _0769_ _0671_ _1796_ VGND VGND VPWR VPWR _2230_ sky130_fd_sc_hd__a22oi_1
X_5737_ _1249_ _1083_ VGND VGND VPWR VPWR _1084_ sky130_fd_sc_hd__xnor2_1
XFILLER_0_9_588 VPWR VGND VPWR VGND sky130_ef_sc_hd__decap_12
XFILLER_0_44_141 VGND VGND VPWR VPWR sky130_fd_sc_hd__decap_4
X_7407_ _2907_ _2908_ VGND VGND VPWR VPWR _2909_ sky130_fd_sc_hd__xnor2_1
XTAP_TAPCELL_ROW_20_467 VGND VPWR sky130_fd_sc_hd__tapvpwrvgnd_1
X_5668_ _2660_ _1402_ _1971_ _3248_ VGND VGND VPWR VPWR _1008_ sky130_fd_sc_hd__o2bb2a_1
X_4619_ _3342_ _3724_ VGND VGND VPWR VPWR _3725_ sky130_fd_sc_hd__and2_1
X_5599_ _0743_ _0932_ VGND VGND VPWR VPWR _0934_ sky130_fd_sc_hd__xor2_1
X_7338_ _2812_ _2832_ _2833_ VGND VGND VPWR VPWR _2834_ sky130_fd_sc_hd__or3_1
X_7269_ _2397_ _0878_ _1075_ _3269_ VGND VGND VPWR VPWR _2759_ sky130_fd_sc_hd__a22oi_1
XTAP_TAPCELL_ROW_86_1226 VGND VPWR sky130_fd_sc_hd__tapvpwrvgnd_1
XTAP_TAPCELL_ROW_28_556 VGND VPWR sky130_fd_sc_hd__tapvpwrvgnd_1
XTAP_TAPCELL_ROW_56_876 VGND VPWR sky130_fd_sc_hd__tapvpwrvgnd_1
XFILLER_0_95_553 VGND VGND VPWR VPWR sky130_fd_sc_hd__decap_6
XFILLER_0_55_406 VGND VGND VPWR VPWR sky130_fd_sc_hd__fill_1
XFILLER_0_95_597 VPWR VGND VPWR VGND sky130_ef_sc_hd__decap_12
XFILLER_0_36_631 VPWR VGND VPWR VGND sky130_ef_sc_hd__decap_12
XFILLER_0_63_461 VPWR VGND VPWR VGND sky130_ef_sc_hd__decap_12
XTAP_TAPCELL_ROW_97_1355 VGND VPWR sky130_fd_sc_hd__tapvpwrvgnd_1
XFILLER_0_50_111 VGND VGND VPWR VPWR sky130_fd_sc_hd__decap_4
XFILLER_0_50_155 VPWR VGND VPWR VGND sky130_ef_sc_hd__decap_12
XFILLER_0_31_380 VGND VGND VPWR VPWR sky130_fd_sc_hd__fill_1
XFILLER_0_92_27 VGND VGND VPWR VPWR sky130_fd_sc_hd__fill_1
XTAP_TAPCELL_ROW_106_1451 VGND VPWR sky130_fd_sc_hd__tapvpwrvgnd_1
XFILLER_0_25_65 VGND VGND VPWR VPWR sky130_fd_sc_hd__fill_1
X_4970_ _0143_ _0145_ _0144_ VGND VGND VPWR VPWR _0248_ sky130_fd_sc_hd__o21bai_1
X_3921_ _0856_ _0878_ VGND VGND VPWR VPWR _0889_ sky130_fd_sc_hd__or2_1
XFILLER_0_58_244 VGND VGND VPWR VPWR sky130_fd_sc_hd__fill_1
XFILLER_0_39_480 VGND VGND VPWR VPWR sky130_fd_sc_hd__decap_4
X_6640_ _2067_ _2068_ _2070_ VGND VGND VPWR VPWR _2071_ sky130_fd_sc_hd__nand3_1
X_3852_ net17 VGND VGND VPWR VPWR _0137_ sky130_fd_sc_hd__clkbuf_4
X_6571_ _0584_ _1096_ _1995_ VGND VGND VPWR VPWR _1996_ sky130_fd_sc_hd__a21oi_1
XFILLER_0_73_269 VGND VGND VPWR VPWR sky130_fd_sc_hd__decap_8
X_5522_ _0847_ _0848_ _0849_ VGND VGND VPWR VPWR _0850_ sky130_fd_sc_hd__or3b_1
XFILLER_0_41_97 VPWR VGND VPWR VGND sky130_ef_sc_hd__decap_12
XFILLER_0_42_601 VPWR VGND VPWR VGND sky130_ef_sc_hd__decap_12
XFILLER_0_42_645 VGND VGND VPWR VPWR sky130_fd_sc_hd__decap_3
X_5453_ _0752_ _0773_ VGND VGND VPWR VPWR _0774_ sky130_fd_sc_hd__xnor2_1
X_4404_ _3403_ _3506_ _3507_ _3511_ _3513_ VGND VGND VPWR VPWR _3514_ sky130_fd_sc_hd__a311o_1
X_5384_ _0579_ _0577_ _0697_ _0698_ VGND VGND VPWR VPWR _0699_ sky130_fd_sc_hd__a211oi_4
X_4335_ _3430_ _3445_ _3394_ VGND VGND VPWR VPWR _3446_ sky130_fd_sc_hd__mux2_1
XFILLER_0_10_553 VGND VGND VPWR VPWR sky130_fd_sc_hd__fill_1
X_7123_ _2382_ _2384_ _2597_ VGND VGND VPWR VPWR _2599_ sky130_fd_sc_hd__and3_1
XTAP_TAPCELL_ROW_70_1038 VGND VPWR sky130_fd_sc_hd__tapvpwrvgnd_1
X_4266_ _3375_ _3377_ _3313_ VGND VGND VPWR VPWR _3378_ sky130_fd_sc_hd__mux2_1
X_7054_ _1741_ _0998_ VGND VGND VPWR VPWR _2523_ sky130_fd_sc_hd__nand2_1
X_4197_ _3308_ VGND VGND VPWR VPWR _3309_ sky130_fd_sc_hd__buf_4
X_6005_ _3376_ _1304_ _1184_ _1217_ VGND VGND VPWR VPWR _1377_ sky130_fd_sc_hd__o211a_1
XFILLER_0_66_94 VGND VGND VPWR VPWR sky130_fd_sc_hd__decap_6
XFILLER_0_96_317 VPWR VGND VPWR VGND sky130_ef_sc_hd__decap_12
XFILLER_0_49_200 VPWR VGND VPWR VGND sky130_ef_sc_hd__decap_12
XTAP_TAPCELL_ROW_25_526 VGND VPWR sky130_fd_sc_hd__tapvpwrvgnd_1
X_6907_ _2359_ _2360_ _2203_ _2329_ VGND VGND VPWR VPWR _2362_ sky130_fd_sc_hd__o211a_1
XTAP_TAPCELL_ROW_53_846 VGND VPWR sky130_fd_sc_hd__tapvpwrvgnd_1
XTAP_TAPCELL_ROW_81_1167 VGND VPWR sky130_fd_sc_hd__tapvpwrvgnd_1
XFILLER_0_77_597 VPWR VGND VPWR VGND sky130_ef_sc_hd__decap_12
XFILLER_0_9_330 VGND VGND VPWR VPWR sky130_fd_sc_hd__decap_6
X_6838_ net106 _2285_ _2120_ net153 VGND VGND VPWR VPWR _2287_ sky130_fd_sc_hd__o211a_1
XFILLER_0_49_277 VGND VGND VPWR VPWR sky130_fd_sc_hd__decap_3
XFILLER_0_64_247 VGND VGND VPWR VPWR sky130_fd_sc_hd__fill_2
XFILLER_0_17_130 VPWR VGND VPWR VGND sky130_ef_sc_hd__decap_12
XFILLER_0_92_589 VPWR VGND VPWR VGND sky130_ef_sc_hd__decap_12
XFILLER_0_45_461 VPWR VGND VPWR VGND sky130_ef_sc_hd__decap_12
X_6769_ _2209_ _2210_ VGND VGND VPWR VPWR _2212_ sky130_fd_sc_hd__xnor2_1
XFILLER_0_5_580 VPWR VGND VPWR VGND sky130_ef_sc_hd__decap_12
XFILLER_0_103_555 VGND VGND VPWR VPWR sky130_fd_sc_hd__decap_4
XFILLER_0_32_177 VGND VGND VPWR VPWR sky130_fd_sc_hd__fill_1
XFILLER_0_13_391 VGND VGND VPWR VPWR sky130_fd_sc_hd__fill_1
XTAP_TAPCELL_ROW_92_1296 VGND VPWR sky130_fd_sc_hd__tapvpwrvgnd_1
XFILLER_0_99_111 VGND VGND VPWR VPWR sky130_fd_sc_hd__fill_1
XTAP_TAPCELL_ROW_5_295 VGND VPWR sky130_fd_sc_hd__tapvpwrvgnd_1
XFILLER_0_99_166 VGND VGND VPWR VPWR sky130_fd_sc_hd__fill_2
XFILLER_0_55_225 VGND VGND VPWR VPWR sky130_fd_sc_hd__decap_3
XFILLER_0_83_545 VPWR VGND VPWR VGND sky130_ef_sc_hd__decap_12
XFILLER_0_70_217 VGND VGND VPWR VPWR sky130_fd_sc_hd__decap_8
XFILLER_0_24_645 VGND VGND VPWR VPWR sky130_fd_sc_hd__decap_6
XFILLER_0_51_431 VGND VGND VPWR VPWR sky130_fd_sc_hd__decap_4
XFILLER_0_11_328 VGND VGND VPWR VPWR sky130_fd_sc_hd__fill_2
X_4120_ net32 VGND VGND VPWR VPWR _3064_ sky130_fd_sc_hd__buf_8
X_4051_ _0944_ VGND VGND VPWR VPWR _2310_ sky130_fd_sc_hd__inv_2
Xinput5 A[14] VGND VGND VPWR VPWR net5 sky130_fd_sc_hd__buf_2
XFILLER_0_78_306 VGND VGND VPWR VPWR sky130_fd_sc_hd__fill_2
XFILLER_0_93_309 VGND VGND VPWR VPWR sky130_fd_sc_hd__fill_2
XFILLER_0_86_350 VGND VGND VPWR VPWR sky130_fd_sc_hd__decap_4
XFILLER_0_59_553 VGND VGND VPWR VPWR sky130_fd_sc_hd__decap_6
X_4953_ _0226_ _0227_ _0225_ VGND VGND VPWR VPWR _0229_ sky130_fd_sc_hd__a21bo_1
XFILLER_0_52_41 VGND VGND VPWR VPWR sky130_fd_sc_hd__decap_4
XFILLER_0_74_512 VGND VGND VPWR VPWR sky130_fd_sc_hd__fill_1
X_7672_ _3014_ _3037_ _3036_ VGND VGND VPWR VPWR _3200_ sky130_fd_sc_hd__o21ba_1
XFILLER_0_19_417 VGND VGND VPWR VPWR sky130_fd_sc_hd__decap_8
X_3904_ _0693_ VGND VGND VPWR VPWR _0704_ sky130_fd_sc_hd__clkbuf_4
XTAP_TAPCELL_ROW_50_816 VGND VPWR sky130_fd_sc_hd__tapvpwrvgnd_1
XFILLER_0_52_74 VGND VGND VPWR VPWR sky130_fd_sc_hd__decap_8
XFILLER_0_74_567 VPWR VGND VPWR VGND sky130_ef_sc_hd__decap_12
X_6623_ _2049_ _2050_ _2042_ VGND VGND VPWR VPWR _2052_ sky130_fd_sc_hd__a21o_1
X_4884_ _0052_ _0060_ _0059_ VGND VGND VPWR VPWR _0154_ sky130_fd_sc_hd__a21bo_1
XFILLER_0_52_85 VGND VGND VPWR VPWR sky130_fd_sc_hd__decap_6
XFILLER_0_74_589 VPWR VGND VPWR VGND sky130_ef_sc_hd__decap_12
X_6554_ _3283_ _2331_ VGND VGND VPWR VPWR _1977_ sky130_fd_sc_hd__and2b_1
XFILLER_0_6_377 VGND VGND VPWR VPWR sky130_fd_sc_hd__fill_1
XFILLER_0_27_494 VGND VGND VPWR VPWR sky130_fd_sc_hd__decap_8
X_5505_ _0829_ _0510_ _0830_ VGND VGND VPWR VPWR _0831_ sky130_fd_sc_hd__a21o_1
X_6485_ _1898_ _1899_ _1900_ VGND VGND VPWR VPWR _1901_ sky130_fd_sc_hd__nand3_2
XTAP_TAPCELL_ROW_30_584 VGND VPWR sky130_fd_sc_hd__tapvpwrvgnd_1
X_5436_ _3119_ _3692_ _0634_ _3253_ VGND VGND VPWR VPWR _0755_ sky130_fd_sc_hd__and4_1
XFILLER_0_42_475 VGND VGND VPWR VPWR sky130_fd_sc_hd__fill_1
XFILLER_0_77_82 VPWR VGND VPWR VGND sky130_ef_sc_hd__decap_12
XFILLER_0_10_350 VGND VGND VPWR VPWR sky130_fd_sc_hd__fill_1
X_5367_ _0677_ _0678_ _0679_ VGND VGND VPWR VPWR _0680_ sky130_fd_sc_hd__nand3_1
X_4318_ _3427_ _3428_ _3312_ VGND VGND VPWR VPWR _3429_ sky130_fd_sc_hd__mux2_1
X_5298_ _1479_ _3316_ _3360_ VGND VGND VPWR VPWR _0605_ sky130_fd_sc_hd__mux2_1
X_7106_ _2414_ _2420_ VGND VGND VPWR VPWR _2580_ sky130_fd_sc_hd__or2b_1
X_4249_ net63 net64 VGND VGND VPWR VPWR _3361_ sky130_fd_sc_hd__nand2_1
X_7037_ _2502_ _2503_ VGND VGND VPWR VPWR _2504_ sky130_fd_sc_hd__xnor2_1
XTAP_TAPCELL_ROW_58_905 VGND VPWR sky130_fd_sc_hd__tapvpwrvgnd_1
XFILLER_0_97_604 VPWR VGND VPWR VGND sky130_ef_sc_hd__decap_12
XFILLER_0_93_70 VPWR VGND VPWR VGND sky130_ef_sc_hd__decap_12
XTAP_TAPCELL_ROW_2_254 VGND VPWR sky130_fd_sc_hd__tapvpwrvgnd_1
XTAP_TAPCELL_ROW_2_265 VGND VPWR sky130_fd_sc_hd__tapvpwrvgnd_1
XFILLER_0_69_328 VGND VGND VPWR VPWR sky130_fd_sc_hd__decap_8
XTAP_TAPCELL_ROW_38_673 VGND VPWR sky130_fd_sc_hd__tapvpwrvgnd_1
XFILLER_0_96_169 VGND VGND VPWR VPWR sky130_fd_sc_hd__fill_1
XFILLER_0_84_309 VGND VGND VPWR VPWR sky130_fd_sc_hd__decap_6
XTAP_TAPCELL_ROW_66_993 VGND VPWR sky130_fd_sc_hd__tapvpwrvgnd_1
XFILLER_0_77_383 VGND VGND VPWR VPWR sky130_fd_sc_hd__decap_8
XFILLER_0_37_225 VGND VGND VPWR VPWR sky130_fd_sc_hd__fill_2
XFILLER_0_108_625 VPWR VGND VPWR VGND sky130_ef_sc_hd__decap_12
XFILLER_0_107_113 VPWR VGND VPWR VGND sky130_ef_sc_hd__decap_12
XFILLER_0_9_193 VPWR VGND VPWR VGND sky130_ef_sc_hd__decap_12
XFILLER_0_18_461 VGND VGND VPWR VPWR sky130_fd_sc_hd__fill_1
XTAP_TAPCELL_ROW_94_1314 VGND VPWR sky130_fd_sc_hd__tapvpwrvgnd_1
XFILLER_0_103_363 VGND VGND VPWR VPWR sky130_fd_sc_hd__fill_1
XFILLER_0_87_136 VGND VGND VPWR VPWR sky130_fd_sc_hd__fill_1
XFILLER_0_87_125 VGND VGND VPWR VPWR sky130_fd_sc_hd__decap_4
XFILLER_0_87_169 VPWR VGND VPWR VGND sky130_ef_sc_hd__decap_12
XTAP_TAPCELL_ROW_103_1421 VGND VPWR sky130_fd_sc_hd__tapvpwrvgnd_1
XFILLER_0_56_589 VPWR VGND VPWR VGND sky130_ef_sc_hd__decap_12
XFILLER_0_98_15 VPWR VGND VPWR VGND sky130_ef_sc_hd__decap_12
XFILLER_0_106_190 VGND VGND VPWR VPWR sky130_fd_sc_hd__decap_6
XFILLER_0_12_637 VGND VGND VPWR VPWR sky130_fd_sc_hd__decap_6
XFILLER_0_24_497 VGND VGND VPWR VPWR sky130_fd_sc_hd__fill_1
X_6270_ _1064_ _1140_ _1356_ _1666_ VGND VGND VPWR VPWR _1667_ sky130_fd_sc_hd__a31o_1
XPHY_EDGE_ROW_102_Left_212 VGND VGND VPWR VPWR sky130_fd_sc_hd__decap_3
X_5221_ _3010_ _1402_ _1971_ _2900_ VGND VGND VPWR VPWR _0521_ sky130_fd_sc_hd__o2bb2a_1
X_5152_ _0331_ _0351_ _0352_ VGND VGND VPWR VPWR _0446_ sky130_fd_sc_hd__nand3_1
XFILLER_0_47_30 VPWR VGND VPWR VGND sky130_ef_sc_hd__decap_12
X_4103_ _2867_ VGND VGND VPWR VPWR _2878_ sky130_fd_sc_hd__buf_4
XFILLER_0_44_7 VGND VGND VPWR VPWR sky130_fd_sc_hd__decap_4
X_5083_ _0306_ _0369_ _0370_ VGND VGND VPWR VPWR _0371_ sky130_fd_sc_hd__nand3_1
X_4034_ _1479_ _1512_ _1982_ _2014_ _2113_ VGND VGND VPWR VPWR _2124_ sky130_fd_sc_hd__o221a_1
XFILLER_0_2_65 VPWR VGND VPWR VGND sky130_ef_sc_hd__decap_12
XFILLER_0_66_309 VGND VGND VPWR VPWR sky130_fd_sc_hd__fill_1
XTAP_TAPCELL_ROW_63_963 VGND VPWR sky130_fd_sc_hd__tapvpwrvgnd_1
X_5985_ _1345_ _1353_ _1354_ VGND VGND VPWR VPWR _1355_ sky130_fd_sc_hd__o21a_1
XTAP_TAPCELL_ROW_35_643 VGND VPWR sky130_fd_sc_hd__tapvpwrvgnd_1
XFILLER_0_19_225 VGND VGND VPWR VPWR sky130_fd_sc_hd__fill_1
X_4936_ _3010_ _3163_ _1807_ _1621_ VGND VGND VPWR VPWR _0210_ sky130_fd_sc_hd__and4_1
X_7655_ _3325_ _0159_ VGND VGND VPWR VPWR _3181_ sky130_fd_sc_hd__nand2_1
XFILLER_0_62_515 VPWR VGND VPWR VGND sky130_ef_sc_hd__decap_12
X_4867_ _0133_ _0134_ VGND VGND VPWR VPWR _0135_ sky130_fd_sc_hd__xnor2_1
XANTENNA_10 _3518_ VGND VGND VPWR VPWR sky130_fd_sc_hd__diode_2
X_7586_ _3101_ _3104_ VGND VGND VPWR VPWR _3105_ sky130_fd_sc_hd__xnor2_1
XFILLER_0_105_617 VPWR VGND VPWR VGND sky130_ef_sc_hd__decap_12
XFILLER_0_62_537 VGND VGND VPWR VPWR sky130_fd_sc_hd__fill_1
XFILLER_0_6_141 VPWR VGND VPWR VGND sky130_ef_sc_hd__decap_12
X_6606_ _2671_ _1020_ VGND VGND VPWR VPWR _2033_ sky130_fd_sc_hd__nand2_1
X_6537_ _1680_ _1956_ _1957_ VGND VGND VPWR VPWR _1958_ sky130_fd_sc_hd__nor3_1
X_4798_ _0056_ _0057_ _0058_ VGND VGND VPWR VPWR _0060_ sky130_fd_sc_hd__a21o_1
XFILLER_0_30_401 VPWR VGND VPWR VGND sky130_ef_sc_hd__decap_12
XFILLER_0_42_272 VPWR VGND VPWR VGND sky130_ef_sc_hd__decap_12
X_6468_ _1879_ _1880_ _1746_ _1748_ VGND VGND VPWR VPWR _1882_ sky130_fd_sc_hd__o211a_1
XTAP_TAPCELL_ROW_7_313 VGND VPWR sky130_fd_sc_hd__tapvpwrvgnd_1
XFILLER_0_2_380 VPWR VGND VPWR VGND sky130_ef_sc_hd__decap_12
XFILLER_0_30_489 VPWR VGND VPWR VGND sky130_ef_sc_hd__decap_12
X_5419_ _3332_ _1501_ _0636_ _0635_ VGND VGND VPWR VPWR _0737_ sky130_fd_sc_hd__a31o_1
X_6399_ _1806_ _1805_ _1672_ VGND VGND VPWR VPWR _1808_ sky130_fd_sc_hd__and3_1
XFILLER_0_100_377 VGND VGND VPWR VPWR sky130_fd_sc_hd__decap_6
XFILLER_0_100_344 VGND VGND VPWR VPWR sky130_fd_sc_hd__decap_6
XFILLER_0_97_478 VGND VGND VPWR VPWR sky130_fd_sc_hd__decap_3
XFILLER_0_97_445 VGND VGND VPWR VPWR sky130_fd_sc_hd__decap_3
XFILLER_0_69_169 VGND VGND VPWR VPWR sky130_fd_sc_hd__decap_3
XFILLER_0_92_150 VPWR VGND VPWR VGND sky130_ef_sc_hd__decap_12
XFILLER_0_80_301 VGND VGND VPWR VPWR sky130_fd_sc_hd__decap_6
XFILLER_0_108_477 VPWR VGND VPWR VGND sky130_ef_sc_hd__decap_12
XFILLER_0_92_194 VGND VGND VPWR VPWR sky130_fd_sc_hd__fill_2
XFILLER_0_25_239 VPWR VGND VPWR VGND sky130_ef_sc_hd__decap_12
XFILLER_0_53_559 VGND VGND VPWR VPWR sky130_fd_sc_hd__fill_1
XFILLER_0_61_581 VGND VGND VPWR VPWR sky130_fd_sc_hd__decap_3
XFILLER_0_17_77 VPWR VGND VPWR VGND sky130_ef_sc_hd__decap_12
XFILLER_0_84_640 VGND VGND VPWR VPWR sky130_fd_sc_hd__decap_4
XTAP_TAPCELL_ROW_60_922 VGND VPWR sky130_fd_sc_hd__tapvpwrvgnd_1
XTAP_TAPCELL_ROW_32_602 VGND VPWR sky130_fd_sc_hd__tapvpwrvgnd_1
X_5770_ _3692_ _2069_ _0693_ _3119_ VGND VGND VPWR VPWR _1120_ sky130_fd_sc_hd__a22oi_1
XFILLER_0_90_109 VPWR VGND VPWR VGND sky130_ef_sc_hd__decap_12
XFILLER_0_84_651 VGND VGND VPWR VPWR sky130_fd_sc_hd__fill_1
X_4721_ _3822_ _3823_ _3821_ VGND VGND VPWR VPWR _3825_ sky130_fd_sc_hd__o21ai_1
X_7440_ _2943_ _2923_ VGND VGND VPWR VPWR _2946_ sky130_fd_sc_hd__and2b_1
X_4652_ _3611_ _3746_ _3756_ VGND VGND VPWR VPWR _3757_ sky130_fd_sc_hd__o21ai_1
XFILLER_0_4_601 VPWR VGND VPWR VGND sky130_ef_sc_hd__decap_12
XFILLER_0_44_537 VGND VGND VPWR VPWR sky130_fd_sc_hd__fill_1
XTAP_TAPCELL_ROW_12_370 VGND VPWR sky130_fd_sc_hd__tapvpwrvgnd_1
Xinput30 A[8] VGND VGND VPWR VPWR net30 sky130_fd_sc_hd__clkbuf_2
Xinput52 B[29] VGND VGND VPWR VPWR net52 sky130_fd_sc_hd__buf_1
Xinput63 opcode[0] VGND VGND VPWR VPWR net63 sky130_fd_sc_hd__buf_2
X_7371_ _1088_ _0609_ _0612_ _2869_ VGND VGND VPWR VPWR _2870_ sky130_fd_sc_hd__a22o_1
X_4583_ _3687_ _3688_ VGND VGND VPWR VPWR _3689_ sky130_fd_sc_hd__xor2_1
XFILLER_0_4_645 VGND VGND VPWR VPWR sky130_fd_sc_hd__decap_6
Xinput41 B[19] VGND VGND VPWR VPWR net41 sky130_fd_sc_hd__clkbuf_2
XFILLER_0_12_445 VGND VGND VPWR VPWR sky130_fd_sc_hd__decap_4
X_6322_ _1558_ _1683_ _1721_ _1722_ VGND VGND VPWR VPWR _1723_ sky130_fd_sc_hd__a211oi_1
X_6253_ _1386_ _1384_ _1500_ VGND VGND VPWR VPWR _1648_ sky130_fd_sc_hd__o21a_1
X_5204_ _0278_ _0299_ _0301_ _3258_ VGND VGND VPWR VPWR _0503_ sky130_fd_sc_hd__a31o_1
X_6184_ _3253_ _0240_ _1643_ _0634_ VGND VGND VPWR VPWR _1572_ sky130_fd_sc_hd__a22oi_1
X_5135_ _0323_ _0330_ VGND VGND VPWR VPWR _0427_ sky130_fd_sc_hd__and2_1
XFILLER_0_35_3 VGND VGND VPWR VPWR sky130_fd_sc_hd__decap_4
X_5066_ _0348_ _0349_ _0350_ VGND VGND VPWR VPWR _0352_ sky130_fd_sc_hd__a21o_1
XFILLER_0_74_72 VPWR VGND VPWR VGND sky130_ef_sc_hd__decap_12
X_4017_ _1927_ VGND VGND VPWR VPWR _1938_ sky130_fd_sc_hd__buf_6
XFILLER_0_79_445 VGND VGND VPWR VPWR sky130_fd_sc_hd__decap_3
XFILLER_0_67_607 VGND VGND VPWR VPWR sky130_fd_sc_hd__decap_8
XTAP_TAPCELL_ROW_48_790 VGND VPWR sky130_fd_sc_hd__tapvpwrvgnd_1
XFILLER_0_94_415 VGND VGND VPWR VPWR sky130_fd_sc_hd__decap_4
X_5968_ _1197_ _1199_ _1334_ _1335_ VGND VGND VPWR VPWR _1336_ sky130_fd_sc_hd__a211oi_2
X_7707_ net90 net92 net93 net102 VGND VGND VPWR VPWR net101 sky130_fd_sc_hd__nor4b_4
X_4919_ _3470_ _3488_ _3343_ VGND VGND VPWR VPWR _0193_ sky130_fd_sc_hd__mux2_1
XFILLER_0_81_109 VGND VGND VPWR VPWR sky130_fd_sc_hd__decap_3
X_5899_ _1248_ _1250_ _1259_ VGND VGND VPWR VPWR _1261_ sky130_fd_sc_hd__a21oi_2
X_7638_ _2983_ _2985_ VGND VGND VPWR VPWR _3162_ sky130_fd_sc_hd__nor2_1
XFILLER_0_62_345 VPWR VGND VPWR VGND sky130_ef_sc_hd__decap_12
XFILLER_0_35_559 VGND VGND VPWR VPWR sky130_fd_sc_hd__fill_1
XFILLER_0_50_507 VGND VGND VPWR VPWR sky130_fd_sc_hd__decap_8
X_7569_ _3076_ _3085_ VGND VGND VPWR VPWR _3087_ sky130_fd_sc_hd__xnor2_1
XFILLER_0_99_91 VPWR VGND VPWR VGND sky130_ef_sc_hd__decap_12
XTAP_TAPCELL_ROW_78_1139 VGND VPWR sky130_fd_sc_hd__tapvpwrvgnd_1
XTAP_TAPCELL_ROW_78_1128 VGND VPWR sky130_fd_sc_hd__tapvpwrvgnd_1
XFILLER_0_15_261 VGND VGND VPWR VPWR sky130_fd_sc_hd__decap_3
XFILLER_0_100_141 VGND VGND VPWR VPWR sky130_fd_sc_hd__decap_3
XFILLER_0_100_174 VPWR VGND VPWR VGND sky130_ef_sc_hd__decap_12
XTAP_TAPCELL_ROW_89_1257 VGND VPWR sky130_fd_sc_hd__tapvpwrvgnd_1
XFILLER_0_58_618 VPWR VGND VPWR VGND sky130_ef_sc_hd__decap_12
XFILLER_0_57_117 VGND VGND VPWR VPWR sky130_fd_sc_hd__decap_6
XFILLER_0_26_515 VGND VGND VPWR VPWR sky130_fd_sc_hd__fill_1
XFILLER_0_26_526 VGND VGND VPWR VPWR sky130_fd_sc_hd__decap_6
XFILLER_0_80_186 VGND VGND VPWR VPWR sky130_fd_sc_hd__decap_3
XFILLER_0_41_518 VGND VGND VPWR VPWR sky130_fd_sc_hd__fill_1
XFILLER_0_53_389 VGND VGND VPWR VPWR sky130_fd_sc_hd__decap_3
XFILLER_0_1_604 VPWR VGND VPWR VGND sky130_ef_sc_hd__decap_12
XFILLER_0_21_220 VGND VGND VPWR VPWR sky130_fd_sc_hd__decap_4
XFILLER_0_0_125 VPWR VGND VPWR VGND sky130_ef_sc_hd__decap_12
XFILLER_0_0_169 VGND VGND VPWR VPWR sky130_fd_sc_hd__decap_3
XFILLER_0_0_158 VGND VGND VPWR VPWR sky130_fd_sc_hd__decap_8
XFILLER_0_21_297 VPWR VGND VPWR VGND sky130_ef_sc_hd__decap_12
X_6940_ _2396_ _2398_ VGND VGND VPWR VPWR _2399_ sky130_fd_sc_hd__xnor2_1
XTAP_TAPCELL_ROW_109_1493 VGND VPWR sky130_fd_sc_hd__tapvpwrvgnd_1
XFILLER_0_49_629 VPWR VGND VPWR VGND sky130_ef_sc_hd__decap_12
X_6871_ _2133_ _2297_ VGND VGND VPWR VPWR _2323_ sky130_fd_sc_hd__or2b_1
X_5822_ net7 net53 net8 net56 VGND VGND VPWR VPWR _1177_ sky130_fd_sc_hd__and4_1
XFILLER_0_29_320 VPWR VGND VPWR VGND sky130_ef_sc_hd__decap_12
XFILLER_0_48_128 VPWR VGND VPWR VGND sky130_ef_sc_hd__decap_12
X_5753_ _0977_ _1077_ _1078_ _1101_ VGND VGND VPWR VPWR net78 sky130_fd_sc_hd__a31o_1
XFILLER_0_57_651 VGND VGND VPWR VPWR sky130_fd_sc_hd__fill_1
XFILLER_0_44_323 VGND VGND VPWR VPWR sky130_fd_sc_hd__decap_3
X_4704_ _3524_ _2703_ _3774_ _3773_ VGND VGND VPWR VPWR _3808_ sky130_fd_sc_hd__a31o_1
XFILLER_0_72_643 VGND VGND VPWR VPWR sky130_fd_sc_hd__fill_1
XFILLER_0_60_85 VGND VGND VPWR VPWR sky130_fd_sc_hd__fill_1
X_5684_ _0885_ _0887_ _0886_ VGND VGND VPWR VPWR _1026_ sky130_fd_sc_hd__o21ba_1
X_4635_ _3679_ _3739_ VGND VGND VPWR VPWR _3740_ sky130_fd_sc_hd__nor2_1
XFILLER_0_71_175 VGND VGND VPWR VPWR sky130_fd_sc_hd__decap_8
XFILLER_0_71_164 VGND VGND VPWR VPWR sky130_fd_sc_hd__decap_4
X_7423_ _1173_ _2925_ _2926_ VGND VGND VPWR VPWR _2927_ sky130_fd_sc_hd__a21bo_1
X_4566_ _3667_ _3671_ _3672_ _3611_ VGND VGND VPWR VPWR _3673_ sky130_fd_sc_hd__o22a_1
X_7354_ _2498_ _2653_ _2850_ _2851_ VGND VGND VPWR VPWR _2852_ sky130_fd_sc_hd__a211oi_1
XFILLER_0_8_53 VPWR VGND VPWR VGND sky130_ef_sc_hd__decap_12
XFILLER_0_69_83 VGND VGND VPWR VPWR sky130_fd_sc_hd__fill_2
XFILLER_0_8_97 VGND VGND VPWR VPWR sky130_fd_sc_hd__fill_1
X_6305_ _2671_ _0791_ _1552_ _1551_ VGND VGND VPWR VPWR _1704_ sky130_fd_sc_hd__a31o_1
X_4497_ _3228_ _3604_ VGND VGND VPWR VPWR _3605_ sky130_fd_sc_hd__nand2_1
X_7285_ _2582_ _2590_ VGND VGND VPWR VPWR _2776_ sky130_fd_sc_hd__nand2_1
X_6236_ _1484_ _1567_ _1627_ _1628_ VGND VGND VPWR VPWR _1629_ sky130_fd_sc_hd__o211a_1
XFILLER_0_85_71 VGND VGND VPWR VPWR sky130_fd_sc_hd__decap_8
X_6167_ _3621_ _0791_ VGND VGND VPWR VPWR _1553_ sky130_fd_sc_hd__nand2_1
XFILLER_0_99_518 VGND VGND VPWR VPWR sky130_fd_sc_hd__fill_1
X_5118_ _3374_ _0403_ _0407_ VGND VGND VPWR VPWR _0408_ sky130_fd_sc_hd__a21boi_1
X_6098_ _1319_ _1310_ _1318_ VGND VGND VPWR VPWR _1478_ sky130_fd_sc_hd__a21bo_1
XFILLER_0_79_220 VGND VGND VPWR VPWR sky130_fd_sc_hd__decap_4
X_5049_ _3772_ _0332_ VGND VGND VPWR VPWR _0334_ sky130_fd_sc_hd__nand2_1
XFILLER_0_79_275 VGND VGND VPWR VPWR sky130_fd_sc_hd__decap_4
XFILLER_0_94_267 VPWR VGND VPWR VGND sky130_ef_sc_hd__decap_12
XTAP_TAPCELL_ROW_84_1198 VGND VPWR sky130_fd_sc_hd__tapvpwrvgnd_1
XFILLER_0_48_651 VGND VGND VPWR VPWR sky130_fd_sc_hd__fill_1
XFILLER_0_35_312 VGND VGND VPWR VPWR sky130_fd_sc_hd__fill_2
Xclone22 net53 VGND VGND VPWR VPWR net140 sky130_fd_sc_hd__clkbuf_16
Xclone11 net30 VGND VGND VPWR VPWR net129 sky130_fd_sc_hd__buf_2
XTAP_TAPCELL_ROW_23_498 VGND VPWR sky130_fd_sc_hd__tapvpwrvgnd_1
XFILLER_0_105_222 VGND VGND VPWR VPWR sky130_fd_sc_hd__fill_2
XFILLER_0_35_367 VPWR VGND VPWR VGND sky130_ef_sc_hd__decap_12
XFILLER_0_31_540 VPWR VGND VPWR VGND sky130_ef_sc_hd__decap_12
XFILLER_0_31_595 VGND VGND VPWR VPWR sky130_fd_sc_hd__decap_8
XFILLER_0_58_415 VGND VGND VPWR VPWR sky130_fd_sc_hd__fill_1
XFILLER_0_85_223 VGND VGND VPWR VPWR sky130_fd_sc_hd__fill_1
XFILLER_0_105_69 VPWR VGND VPWR VGND sky130_ef_sc_hd__decap_12
XFILLER_0_109_583 VGND VGND VPWR VPWR sky130_fd_sc_hd__decap_4
XFILLER_0_30_11 VGND VGND VPWR VPWR sky130_fd_sc_hd__decap_3
XFILLER_0_38_183 VGND VGND VPWR VPWR sky130_fd_sc_hd__fill_2
XFILLER_0_53_142 VPWR VGND VPWR VGND sky130_ef_sc_hd__decap_12
XFILLER_0_54_643 VGND VGND VPWR VPWR sky130_fd_sc_hd__fill_1
XFILLER_0_81_473 VPWR VGND VPWR VGND sky130_ef_sc_hd__decap_12
XFILLER_0_53_175 VGND VGND VPWR VPWR sky130_fd_sc_hd__fill_1
X_4420_ _3496_ _3528_ VGND VGND VPWR VPWR _3529_ sky130_fd_sc_hd__and2_4
XFILLER_0_1_401 VGND VGND VPWR VPWR sky130_fd_sc_hd__decap_4
XFILLER_0_53_197 VGND VGND VPWR VPWR sky130_fd_sc_hd__decap_3
X_4351_ _3421_ _3442_ _3461_ VGND VGND VPWR VPWR _3462_ sky130_fd_sc_hd__or3_1
X_4282_ _2878_ VGND VGND VPWR VPWR _3394_ sky130_fd_sc_hd__clkbuf_4
X_7070_ _2538_ _2540_ VGND VGND VPWR VPWR _2541_ sky130_fd_sc_hd__nor2_1
X_6021_ _1247_ _1261_ _1262_ VGND VGND VPWR VPWR _1394_ sky130_fd_sc_hd__or3_1
X_6923_ _2378_ _2379_ VGND VGND VPWR VPWR _2380_ sky130_fd_sc_hd__xnor2_1
X_6854_ _2302_ _2304_ _0506_ VGND VGND VPWR VPWR _2305_ sky130_fd_sc_hd__o21ai_1
X_3997_ net61 VGND VGND VPWR VPWR _1719_ sky130_fd_sc_hd__clkbuf_4
X_5805_ _1155_ _1156_ _1137_ _1138_ VGND VGND VPWR VPWR _1158_ sky130_fd_sc_hd__a211oi_2
X_6785_ _1796_ _1610_ _0758_ _0660_ VGND VGND VPWR VPWR _2229_ sky130_fd_sc_hd__and4_1
XFILLER_0_91_259 VGND VGND VPWR VPWR sky130_fd_sc_hd__fill_2
X_5736_ _0839_ _1082_ _0824_ VGND VGND VPWR VPWR _1083_ sky130_fd_sc_hd__a21o_1
XFILLER_0_60_624 VGND VGND VPWR VPWR sky130_fd_sc_hd__decap_6
XFILLER_0_17_389 VGND VGND VPWR VPWR sky130_fd_sc_hd__decap_3
X_5667_ _3777_ _2660_ _1402_ _3253_ VGND VGND VPWR VPWR _1007_ sky130_fd_sc_hd__and4_1
XFILLER_0_44_164 VPWR VGND VPWR VGND sky130_ef_sc_hd__decap_12
X_4618_ _3469_ _3464_ _3320_ VGND VGND VPWR VPWR _3724_ sky130_fd_sc_hd__mux2_1
X_7406_ _1752_ _0856_ VGND VGND VPWR VPWR _2908_ sky130_fd_sc_hd__nand2_1
XTAP_TAPCELL_ROW_20_468 VGND VPWR sky130_fd_sc_hd__tapvpwrvgnd_1
XFILLER_0_44_197 VPWR VGND VPWR VGND sky130_ef_sc_hd__decap_12
XFILLER_0_102_236 VPWR VGND VPWR VGND sky130_ef_sc_hd__decap_12
X_5598_ _0921_ _0931_ VGND VGND VPWR VPWR _0932_ sky130_fd_sc_hd__xnor2_1
X_4549_ _2824_ _3654_ VGND VGND VPWR VPWR _3656_ sky130_fd_sc_hd__or2_1
X_7337_ _2625_ _2628_ _2831_ VGND VGND VPWR VPWR _2833_ sky130_fd_sc_hd__nor3_1
XFILLER_0_96_70 VGND VGND VPWR VPWR sky130_fd_sc_hd__decap_6
X_7268_ _2592_ VGND VGND VPWR VPWR _2757_ sky130_fd_sc_hd__inv_2
X_6219_ net132 _1097_ VGND VGND VPWR VPWR _1611_ sky130_fd_sc_hd__nand2_1
X_7199_ _2678_ _2679_ _2680_ VGND VGND VPWR VPWR _2682_ sky130_fd_sc_hd__a21o_1
XFILLER_0_99_337 VGND VGND VPWR VPWR sky130_fd_sc_hd__decap_8
XTAP_TAPCELL_ROW_86_1227 VGND VPWR sky130_fd_sc_hd__tapvpwrvgnd_1
XTAP_TAPCELL_ROW_28_557 VGND VPWR sky130_fd_sc_hd__tapvpwrvgnd_1
XTAP_TAPCELL_ROW_56_877 VGND VPWR sky130_fd_sc_hd__tapvpwrvgnd_1
XFILLER_0_36_643 VGND VGND VPWR VPWR sky130_fd_sc_hd__fill_1
XFILLER_0_63_473 VPWR VGND VPWR VGND sky130_ef_sc_hd__decap_12
XFILLER_0_51_613 VGND VGND VPWR VPWR sky130_fd_sc_hd__decap_3
XTAP_TAPCELL_ROW_97_1356 VGND VPWR sky130_fd_sc_hd__tapvpwrvgnd_1
XFILLER_0_90_281 VGND VGND VPWR VPWR sky130_fd_sc_hd__decap_3
XFILLER_0_23_337 VPWR VGND VPWR VGND sky130_ef_sc_hd__decap_12
XFILLER_0_50_123 VGND VGND VPWR VPWR sky130_fd_sc_hd__decap_8
XFILLER_0_50_145 VGND VGND VPWR VPWR sky130_fd_sc_hd__decap_3
XFILLER_0_50_167 VPWR VGND VPWR VGND sky130_ef_sc_hd__decap_12
XTAP_TAPCELL_ROW_106_1452 VGND VPWR sky130_fd_sc_hd__tapvpwrvgnd_1
X_3920_ _0867_ VGND VGND VPWR VPWR _0878_ sky130_fd_sc_hd__buf_2
X_3851_ _0116_ VGND VGND VPWR VPWR _0126_ sky130_fd_sc_hd__inv_2
X_6570_ _0595_ _1094_ _1994_ VGND VGND VPWR VPWR _1995_ sky130_fd_sc_hd__o21ai_1
XFILLER_0_41_65 VGND VGND VPWR VPWR sky130_fd_sc_hd__fill_2
X_5521_ _0682_ _3358_ _3747_ _0726_ VGND VGND VPWR VPWR _0849_ sky130_fd_sc_hd__o22a_1
XFILLER_0_41_76 VGND VGND VPWR VPWR sky130_fd_sc_hd__decap_6
XFILLER_0_42_613 VPWR VGND VPWR VGND sky130_ef_sc_hd__decap_12
XFILLER_0_81_281 VPWR VGND VPWR VGND sky130_ef_sc_hd__decap_12
XFILLER_0_81_270 VGND VGND VPWR VPWR sky130_fd_sc_hd__decap_8
XFILLER_0_26_197 VGND VGND VPWR VPWR sky130_fd_sc_hd__decap_4
XFILLER_0_74_7 VPWR VGND VPWR VGND sky130_ef_sc_hd__decap_12
X_5452_ _0771_ _0772_ VGND VGND VPWR VPWR _0773_ sky130_fd_sc_hd__nand2_1
X_4403_ _3335_ _3357_ _3512_ _3509_ VGND VGND VPWR VPWR _3513_ sky130_fd_sc_hd__a2bb2o_1
X_5383_ _0695_ _0696_ _0626_ VGND VGND VPWR VPWR _0698_ sky130_fd_sc_hd__a21oi_1
X_4334_ _3321_ _3444_ _3437_ VGND VGND VPWR VPWR _3445_ sky130_fd_sc_hd__a21o_1
X_7122_ _2382_ _2384_ _2597_ VGND VGND VPWR VPWR _2598_ sky130_fd_sc_hd__a21oi_2
X_7053_ _2520_ _2521_ VGND VGND VPWR VPWR _2522_ sky130_fd_sc_hd__nor2_1
X_4265_ _1184_ _3376_ _3308_ VGND VGND VPWR VPWR _3377_ sky130_fd_sc_hd__mux2_1
X_6004_ _0718_ _0837_ _1375_ VGND VGND VPWR VPWR _1376_ sky130_fd_sc_hd__or3_1
XTAP_TAPCELL_ROW_70_1039 VGND VPWR sky130_fd_sc_hd__tapvpwrvgnd_1
XFILLER_0_10_598 VPWR VGND VPWR VGND sky130_ef_sc_hd__decap_12
X_4196_ _3307_ VGND VGND VPWR VPWR _3308_ sky130_fd_sc_hd__buf_4
XFILLER_0_96_329 VPWR VGND VPWR VGND sky130_ef_sc_hd__decap_12
XFILLER_0_89_370 VPWR VGND VPWR VGND sky130_ef_sc_hd__decap_12
XFILLER_0_82_61 VGND VGND VPWR VPWR sky130_fd_sc_hd__fill_2
XFILLER_0_49_212 VPWR VGND VPWR VGND sky130_ef_sc_hd__decap_12
XTAP_TAPCELL_ROW_25_527 VGND VPWR sky130_fd_sc_hd__tapvpwrvgnd_1
X_6906_ _2203_ _2329_ _2359_ _2360_ VGND VGND VPWR VPWR _2361_ sky130_fd_sc_hd__a211oi_1
XTAP_TAPCELL_ROW_53_847 VGND VPWR sky130_fd_sc_hd__tapvpwrvgnd_1
X_6837_ _2120_ net147 net106 _2285_ VGND VGND VPWR VPWR _2286_ sky130_fd_sc_hd__a211oi_4
XFILLER_0_107_328 VGND VGND VPWR VPWR sky130_fd_sc_hd__fill_1
XTAP_TAPCELL_ROW_81_1168 VGND VPWR sky130_fd_sc_hd__tapvpwrvgnd_1
XFILLER_0_64_259 VGND VGND VPWR VPWR sky130_fd_sc_hd__fill_1
XFILLER_0_18_643 VGND VGND VPWR VPWR sky130_fd_sc_hd__fill_1
XFILLER_0_92_579 VGND VGND VPWR VPWR sky130_fd_sc_hd__decap_8
XFILLER_0_17_142 VPWR VGND VPWR VGND sky130_ef_sc_hd__decap_12
X_6768_ _1741_ _1162_ VGND VGND VPWR VPWR _2210_ sky130_fd_sc_hd__nand2_1
XFILLER_0_45_473 VPWR VGND VPWR VGND sky130_ef_sc_hd__decap_12
XFILLER_0_60_421 VGND VGND VPWR VPWR sky130_fd_sc_hd__decap_6
X_5719_ _1001_ _1062_ _1063_ VGND VGND VPWR VPWR _1065_ sky130_fd_sc_hd__or3_4
XFILLER_0_33_624 VPWR VGND VPWR VGND sky130_ef_sc_hd__decap_12
X_6699_ _1961_ _2133_ _2134_ VGND VGND VPWR VPWR _2136_ sky130_fd_sc_hd__and3_1
XFILLER_0_5_592 VPWR VGND VPWR VGND sky130_ef_sc_hd__decap_12
XTAP_TAPCELL_ROW_92_1297 VGND VPWR sky130_fd_sc_hd__tapvpwrvgnd_1
XTAP_TAPCELL_ROW_5_296 VGND VPWR sky130_fd_sc_hd__tapvpwrvgnd_1
XFILLER_0_68_521 VGND VGND VPWR VPWR sky130_fd_sc_hd__decap_8
XFILLER_0_28_418 VGND VGND VPWR VPWR sky130_fd_sc_hd__fill_2
XFILLER_0_83_557 VGND VGND VPWR VPWR sky130_fd_sc_hd__decap_3
XFILLER_0_102_15 VPWR VGND VPWR VGND sky130_ef_sc_hd__decap_12
XTAP_TAPCELL_ROW_101_1393 VGND VPWR sky130_fd_sc_hd__tapvpwrvgnd_1
XFILLER_0_63_281 VGND VGND VPWR VPWR sky130_fd_sc_hd__decap_6
XFILLER_0_11_57 VGND VGND VPWR VPWR sky130_fd_sc_hd__decap_8
XFILLER_0_3_518 VPWR VGND VPWR VGND sky130_ef_sc_hd__decap_12
XFILLER_0_106_361 VGND VGND VPWR VPWR sky130_fd_sc_hd__decap_3
XFILLER_0_51_498 VGND VGND VPWR VPWR sky130_fd_sc_hd__decap_6
X_4050_ _2157_ _2167_ _1118_ _2288_ _1129_ VGND VGND VPWR VPWR _2299_ sky130_fd_sc_hd__o221a_1
Xinput6 A[15] VGND VGND VPWR VPWR net6 sky130_fd_sc_hd__clkbuf_2
XFILLER_0_59_565 VGND VGND VPWR VPWR sky130_fd_sc_hd__fill_1
X_4952_ _0225_ _0226_ _0227_ VGND VGND VPWR VPWR _0228_ sky130_fd_sc_hd__nand3b_1
XFILLER_0_86_373 VPWR VGND VPWR VGND sky130_ef_sc_hd__decap_12
X_7671_ _3165_ _3198_ VGND VGND VPWR VPWR _3199_ sky130_fd_sc_hd__xnor2_1
X_4883_ _0150_ _0151_ _0142_ VGND VGND VPWR VPWR _0153_ sky130_fd_sc_hd__a21o_1
X_3903_ net38 VGND VGND VPWR VPWR _0693_ sky130_fd_sc_hd__buf_2
XTAP_TAPCELL_ROW_50_806 VGND VPWR sky130_fd_sc_hd__tapvpwrvgnd_1
X_6622_ _2042_ _2049_ _2050_ VGND VGND VPWR VPWR _2051_ sky130_fd_sc_hd__nand3_2
XFILLER_0_46_259 VGND VGND VPWR VPWR sky130_fd_sc_hd__decap_8
XTAP_TAPCELL_ROW_50_817 VGND VPWR sky130_fd_sc_hd__tapvpwrvgnd_1
XFILLER_0_74_579 VGND VGND VPWR VPWR sky130_fd_sc_hd__decap_8
XFILLER_0_15_613 VGND VGND VPWR VPWR sky130_fd_sc_hd__decap_3
X_6553_ _1975_ _1974_ _3492_ VGND VGND VPWR VPWR _1976_ sky130_fd_sc_hd__and3_1
XFILLER_0_42_410 VGND VGND VPWR VPWR sky130_fd_sc_hd__fill_1
XFILLER_0_54_270 VGND VGND VPWR VPWR sky130_fd_sc_hd__fill_1
X_5504_ _0590_ _0710_ _0828_ VGND VGND VPWR VPWR _0830_ sky130_fd_sc_hd__a21boi_1
X_6484_ _1736_ _1737_ _1735_ VGND VGND VPWR VPWR _1900_ sky130_fd_sc_hd__o21bai_2
XTAP_TAPCELL_ROW_30_585 VGND VPWR sky130_fd_sc_hd__tapvpwrvgnd_1
X_5435_ _3163_ _1490_ VGND VGND VPWR VPWR _0754_ sky130_fd_sc_hd__nand2_1
XFILLER_0_100_537 VGND VGND VPWR VPWR sky130_fd_sc_hd__fill_1
XFILLER_0_77_61 VGND VGND VPWR VPWR sky130_fd_sc_hd__fill_1
X_5366_ _0556_ _0558_ _0557_ VGND VGND VPWR VPWR _0679_ sky130_fd_sc_hd__o21bai_1
X_4317_ _0933_ _0181_ _3306_ VGND VGND VPWR VPWR _3428_ sky130_fd_sc_hd__mux2_1
X_5297_ _0390_ _3724_ _0603_ VGND VGND VPWR VPWR _0604_ sky130_fd_sc_hd__o21ai_1
XFILLER_0_77_94 VGND VGND VPWR VPWR sky130_fd_sc_hd__fill_2
X_7105_ _2577_ _2578_ VGND VGND VPWR VPWR _2579_ sky130_fd_sc_hd__or2_1
X_7036_ _3310_ net19 VGND VGND VPWR VPWR _2503_ sky130_fd_sc_hd__nand2_1
X_4248_ _3309_ VGND VGND VPWR VPWR _3360_ sky130_fd_sc_hd__clkbuf_4
XTAP_TAPCELL_ROW_58_906 VGND VPWR sky130_fd_sc_hd__tapvpwrvgnd_1
XFILLER_0_93_82 VGND VGND VPWR VPWR sky130_fd_sc_hd__decap_4
X_4179_ _3141_ _3174_ VGND VGND VPWR VPWR _3291_ sky130_fd_sc_hd__nor2_1
XTAP_TAPCELL_ROW_2_255 VGND VPWR sky130_fd_sc_hd__tapvpwrvgnd_1
XFILLER_0_97_649 VGND VGND VPWR VPWR sky130_fd_sc_hd__decap_3
XTAP_TAPCELL_ROW_66_994 VGND VPWR sky130_fd_sc_hd__tapvpwrvgnd_1
XTAP_TAPCELL_ROW_38_674 VGND VPWR sky130_fd_sc_hd__tapvpwrvgnd_1
XFILLER_0_92_321 VGND VGND VPWR VPWR sky130_fd_sc_hd__decap_6
XFILLER_0_108_637 VGND VGND VPWR VPWR sky130_fd_sc_hd__decap_6
XFILLER_0_107_125 VGND VGND VPWR VPWR sky130_fd_sc_hd__fill_2
XFILLER_0_92_376 VPWR VGND VPWR VGND sky130_ef_sc_hd__decap_12
XFILLER_0_92_365 VGND VGND VPWR VPWR sky130_fd_sc_hd__fill_2
XPHY_EDGE_ROW_14_Right_14 VGND VGND VPWR VPWR sky130_fd_sc_hd__decap_3
XFILLER_0_80_527 VGND VGND VPWR VPWR sky130_fd_sc_hd__decap_4
XFILLER_0_33_410 VPWR VGND VPWR VGND sky130_ef_sc_hd__decap_12
XFILLER_0_45_281 VPWR VGND VPWR VGND sky130_ef_sc_hd__decap_12
XTAP_TAPCELL_ROW_94_1315 VGND VPWR sky130_fd_sc_hd__tapvpwrvgnd_1
XFILLER_0_21_649 VGND VGND VPWR VPWR sky130_fd_sc_hd__decap_3
XPHY_EDGE_ROW_23_Right_23 VGND VGND VPWR VPWR sky130_fd_sc_hd__decap_3
XFILLER_0_73_19 VGND VGND VPWR VPWR sky130_fd_sc_hd__decap_8
XTAP_TAPCELL_ROW_103_1422 VGND VPWR sky130_fd_sc_hd__tapvpwrvgnd_1
XFILLER_0_28_204 VGND VGND VPWR VPWR sky130_fd_sc_hd__decap_4
XPHY_EDGE_ROW_32_Right_32 VGND VGND VPWR VPWR sky130_fd_sc_hd__decap_3
XFILLER_0_95_181 VGND VGND VPWR VPWR sky130_fd_sc_hd__decap_8
XFILLER_0_7_109 VGND VGND VPWR VPWR sky130_fd_sc_hd__decap_3
XFILLER_0_28_237 VGND VGND VPWR VPWR sky130_fd_sc_hd__fill_1
XFILLER_0_83_376 VGND VGND VPWR VPWR sky130_fd_sc_hd__decap_6
XFILLER_0_56_579 VGND VGND VPWR VPWR sky130_fd_sc_hd__decap_8
XFILLER_0_24_421 VGND VGND VPWR VPWR sky130_fd_sc_hd__decap_6
XFILLER_0_98_27 VGND VGND VPWR VPWR sky130_fd_sc_hd__fill_1
XFILLER_0_106_180 VGND VGND VPWR VPWR sky130_fd_sc_hd__decap_6
XFILLER_0_11_104 VGND VGND VPWR VPWR sky130_fd_sc_hd__fill_1
XFILLER_0_3_337 VPWR VGND VPWR VGND sky130_ef_sc_hd__decap_12
X_5220_ _0447_ _0454_ VGND VGND VPWR VPWR _0520_ sky130_fd_sc_hd__nand2_1
XPHY_EDGE_ROW_41_Right_41 VGND VGND VPWR VPWR sky130_fd_sc_hd__decap_3
X_5151_ _0441_ _0443_ _0424_ _0425_ VGND VGND VPWR VPWR _0445_ sky130_fd_sc_hd__o211a_1
X_5082_ _0168_ _0270_ _0367_ _0368_ VGND VGND VPWR VPWR _0370_ sky130_fd_sc_hd__a22o_1
XFILLER_0_47_42 VPWR VGND VPWR VGND sky130_ef_sc_hd__decap_12
X_4102_ _2857_ VGND VGND VPWR VPWR _2867_ sky130_fd_sc_hd__clkbuf_8
X_4033_ _2058_ _2102_ VGND VGND VPWR VPWR _2113_ sky130_fd_sc_hd__or2_1
XFILLER_0_79_605 VGND VGND VPWR VPWR sky130_fd_sc_hd__fill_1
XTAP_TAPCELL_ROW_69_1030 VGND VPWR sky130_fd_sc_hd__tapvpwrvgnd_1
XFILLER_0_78_104 VGND VGND VPWR VPWR sky130_fd_sc_hd__decap_8
XFILLER_0_63_63 VGND VGND VPWR VPWR sky130_fd_sc_hd__fill_1
XFILLER_0_2_77 VGND VGND VPWR VPWR sky130_fd_sc_hd__decap_6
XPHY_EDGE_ROW_50_Right_50 VGND VGND VPWR VPWR sky130_fd_sc_hd__decap_3
XTAP_TAPCELL_ROW_63_964 VGND VPWR sky130_fd_sc_hd__tapvpwrvgnd_1
X_5984_ _1345_ _1353_ _3647_ VGND VGND VPWR VPWR _1354_ sky130_fd_sc_hd__a21oi_1
XFILLER_0_19_215 VGND VGND VPWR VPWR sky130_fd_sc_hd__decap_8
XTAP_TAPCELL_ROW_35_644 VGND VPWR sky130_fd_sc_hd__tapvpwrvgnd_1
X_4935_ _3414_ _1533_ VGND VGND VPWR VPWR _0209_ sky130_fd_sc_hd__nand2_1
XFILLER_0_47_535 VGND VGND VPWR VPWR sky130_fd_sc_hd__decap_3
X_7654_ _2802_ _0116_ VGND VGND VPWR VPWR _3180_ sky130_fd_sc_hd__nand2_1
XFILLER_0_74_365 VPWR VGND VPWR VGND sky130_ef_sc_hd__decap_12
X_4866_ _3524_ _1741_ VGND VGND VPWR VPWR _0134_ sky130_fd_sc_hd__nand2_1
XANTENNA_11 _3518_ VGND VGND VPWR VPWR sky130_fd_sc_hd__diode_2
X_7585_ _3102_ _3103_ VGND VGND VPWR VPWR _3104_ sky130_fd_sc_hd__xnor2_2
XFILLER_0_74_398 VGND VGND VPWR VPWR sky130_fd_sc_hd__decap_8
XFILLER_0_62_527 VGND VGND VPWR VPWR sky130_fd_sc_hd__decap_4
XFILLER_0_6_153 VPWR VGND VPWR VGND sky130_ef_sc_hd__decap_12
XFILLER_0_15_421 VPWR VGND VPWR VGND sky130_ef_sc_hd__decap_12
X_4797_ _0056_ _0057_ _0058_ VGND VGND VPWR VPWR _0059_ sky130_fd_sc_hd__nand3_1
X_6605_ _2474_ _1282_ _1195_ _2386_ VGND VGND VPWR VPWR _2032_ sky130_fd_sc_hd__a22oi_2
XFILLER_0_105_629 VPWR VGND VPWR VGND sky130_ef_sc_hd__decap_12
X_6536_ _1954_ _1955_ _1795_ _1831_ VGND VGND VPWR VPWR _1957_ sky130_fd_sc_hd__a211oi_1
XFILLER_0_104_139 VGND VGND VPWR VPWR sky130_fd_sc_hd__fill_1
XFILLER_0_6_197 VPWR VGND VPWR VGND sky130_ef_sc_hd__decap_12
XFILLER_0_30_413 VGND VGND VPWR VPWR sky130_fd_sc_hd__decap_6
XFILLER_0_42_251 VGND VGND VPWR VPWR sky130_fd_sc_hd__fill_1
X_6467_ _1746_ _1748_ _1879_ _1880_ VGND VGND VPWR VPWR _1881_ sky130_fd_sc_hd__a211oi_2
XFILLER_0_42_284 VGND VGND VPWR VPWR sky130_fd_sc_hd__decap_4
XFILLER_0_42_295 VPWR VGND VPWR VGND sky130_ef_sc_hd__decap_12
XTAP_TAPCELL_ROW_7_314 VGND VPWR sky130_fd_sc_hd__tapvpwrvgnd_1
XFILLER_0_2_392 VGND VGND VPWR VPWR sky130_fd_sc_hd__decap_6
X_5418_ _0621_ _0622_ VGND VGND VPWR VPWR _0735_ sky130_fd_sc_hd__nor2_1
X_6398_ _1803_ _1802_ _1804_ VGND VGND VPWR VPWR _1806_ sky130_fd_sc_hd__a21o_1
X_5349_ _0657_ _0658_ _0659_ VGND VGND VPWR VPWR _0661_ sky130_fd_sc_hd__nand3b_1
X_7019_ _1088_ _0288_ _0848_ _2481_ _2484_ VGND VGND VPWR VPWR _2486_ sky130_fd_sc_hd__a2111o_1
XFILLER_0_69_104 VGND VGND VPWR VPWR sky130_fd_sc_hd__decap_8
XFILLER_0_93_641 VGND VGND VPWR VPWR sky130_fd_sc_hd__decap_8
XFILLER_0_38_557 VPWR VGND VPWR VGND sky130_ef_sc_hd__decap_12
XFILLER_0_65_343 VPWR VGND VPWR VGND sky130_ef_sc_hd__decap_12
XFILLER_0_92_162 VPWR VGND VPWR VGND sky130_ef_sc_hd__decap_12
XFILLER_0_80_324 VGND VGND VPWR VPWR sky130_fd_sc_hd__fill_2
XFILLER_0_108_489 VPWR VGND VPWR VGND sky130_ef_sc_hd__decap_12
XFILLER_0_18_281 VPWR VGND VPWR VGND sky130_ef_sc_hd__decap_12
XFILLER_0_104_651 VGND VGND VPWR VPWR sky130_fd_sc_hd__fill_1
XFILLER_0_84_29 VGND VGND VPWR VPWR sky130_fd_sc_hd__decap_8
XFILLER_0_17_89 VPWR VGND VPWR VGND sky130_ef_sc_hd__decap_12
XTAP_TAPCELL_ROW_60_923 VGND VPWR sky130_fd_sc_hd__tapvpwrvgnd_1
XFILLER_0_56_321 VPWR VGND VPWR VGND sky130_ef_sc_hd__decap_12
XTAP_TAPCELL_ROW_32_603 VGND VPWR sky130_fd_sc_hd__tapvpwrvgnd_1
XFILLER_0_33_55 VGND VGND VPWR VPWR sky130_fd_sc_hd__fill_1
XFILLER_0_83_140 VGND VGND VPWR VPWR sky130_fd_sc_hd__decap_3
XFILLER_0_56_365 VPWR VGND VPWR VGND sky130_ef_sc_hd__decap_12
XFILLER_0_8_429 VGND VGND VPWR VPWR sky130_fd_sc_hd__decap_8
XFILLER_0_29_568 VGND VGND VPWR VPWR sky130_fd_sc_hd__fill_1
X_4720_ _3821_ _3822_ _3823_ VGND VGND VPWR VPWR _3824_ sky130_fd_sc_hd__or3_1
XFILLER_0_44_505 VPWR VGND VPWR VGND sky130_ef_sc_hd__decap_12
X_4651_ _3747_ _3749_ _3750_ _3752_ _3755_ VGND VGND VPWR VPWR _3756_ sky130_fd_sc_hd__o2111a_1
Xinput20 A[28] VGND VGND VPWR VPWR net20 sky130_fd_sc_hd__clkbuf_4
XFILLER_0_71_346 VGND VGND VPWR VPWR sky130_fd_sc_hd__fill_2
XTAP_TAPCELL_ROW_12_371 VGND VPWR sky130_fd_sc_hd__tapvpwrvgnd_1
XFILLER_0_4_613 VPWR VGND VPWR VGND sky130_ef_sc_hd__decap_12
Xinput31 A[9] VGND VGND VPWR VPWR net31 sky130_fd_sc_hd__buf_2
Xinput64 opcode[1] VGND VGND VPWR VPWR net64 sky130_fd_sc_hd__buf_2
X_7370_ _0382_ _1658_ _2868_ _1985_ VGND VGND VPWR VPWR _2869_ sky130_fd_sc_hd__a211oi_1
X_4582_ _3196_ _2703_ VGND VGND VPWR VPWR _3688_ sky130_fd_sc_hd__nand2_1
Xinput53 B[2] VGND VGND VPWR VPWR net53 sky130_fd_sc_hd__buf_12
Xinput42 B[1] VGND VGND VPWR VPWR net42 sky130_fd_sc_hd__clkbuf_2
XTAP_TAPCELL_ROW_40_691 VGND VPWR sky130_fd_sc_hd__tapvpwrvgnd_1
XFILLER_0_101_109 VGND VGND VPWR VPWR sky130_fd_sc_hd__decap_3
X_6321_ _1718_ _1720_ _1585_ _1684_ VGND VGND VPWR VPWR _1722_ sky130_fd_sc_hd__o211a_1
X_6252_ _1645_ _1646_ VGND VGND VPWR VPWR _1647_ sky130_fd_sc_hd__nor2_1
X_5203_ _3647_ _0501_ VGND VGND VPWR VPWR _0502_ sky130_fd_sc_hd__nor2_1
X_6183_ _1452_ _1460_ VGND VGND VPWR VPWR _1571_ sky130_fd_sc_hd__or2b_1
XFILLER_0_58_85 VPWR VGND VPWR VGND sky130_ef_sc_hd__decap_12
XFILLER_0_20_490 VGND VGND VPWR VPWR sky130_fd_sc_hd__decap_4
X_5134_ _0324_ _0329_ VGND VGND VPWR VPWR _0426_ sky130_fd_sc_hd__and2b_1
XFILLER_0_74_51 VGND VGND VPWR VPWR sky130_fd_sc_hd__fill_2
X_5065_ _0348_ _0349_ _0350_ VGND VGND VPWR VPWR _0351_ sky130_fd_sc_hd__nand3_2
XFILLER_0_79_413 VGND VGND VPWR VPWR sky130_fd_sc_hd__fill_2
X_4016_ net3 VGND VGND VPWR VPWR _1927_ sky130_fd_sc_hd__buf_6
XFILLER_0_28_3 VPWR VGND VPWR VGND sky130_ef_sc_hd__decap_12
XTAP_TAPCELL_ROW_48_791 VGND VPWR sky130_fd_sc_hd__tapvpwrvgnd_1
XFILLER_0_109_209 VPWR VGND VPWR VGND sky130_ef_sc_hd__decap_12
XFILLER_0_75_641 VGND VGND VPWR VPWR sky130_fd_sc_hd__decap_8
X_5967_ _1267_ _1268_ _1332_ _1333_ VGND VGND VPWR VPWR _1335_ sky130_fd_sc_hd__a2bb2oi_1
X_4918_ _3466_ _0102_ _0190_ net118 VGND VGND VPWR VPWR _0191_ sky130_fd_sc_hd__a22oi_2
X_7706_ net88 net89 _3235_ _3234_ VGND VGND VPWR VPWR _3236_ sky130_fd_sc_hd__nor4_4
XFILLER_0_35_505 VGND VGND VPWR VPWR sky130_fd_sc_hd__decap_8
X_7637_ _2919_ _2947_ _2918_ VGND VGND VPWR VPWR _3161_ sky130_fd_sc_hd__a21o_1
X_5898_ _1251_ _1258_ VGND VGND VPWR VPWR _1259_ sky130_fd_sc_hd__xnor2_1
XFILLER_0_47_398 VGND VGND VPWR VPWR sky130_fd_sc_hd__fill_1
X_4849_ _0082_ _0085_ _0115_ VGND VGND VPWR VPWR net100 sky130_fd_sc_hd__o21ai_1
XFILLER_0_62_357 VGND VGND VPWR VPWR sky130_fd_sc_hd__decap_6
XTAP_TAPCELL_ROW_78_1129 VGND VPWR sky130_fd_sc_hd__tapvpwrvgnd_1
X_7568_ _3077_ _3084_ VGND VGND VPWR VPWR _3085_ sky130_fd_sc_hd__xnor2_1
X_7499_ _3009_ VGND VGND VPWR VPWR _3011_ sky130_fd_sc_hd__inv_2
X_6519_ _1932_ _1937_ VGND VGND VPWR VPWR _1939_ sky130_fd_sc_hd__xnor2_1
XFILLER_0_100_120 VGND VGND VPWR VPWR sky130_fd_sc_hd__fill_1
XFILLER_0_100_197 VPWR VGND VPWR VGND sky130_ef_sc_hd__decap_12
XFILLER_0_100_186 VGND VGND VPWR VPWR sky130_fd_sc_hd__decap_8
XTAP_TAPCELL_ROW_89_1258 VGND VPWR sky130_fd_sc_hd__tapvpwrvgnd_1
XFILLER_0_85_405 VGND VGND VPWR VPWR sky130_fd_sc_hd__fill_1
XFILLER_0_85_449 VPWR VGND VPWR VGND sky130_ef_sc_hd__decap_12
XFILLER_0_57_129 VGND VGND VPWR VPWR sky130_fd_sc_hd__decap_8
XFILLER_0_108_242 VGND VGND VPWR VPWR sky130_fd_sc_hd__fill_1
XFILLER_0_81_633 VPWR VGND VPWR VGND sky130_ef_sc_hd__decap_12
XFILLER_0_65_184 VGND VGND VPWR VPWR sky130_fd_sc_hd__decap_4
XFILLER_0_53_324 VPWR VGND VPWR VGND sky130_ef_sc_hd__decap_12
XFILLER_0_1_649 VGND VGND VPWR VPWR sky130_fd_sc_hd__decap_3
XFILLER_0_21_243 VGND VGND VPWR VPWR sky130_fd_sc_hd__decap_6
XFILLER_0_0_137 VGND VGND VPWR VPWR sky130_fd_sc_hd__decap_3
XFILLER_0_21_276 VGND VGND VPWR VPWR sky130_fd_sc_hd__decap_4
XFILLER_0_88_243 VGND VGND VPWR VPWR sky130_fd_sc_hd__decap_8
XFILLER_0_88_221 VGND VGND VPWR VPWR sky130_fd_sc_hd__decap_3
XTAP_TAPCELL_ROW_66_1000 VGND VPWR sky130_fd_sc_hd__tapvpwrvgnd_1
XTAP_TAPCELL_ROW_109_1494 VGND VPWR sky130_fd_sc_hd__tapvpwrvgnd_1
XFILLER_0_88_265 VGND VGND VPWR VPWR sky130_fd_sc_hd__fill_2
X_6870_ _0977_ _2300_ _2301_ _2322_ VGND VGND VPWR VPWR net87 sky130_fd_sc_hd__a31o_1
XTAP_TAPCELL_ROW_17_430 VGND VPWR sky130_fd_sc_hd__tapvpwrvgnd_1
X_5821_ net42 net9 VGND VGND VPWR VPWR _1176_ sky130_fd_sc_hd__nand2_1
XTAP_TAPCELL_ROW_45_750 VGND VPWR sky130_fd_sc_hd__tapvpwrvgnd_1
X_5752_ _0596_ _1081_ _1100_ VGND VGND VPWR VPWR _1101_ sky130_fd_sc_hd__o21ai_1
XFILLER_0_17_505 VGND VGND VPWR VPWR sky130_fd_sc_hd__decap_3
XFILLER_0_29_343 VGND VGND VPWR VPWR sky130_fd_sc_hd__decap_4
X_4703_ _3737_ _3738_ _3761_ _3807_ VGND VGND VPWR VPWR net98 sky130_fd_sc_hd__a211o_1
XFILLER_0_29_365 VGND VGND VPWR VPWR sky130_fd_sc_hd__decap_3
XFILLER_0_29_376 VGND VGND VPWR VPWR sky130_fd_sc_hd__fill_2
XFILLER_0_56_195 VGND VGND VPWR VPWR sky130_fd_sc_hd__fill_1
X_5683_ _0892_ _0910_ _0912_ VGND VGND VPWR VPWR _1025_ sky130_fd_sc_hd__nand3_4
XFILLER_0_44_346 VGND VGND VPWR VPWR sky130_fd_sc_hd__decap_8
XFILLER_0_44_357 VGND VGND VPWR VPWR sky130_fd_sc_hd__decap_6
X_4634_ _3248_ _2517_ VGND VGND VPWR VPWR _3739_ sky130_fd_sc_hd__nor2_1
X_7422_ _3256_ _1173_ _0769_ _1424_ VGND VGND VPWR VPWR _2926_ sky130_fd_sc_hd__a22o_1
XFILLER_0_4_421 VGND VGND VPWR VPWR sky130_fd_sc_hd__decap_6
XFILLER_0_102_407 VGND VGND VPWR VPWR sky130_fd_sc_hd__fill_1
X_4565_ _3395_ _3340_ _3433_ _3537_ _3670_ VGND VGND VPWR VPWR _3672_ sky130_fd_sc_hd__a311oi_4
XFILLER_0_69_40 VPWR VGND VPWR VGND sky130_ef_sc_hd__decap_12
X_7353_ _2467_ _2652_ VGND VGND VPWR VPWR _2851_ sky130_fd_sc_hd__and2_1
XFILLER_0_12_221 VPWR VGND VPWR VGND sky130_ef_sc_hd__decap_12
X_6304_ _1548_ _1556_ VGND VGND VPWR VPWR _1703_ sky130_fd_sc_hd__nand2_1
X_4496_ _3503_ _3290_ _3141_ _3174_ VGND VGND VPWR VPWR _3604_ sky130_fd_sc_hd__a211o_1
X_7284_ _2584_ _2589_ VGND VGND VPWR VPWR _2775_ sky130_fd_sc_hd__or2b_1
XPHY_EDGE_ROW_4_Right_4 VGND VGND VPWR VPWR sky130_fd_sc_hd__decap_3
X_6235_ _1587_ _1589_ net122 _1626_ VGND VGND VPWR VPWR _1628_ sky130_fd_sc_hd__o22ai_1
X_6166_ _1550_ _1551_ VGND VGND VPWR VPWR _1552_ sky130_fd_sc_hd__nor2_1
X_5117_ _0110_ _0406_ _0197_ _3660_ VGND VGND VPWR VPWR _0407_ sky130_fd_sc_hd__o2bb2a_1
X_6097_ _1475_ _1474_ _1466_ VGND VGND VPWR VPWR _1477_ sky130_fd_sc_hd__a21o_1
X_5048_ net58 VGND VGND VPWR VPWR _0332_ sky130_fd_sc_hd__clkbuf_4
XFILLER_0_79_254 VGND VGND VPWR VPWR sky130_fd_sc_hd__fill_2
XFILLER_0_79_298 VPWR VGND VPWR VGND sky130_ef_sc_hd__decap_12
XTAP_TAPCELL_ROW_84_1199 VGND VPWR sky130_fd_sc_hd__tapvpwrvgnd_1
XFILLER_0_82_419 VGND VGND VPWR VPWR sky130_fd_sc_hd__fill_1
X_6999_ _2460_ _2461_ _2286_ _2327_ VGND VGND VPWR VPWR _2464_ sky130_fd_sc_hd__a211oi_1
XFILLER_0_94_279 VPWR VGND VPWR VGND sky130_ef_sc_hd__decap_12
XFILLER_0_62_121 VPWR VGND VPWR VGND sky130_ef_sc_hd__decap_12
Xclone12 net32 VGND VGND VPWR VPWR net155 sky130_fd_sc_hd__clkbuf_16
XTAP_TAPCELL_ROW_23_499 VGND VPWR sky130_fd_sc_hd__tapvpwrvgnd_1
XFILLER_0_16_560 VGND VGND VPWR VPWR sky130_fd_sc_hd__decap_4
XFILLER_0_35_379 VPWR VGND VPWR VGND sky130_ef_sc_hd__decap_12
XFILLER_0_105_15 VPWR VGND VPWR VGND sky130_ef_sc_hd__decap_12
XFILLER_0_58_449 VGND VGND VPWR VPWR sky130_fd_sc_hd__decap_4
XFILLER_0_85_268 VGND VGND VPWR VPWR sky130_fd_sc_hd__fill_2
XFILLER_0_73_408 VGND VGND VPWR VPWR sky130_fd_sc_hd__decap_8
XTAP_TAPCELL_ROW_14_400 VGND VPWR sky130_fd_sc_hd__tapvpwrvgnd_1
XFILLER_0_39_641 VGND VGND VPWR VPWR sky130_fd_sc_hd__decap_8
XTAP_TAPCELL_ROW_42_720 VGND VPWR sky130_fd_sc_hd__tapvpwrvgnd_1
XFILLER_0_85_279 VGND VGND VPWR VPWR sky130_fd_sc_hd__fill_1
XFILLER_0_26_379 VPWR VGND VPWR VGND sky130_ef_sc_hd__decap_12
XFILLER_0_53_154 VPWR VGND VPWR VGND sky130_ef_sc_hd__decap_12
XFILLER_0_81_485 VPWR VGND VPWR VGND sky130_ef_sc_hd__decap_12
X_4350_ _3350_ _3302_ _3446_ _3460_ _3304_ VGND VGND VPWR VPWR _3461_ sky130_fd_sc_hd__a32o_1
XFILLER_0_22_530 VGND VGND VPWR VPWR sky130_fd_sc_hd__fill_2
XFILLER_0_22_596 VGND VGND VPWR VPWR sky130_fd_sc_hd__decap_8
X_4281_ _3386_ _3392_ _3321_ VGND VGND VPWR VPWR _3393_ sky130_fd_sc_hd__mux2_1
XTAP_TAPCELL_ROW_72_1070 VGND VPWR sky130_fd_sc_hd__tapvpwrvgnd_1
X_6020_ _1261_ VGND VGND VPWR VPWR _1393_ sky130_fd_sc_hd__inv_2
XFILLER_0_39_98 VGND VGND VPWR VPWR sky130_fd_sc_hd__decap_3
XFILLER_0_55_31 VPWR VGND VPWR VGND sky130_ef_sc_hd__decap_12
X_6922_ _2230_ _2232_ _2229_ VGND VGND VPWR VPWR _2379_ sky130_fd_sc_hd__o21ba_1
XFILLER_0_89_596 VGND VGND VPWR VPWR sky130_fd_sc_hd__fill_2
X_6853_ _0551_ _2000_ _0529_ VGND VGND VPWR VPWR _2304_ sky130_fd_sc_hd__o21a_1
XFILLER_0_49_438 VGND VGND VPWR VPWR sky130_fd_sc_hd__decap_8
XFILLER_0_49_449 VPWR VGND VPWR VGND sky130_ef_sc_hd__decap_12
XFILLER_0_76_268 VGND VGND VPWR VPWR sky130_fd_sc_hd__decap_3
XFILLER_0_76_246 VGND VGND VPWR VPWR sky130_fd_sc_hd__fill_1
X_5804_ _1137_ _1138_ _1155_ _1156_ VGND VGND VPWR VPWR _1157_ sky130_fd_sc_hd__o211a_1
XFILLER_0_91_205 VGND VGND VPWR VPWR sky130_fd_sc_hd__decap_8
XFILLER_0_29_173 VGND VGND VPWR VPWR sky130_fd_sc_hd__fill_1
X_3996_ net30 VGND VGND VPWR VPWR _1708_ sky130_fd_sc_hd__inv_2
X_6784_ _2226_ _2227_ VGND VGND VPWR VPWR _2228_ sky130_fd_sc_hd__xnor2_2
X_5735_ _0726_ _0835_ VGND VGND VPWR VPWR _1082_ sky130_fd_sc_hd__and2_1
XFILLER_0_17_335 VGND VGND VPWR VPWR sky130_fd_sc_hd__fill_1
XFILLER_0_29_184 VGND VGND VPWR VPWR sky130_fd_sc_hd__decap_8
XFILLER_0_44_121 VGND VGND VPWR VPWR sky130_fd_sc_hd__decap_8
X_5666_ _2561_ net36 VGND VGND VPWR VPWR _1006_ sky130_fd_sc_hd__nand2_1
X_4617_ net24 _3348_ _3722_ VGND VGND VPWR VPWR _3723_ sky130_fd_sc_hd__a21o_1
X_7405_ _2905_ _2906_ VGND VGND VPWR VPWR _2907_ sky130_fd_sc_hd__nor2_1
XTAP_TAPCELL_ROW_20_469 VGND VPWR sky130_fd_sc_hd__tapvpwrvgnd_1
XFILLER_0_44_176 VPWR VGND VPWR VGND sky130_ef_sc_hd__decap_12
XFILLER_0_102_204 VPWR VGND VPWR VGND sky130_ef_sc_hd__decap_12
X_5597_ _0929_ _0930_ VGND VGND VPWR VPWR _0931_ sky130_fd_sc_hd__xnor2_2
XFILLER_0_102_248 VGND VGND VPWR VPWR sky130_fd_sc_hd__decap_4
X_4548_ _2824_ _3654_ VGND VGND VPWR VPWR _3655_ sky130_fd_sc_hd__nand2_1
X_7336_ _2625_ _2628_ _2831_ VGND VGND VPWR VPWR _2832_ sky130_fd_sc_hd__o21a_1
XFILLER_0_13_585 VPWR VGND VPWR VGND sky130_ef_sc_hd__decap_12
XFILLER_0_40_360 VGND VGND VPWR VPWR sky130_fd_sc_hd__decap_4
X_4479_ _3527_ _3517_ _3586_ VGND VGND VPWR VPWR _3587_ sky130_fd_sc_hd__o21ai_2
X_7267_ _2754_ _2755_ VGND VGND VPWR VPWR _2756_ sky130_fd_sc_hd__xnor2_1
X_6218_ net140 _0987_ net10 _0242_ VGND VGND VPWR VPWR _1609_ sky130_fd_sc_hd__a22oi_2
X_7198_ _2678_ _2679_ _0506_ VGND VGND VPWR VPWR _2680_ sky130_fd_sc_hd__o21ai_1
X_6149_ _3287_ _0867_ _1075_ _3331_ VGND VGND VPWR VPWR _1534_ sky130_fd_sc_hd__a22oi_1
XTAP_TAPCELL_ROW_86_1228 VGND VPWR sky130_fd_sc_hd__tapvpwrvgnd_1
XPHY_EDGE_ROW_79_Right_79 VGND VGND VPWR VPWR sky130_fd_sc_hd__decap_3
XFILLER_0_67_202 VGND VGND VPWR VPWR sky130_fd_sc_hd__fill_1
XTAP_TAPCELL_ROW_56_878 VGND VPWR sky130_fd_sc_hd__tapvpwrvgnd_1
XTAP_TAPCELL_ROW_28_558 VGND VPWR sky130_fd_sc_hd__tapvpwrvgnd_1
XFILLER_0_95_577 VGND VGND VPWR VPWR sky130_fd_sc_hd__fill_1
XFILLER_0_67_279 VGND VGND VPWR VPWR sky130_fd_sc_hd__fill_1
XFILLER_0_35_165 VGND VGND VPWR VPWR sky130_fd_sc_hd__decap_3
XTAP_TAPCELL_ROW_97_1357 VGND VPWR sky130_fd_sc_hd__tapvpwrvgnd_1
XFILLER_0_90_293 VPWR VGND VPWR VGND sky130_ef_sc_hd__decap_12
XPHY_EDGE_ROW_88_Right_88 VGND VGND VPWR VPWR sky130_fd_sc_hd__decap_3
XFILLER_0_63_485 VPWR VGND VPWR VGND sky130_ef_sc_hd__decap_12
XFILLER_0_106_587 VGND VGND VPWR VPWR sky130_fd_sc_hd__fill_1
XFILLER_0_23_349 VGND VGND VPWR VPWR sky130_fd_sc_hd__decap_8
XFILLER_0_50_179 VPWR VGND VPWR VGND sky130_ef_sc_hd__decap_12
XFILLER_0_31_393 VGND VGND VPWR VPWR sky130_fd_sc_hd__fill_1
XFILLER_0_101_292 VGND VGND VPWR VPWR sky130_fd_sc_hd__fill_1
XPHY_EDGE_ROW_97_Right_97 VGND VGND VPWR VPWR sky130_fd_sc_hd__decap_3
XTAP_TAPCELL_ROW_106_1453 VGND VPWR sky130_fd_sc_hd__tapvpwrvgnd_1
XFILLER_0_86_533 VGND VGND VPWR VPWR sky130_fd_sc_hd__decap_4
X_3850_ net49 VGND VGND VPWR VPWR _0116_ sky130_fd_sc_hd__buf_2
XFILLER_0_58_268 VPWR VGND VPWR VGND sky130_ef_sc_hd__decap_12
XFILLER_0_46_419 VGND VGND VPWR VPWR sky130_fd_sc_hd__fill_1
XFILLER_0_26_121 VPWR VGND VPWR VGND sky130_ef_sc_hd__decap_12
X_5520_ _3370_ _3463_ _3299_ VGND VGND VPWR VPWR _0848_ sky130_fd_sc_hd__and3_2
XFILLER_0_14_305 VGND VGND VPWR VPWR sky130_fd_sc_hd__decap_3
XFILLER_0_81_293 VPWR VGND VPWR VGND sky130_ef_sc_hd__decap_12
XFILLER_0_41_113 VGND VGND VPWR VPWR sky130_fd_sc_hd__decap_6
XFILLER_0_42_625 VPWR VGND VPWR VGND sky130_ef_sc_hd__decap_12
X_5451_ _0768_ _0770_ _0753_ VGND VGND VPWR VPWR _0772_ sky130_fd_sc_hd__a21o_1
X_4402_ _3354_ _0039_ _3356_ VGND VGND VPWR VPWR _3512_ sky130_fd_sc_hd__nor3_4
X_5382_ _0626_ _0695_ _0696_ VGND VGND VPWR VPWR _0697_ sky130_fd_sc_hd__and3_4
X_4333_ _3432_ _3443_ _3312_ VGND VGND VPWR VPWR _3444_ sky130_fd_sc_hd__mux2_1
X_7121_ _2595_ _2596_ VGND VGND VPWR VPWR _2597_ sky130_fd_sc_hd__nand2_1
X_4264_ _1271_ VGND VGND VPWR VPWR _3376_ sky130_fd_sc_hd__clkbuf_4
X_7052_ _2517_ _0856_ _1107_ _2364_ VGND VGND VPWR VPWR _2521_ sky130_fd_sc_hd__a22oi_1
X_6003_ _0747_ _0846_ _1374_ VGND VGND VPWR VPWR _1375_ sky130_fd_sc_hd__or3_1
XFILLER_0_5_55 VGND VGND VPWR VPWR sky130_fd_sc_hd__fill_1
X_4195_ _3306_ VGND VGND VPWR VPWR _3307_ sky130_fd_sc_hd__buf_8
XFILLER_0_66_74 VGND VGND VPWR VPWR sky130_fd_sc_hd__fill_1
XFILLER_0_89_382 VGND VGND VPWR VPWR sky130_fd_sc_hd__decap_8
X_6905_ _2347_ _2348_ _2358_ VGND VGND VPWR VPWR _2360_ sky130_fd_sc_hd__a21oi_1
XFILLER_0_10_3 VPWR VGND VPWR VGND sky130_ef_sc_hd__decap_12
XTAP_TAPCELL_ROW_25_528 VGND VPWR sky130_fd_sc_hd__tapvpwrvgnd_1
XTAP_TAPCELL_ROW_53_848 VGND VPWR sky130_fd_sc_hd__tapvpwrvgnd_1
XFILLER_0_64_205 VGND VGND VPWR VPWR sky130_fd_sc_hd__fill_2
X_6836_ _2245_ _2246_ _2282_ _2283_ VGND VGND VPWR VPWR _2285_ sky130_fd_sc_hd__o22a_1
XFILLER_0_92_536 VPWR VGND VPWR VGND sky130_ef_sc_hd__decap_12
XTAP_TAPCELL_ROW_81_1169 VGND VPWR sky130_fd_sc_hd__tapvpwrvgnd_1
XFILLER_0_57_290 VGND VGND VPWR VPWR sky130_fd_sc_hd__decap_8
XFILLER_0_9_365 VGND VGND VPWR VPWR sky130_fd_sc_hd__decap_6
X_6767_ _2207_ _2208_ VGND VGND VPWR VPWR _2209_ sky130_fd_sc_hd__nor2_1
X_5718_ _1060_ _1061_ _0915_ net113 VGND VGND VPWR VPWR _1063_ sky130_fd_sc_hd__a211oi_2
XFILLER_0_17_154 VPWR VGND VPWR VGND sky130_ef_sc_hd__decap_12
X_3979_ net33 VGND VGND VPWR VPWR _1523_ sky130_fd_sc_hd__clkbuf_4
XFILLER_0_72_260 VGND VGND VPWR VPWR sky130_fd_sc_hd__fill_2
XFILLER_0_32_113 VPWR VGND VPWR VGND sky130_ef_sc_hd__decap_12
XFILLER_0_33_636 VPWR VGND VPWR VGND sky130_ef_sc_hd__decap_12
X_6698_ _2131_ _2132_ _1956_ net103 VGND VGND VPWR VPWR _2134_ sky130_fd_sc_hd__a211o_1
XFILLER_0_45_485 VGND VGND VPWR VPWR sky130_fd_sc_hd__decap_4
XFILLER_0_60_433 VPWR VGND VPWR VGND sky130_ef_sc_hd__decap_12
X_5649_ _3010_ _0791_ VGND VGND VPWR VPWR _0988_ sky130_fd_sc_hd__nand2_1
XFILLER_0_103_568 VPWR VGND VPWR VGND sky130_ef_sc_hd__decap_12
XFILLER_0_60_477 VPWR VGND VPWR VGND sky130_ef_sc_hd__decap_12
X_7319_ _2617_ _2622_ VGND VGND VPWR VPWR _2814_ sky130_fd_sc_hd__or2b_1
XFILLER_0_13_393 VPWR VGND VPWR VGND sky130_ef_sc_hd__decap_12
XTAP_TAPCELL_ROW_92_1298 VGND VPWR sky130_fd_sc_hd__tapvpwrvgnd_1
XFILLER_0_99_113 VPWR VGND VPWR VGND sky130_ef_sc_hd__decap_12
XTAP_TAPCELL_ROW_5_297 VGND VPWR sky130_fd_sc_hd__tapvpwrvgnd_1
XFILLER_0_36_430 VGND VGND VPWR VPWR sky130_fd_sc_hd__fill_2
XFILLER_0_102_27 VGND VGND VPWR VPWR sky130_fd_sc_hd__fill_1
XFILLER_0_24_603 VGND VGND VPWR VPWR sky130_fd_sc_hd__fill_1
XTAP_TAPCELL_ROW_101_1394 VGND VPWR sky130_fd_sc_hd__tapvpwrvgnd_1
XFILLER_0_11_308 VGND VGND VPWR VPWR sky130_fd_sc_hd__fill_2
Xinput7 A[16] VGND VGND VPWR VPWR net7 sky130_fd_sc_hd__buf_4
XFILLER_0_59_511 VGND VGND VPWR VPWR sky130_fd_sc_hd__decap_6
X_4951_ _3810_ _3621_ _2561_ _3809_ VGND VGND VPWR VPWR _0227_ sky130_fd_sc_hd__a22o_1
XFILLER_0_86_385 VGND VGND VPWR VPWR sky130_fd_sc_hd__fill_2
X_7670_ _3193_ _3197_ VGND VGND VPWR VPWR _3198_ sky130_fd_sc_hd__xnor2_1
XFILLER_0_74_525 VGND VGND VPWR VPWR sky130_fd_sc_hd__fill_1
XFILLER_0_74_503 VGND VGND VPWR VPWR sky130_fd_sc_hd__fill_1
X_3902_ _0671_ VGND VGND VPWR VPWR _0682_ sky130_fd_sc_hd__clkbuf_4
XFILLER_0_59_577 VPWR VGND VPWR VGND sky130_ef_sc_hd__decap_12
X_4882_ _0142_ _0150_ _0151_ VGND VGND VPWR VPWR _0152_ sky130_fd_sc_hd__nand3_1
XTAP_TAPCELL_ROW_50_807 VGND VPWR sky130_fd_sc_hd__tapvpwrvgnd_1
X_6621_ _2046_ _2048_ _2043_ VGND VGND VPWR VPWR _2050_ sky130_fd_sc_hd__a21o_1
XFILLER_0_6_324 VGND VGND VPWR VPWR sky130_fd_sc_hd__fill_2
XFILLER_0_82_580 VGND VGND VPWR VPWR sky130_fd_sc_hd__fill_1
X_6552_ _1973_ _1972_ _1968_ _1965_ VGND VGND VPWR VPWR _1975_ sky130_fd_sc_hd__a31o_4
X_5503_ _0305_ _0373_ _0498_ _0828_ VGND VGND VPWR VPWR _0829_ sky130_fd_sc_hd__o31a_1
X_6483_ _1897_ _1896_ _1895_ VGND VGND VPWR VPWR _1899_ sky130_fd_sc_hd__a21bo_1
XTAP_TAPCELL_ROW_30_586 VGND VPWR sky130_fd_sc_hd__tapvpwrvgnd_1
XFILLER_0_42_444 VPWR VGND VPWR VGND sky130_ef_sc_hd__decap_12
XFILLER_0_54_293 VGND VGND VPWR VPWR sky130_fd_sc_hd__decap_4
X_5434_ _0655_ _0664_ _0663_ VGND VGND VPWR VPWR _0753_ sky130_fd_sc_hd__a21bo_1
XFILLER_0_30_628 VPWR VGND VPWR VGND sky130_ef_sc_hd__decap_12
X_7104_ _2568_ _2576_ VGND VGND VPWR VPWR _2578_ sky130_fd_sc_hd__nor2_1
XFILLER_0_58_3 VGND VGND VPWR VPWR sky130_fd_sc_hd__decap_3
X_5365_ _0675_ _0676_ _0674_ VGND VGND VPWR VPWR _0678_ sky130_fd_sc_hd__o21ai_1
X_4316_ _1107_ _2157_ _3306_ VGND VGND VPWR VPWR _3427_ sky130_fd_sc_hd__mux2_1
X_5296_ _3742_ _0602_ _3374_ VGND VGND VPWR VPWR _0603_ sky130_fd_sc_hd__o21a_1
X_7035_ _2500_ _2501_ VGND VGND VPWR VPWR _2502_ sky130_fd_sc_hd__nor2_1
X_4247_ _3354_ _3355_ _3356_ _3358_ _3330_ VGND VGND VPWR VPWR _3359_ sky130_fd_sc_hd__o32ai_1
XTAP_TAPCELL_ROW_58_907 VGND VPWR sky130_fd_sc_hd__tapvpwrvgnd_1
X_4178_ _3287_ _3288_ _3289_ VGND VGND VPWR VPWR _3290_ sky130_fd_sc_hd__o21ai_2
XFILLER_0_97_617 VPWR VGND VPWR VGND sky130_ef_sc_hd__decap_12
XTAP_TAPCELL_ROW_2_256 VGND VPWR sky130_fd_sc_hd__tapvpwrvgnd_1
XTAP_TAPCELL_ROW_66_995 VGND VPWR sky130_fd_sc_hd__tapvpwrvgnd_1
XTAP_TAPCELL_ROW_38_675 VGND VPWR sky130_fd_sc_hd__tapvpwrvgnd_1
X_6819_ _1490_ _1577_ _2100_ _2265_ VGND VGND VPWR VPWR _2267_ sky130_fd_sc_hd__a31o_1
XFILLER_0_92_388 VPWR VGND VPWR VGND sky130_ef_sc_hd__decap_12
XFILLER_0_80_539 VPWR VGND VPWR VGND sky130_ef_sc_hd__decap_12
XFILLER_0_33_422 VGND VGND VPWR VPWR sky130_fd_sc_hd__decap_8
XFILLER_0_60_241 VGND VGND VPWR VPWR sky130_fd_sc_hd__decap_8
XFILLER_0_45_293 VPWR VGND VPWR VGND sky130_ef_sc_hd__decap_12
XTAP_TAPCELL_ROW_94_1316 VGND VPWR sky130_fd_sc_hd__tapvpwrvgnd_1
XFILLER_0_21_617 VPWR VGND VPWR VGND sky130_ef_sc_hd__decap_12
XFILLER_0_88_628 VGND VGND VPWR VPWR sky130_fd_sc_hd__fill_1
XFILLER_0_87_105 VGND VGND VPWR VPWR sky130_fd_sc_hd__decap_6
XTAP_TAPCELL_ROW_103_1423 VGND VPWR sky130_fd_sc_hd__tapvpwrvgnd_1
XFILLER_0_68_363 VGND VGND VPWR VPWR sky130_fd_sc_hd__fill_1
XFILLER_0_56_514 VGND VGND VPWR VPWR sky130_fd_sc_hd__fill_2
XFILLER_0_28_249 VGND VGND VPWR VPWR sky130_fd_sc_hd__decap_3
XFILLER_0_83_366 VGND VGND VPWR VPWR sky130_fd_sc_hd__fill_1
XFILLER_0_83_344 VGND VGND VPWR VPWR sky130_fd_sc_hd__decap_4
XFILLER_0_3_349 VGND VGND VPWR VPWR sky130_fd_sc_hd__fill_1
XFILLER_0_24_477 VPWR VGND VPWR VGND sky130_ef_sc_hd__decap_12
XFILLER_0_11_127 VGND VGND VPWR VPWR sky130_fd_sc_hd__decap_3
XFILLER_0_51_285 VGND VGND VPWR VPWR sky130_fd_sc_hd__fill_1
X_5150_ _0424_ _0425_ _0441_ _0443_ VGND VGND VPWR VPWR _0444_ sky130_fd_sc_hd__a211oi_2
X_5081_ _0168_ _0270_ _0367_ _0368_ VGND VGND VPWR VPWR _0369_ sky130_fd_sc_hd__nand4_1
X_4101_ net56 VGND VGND VPWR VPWR _2857_ sky130_fd_sc_hd__buf_4
XFILLER_0_47_54 VGND VGND VPWR VPWR sky130_fd_sc_hd__fill_2
X_4032_ _2091_ VGND VGND VPWR VPWR _2102_ sky130_fd_sc_hd__inv_2
XPHY_EDGE_ROW_16_Left_126 VGND VGND VPWR VPWR sky130_fd_sc_hd__decap_3
XFILLER_0_79_639 VPWR VGND VPWR VGND sky130_ef_sc_hd__decap_12
XTAP_TAPCELL_ROW_69_1031 VGND VPWR sky130_fd_sc_hd__tapvpwrvgnd_1
X_5983_ _0831_ _1347_ _1352_ VGND VGND VPWR VPWR _1353_ sky130_fd_sc_hd__o21ai_2
XFILLER_0_93_119 VGND VGND VPWR VPWR sky130_fd_sc_hd__fill_1
XTAP_TAPCELL_ROW_63_965 VGND VPWR sky130_fd_sc_hd__tapvpwrvgnd_1
XTAP_TAPCELL_ROW_35_634 VGND VPWR sky130_fd_sc_hd__tapvpwrvgnd_1
X_4934_ _0129_ _0136_ VGND VGND VPWR VPWR _0208_ sky130_fd_sc_hd__or2b_1
XANTENNA_12 _3730_ VGND VGND VPWR VPWR sky130_fd_sc_hd__diode_2
X_7653_ _3326_ _0944_ _2953_ _3178_ VGND VGND VPWR VPWR _3179_ sky130_fd_sc_hd__a31o_1
XPHY_EDGE_ROW_25_Left_135 VGND VGND VPWR VPWR sky130_fd_sc_hd__decap_3
X_4865_ _0131_ _0132_ VGND VGND VPWR VPWR _0133_ sky130_fd_sc_hd__nor2_1
X_7584_ _1544_ _3376_ _2931_ _2930_ _3379_ VGND VGND VPWR VPWR _3103_ sky130_fd_sc_hd__a32o_1
XFILLER_0_74_377 VGND VGND VPWR VPWR sky130_fd_sc_hd__decap_6
X_4796_ _3821_ _3823_ _3822_ VGND VGND VPWR VPWR _0058_ sky130_fd_sc_hd__o21bai_1
X_6604_ _2386_ _2474_ _1282_ _1195_ VGND VGND VPWR VPWR _2031_ sky130_fd_sc_hd__and4_1
XFILLER_0_103_81 VGND VGND VPWR VPWR sky130_fd_sc_hd__decap_8
XFILLER_0_6_165 VPWR VGND VPWR VGND sky130_ef_sc_hd__decap_12
XFILLER_0_15_433 VGND VGND VPWR VPWR sky130_fd_sc_hd__decap_3
X_6535_ _1795_ _1831_ _1954_ _1955_ VGND VGND VPWR VPWR _1956_ sky130_fd_sc_hd__o211a_2
XFILLER_0_30_436 VPWR VGND VPWR VGND sky130_ef_sc_hd__decap_12
X_6466_ _1877_ _1878_ _1863_ VGND VGND VPWR VPWR _1880_ sky130_fd_sc_hd__o21a_1
X_5417_ _0626_ _0695_ _0696_ VGND VGND VPWR VPWR _0734_ sky130_fd_sc_hd__nand3_1
XFILLER_0_30_469 VGND VGND VPWR VPWR sky130_fd_sc_hd__decap_6
X_6397_ _1802_ _1803_ _1804_ VGND VGND VPWR VPWR _1805_ sky130_fd_sc_hd__nand3_2
X_5348_ _2452_ net31 _3267_ _3748_ VGND VGND VPWR VPWR _0659_ sky130_fd_sc_hd__a22o_1
XTAP_TAPCELL_ROW_7_315 VGND VPWR sky130_fd_sc_hd__tapvpwrvgnd_1
XPHY_EDGE_ROW_34_Left_144 VGND VGND VPWR VPWR sky130_fd_sc_hd__decap_3
X_7018_ _2482_ _1096_ _3558_ _0518_ _2483_ VGND VGND VPWR VPWR _2484_ sky130_fd_sc_hd__a221o_1
X_5279_ _0581_ _0582_ _0490_ VGND VGND VPWR VPWR _0585_ sky130_fd_sc_hd__a21o_1
XFILLER_0_97_458 VGND VGND VPWR VPWR sky130_fd_sc_hd__decap_6
XPHY_EDGE_ROW_43_Left_153 VGND VGND VPWR VPWR sky130_fd_sc_hd__decap_3
XFILLER_0_92_141 VGND VGND VPWR VPWR sky130_fd_sc_hd__decap_6
XFILLER_0_65_355 VGND VGND VPWR VPWR sky130_fd_sc_hd__decap_6
XFILLER_0_38_569 VPWR VGND VPWR VGND sky130_ef_sc_hd__decap_12
XFILLER_0_108_457 VPWR VGND VPWR VGND sky130_ef_sc_hd__decap_12
XFILLER_0_92_174 VPWR VGND VPWR VGND sky130_ef_sc_hd__decap_12
XFILLER_0_18_260 VGND VGND VPWR VPWR sky130_fd_sc_hd__decap_3
XFILLER_0_25_219 VGND VGND VPWR VPWR sky130_fd_sc_hd__fill_1
XFILLER_0_18_293 VPWR VGND VPWR VGND sky130_ef_sc_hd__decap_12
XFILLER_0_61_561 VPWR VGND VPWR VGND sky130_ef_sc_hd__decap_12
XFILLER_0_21_425 VGND VGND VPWR VPWR sky130_fd_sc_hd__fill_1
XFILLER_0_21_447 VGND VGND VPWR VPWR sky130_fd_sc_hd__fill_1
XFILLER_0_103_184 VGND VGND VPWR VPWR sky130_fd_sc_hd__decap_6
XPHY_EDGE_ROW_52_Left_162 VGND VGND VPWR VPWR sky130_fd_sc_hd__decap_3
XFILLER_0_84_19 VGND VGND VPWR VPWR sky130_fd_sc_hd__decap_8
XFILLER_0_108_15 VPWR VGND VPWR VGND sky130_ef_sc_hd__decap_12
XFILLER_0_17_57 VGND VGND VPWR VPWR sky130_fd_sc_hd__decap_8
XPHY_EDGE_ROW_61_Left_171 VGND VGND VPWR VPWR sky130_fd_sc_hd__decap_3
XTAP_TAPCELL_ROW_60_924 VGND VPWR sky130_fd_sc_hd__tapvpwrvgnd_1
XTAP_TAPCELL_ROW_32_604 VGND VPWR sky130_fd_sc_hd__tapvpwrvgnd_1
XFILLER_0_83_130 VGND VGND VPWR VPWR sky130_fd_sc_hd__fill_2
XFILLER_0_56_333 VPWR VGND VPWR VGND sky130_ef_sc_hd__decap_12
XFILLER_0_29_558 VGND VGND VPWR VPWR sky130_fd_sc_hd__fill_2
XFILLER_0_33_89 VGND VGND VPWR VPWR sky130_fd_sc_hd__fill_1
X_4650_ _3353_ _3754_ VGND VGND VPWR VPWR _3755_ sky130_fd_sc_hd__nand2_1
XFILLER_0_56_377 VPWR VGND VPWR VGND sky130_ef_sc_hd__decap_12
Xinput21 A[29] VGND VGND VPWR VPWR net21 sky130_fd_sc_hd__buf_1
XTAP_TAPCELL_ROW_12_372 VGND VPWR sky130_fd_sc_hd__tapvpwrvgnd_1
XFILLER_0_4_625 VPWR VGND VPWR VGND sky130_ef_sc_hd__decap_12
Xinput10 A[19] VGND VGND VPWR VPWR net10 sky130_fd_sc_hd__buf_2
Xinput54 B[30] VGND VGND VPWR VPWR net54 sky130_fd_sc_hd__buf_2
X_4581_ _2627_ _3685_ _3686_ VGND VGND VPWR VPWR _3687_ sky130_fd_sc_hd__a21bo_1
XFILLER_0_12_403 VGND VGND VPWR VPWR sky130_fd_sc_hd__decap_4
Xinput32 B[0] VGND VGND VPWR VPWR net32 sky130_fd_sc_hd__clkbuf_4
X_6320_ _1585_ _1684_ _1718_ _1720_ VGND VGND VPWR VPWR _1721_ sky130_fd_sc_hd__a211oi_1
XTAP_TAPCELL_ROW_40_692 VGND VPWR sky130_fd_sc_hd__tapvpwrvgnd_1
Xinput43 B[20] VGND VGND VPWR VPWR net43 sky130_fd_sc_hd__dlymetal6s2s_1
Xinput65 opcode[2] VGND VGND VPWR VPWR net65 sky130_fd_sc_hd__clkbuf_2
XPHY_EDGE_ROW_70_Left_180 VGND VGND VPWR VPWR sky130_fd_sc_hd__decap_3
X_6251_ _1642_ _1644_ _1524_ VGND VGND VPWR VPWR _1646_ sky130_fd_sc_hd__a21oi_1
X_5202_ _0371_ _0498_ VGND VGND VPWR VPWR _0501_ sky130_fd_sc_hd__nor2_1
X_6182_ _1453_ _1459_ VGND VGND VPWR VPWR _1570_ sky130_fd_sc_hd__or2b_1
XFILLER_0_58_97 VPWR VGND VPWR VGND sky130_ef_sc_hd__decap_12
X_5133_ _0309_ _0317_ VGND VGND VPWR VPWR _0425_ sky130_fd_sc_hd__or2b_1
X_5064_ _0239_ _0250_ _0249_ VGND VGND VPWR VPWR _0350_ sky130_fd_sc_hd__a21bo_1
XFILLER_0_74_85 VPWR VGND VPWR VGND sky130_ef_sc_hd__decap_12
X_4015_ _1697_ _1774_ _1861_ _1883_ _1905_ VGND VGND VPWR VPWR _1916_ sky130_fd_sc_hd__a311o_1
XTAP_TAPCELL_ROW_48_792 VGND VPWR sky130_fd_sc_hd__tapvpwrvgnd_1
X_5966_ _1267_ _1268_ _1332_ _1333_ VGND VGND VPWR VPWR _1334_ sky130_fd_sc_hd__and4bb_1
XFILLER_0_47_322 VGND VGND VPWR VPWR sky130_fd_sc_hd__fill_2
X_4917_ _3343_ _3467_ _3536_ VGND VGND VPWR VPWR _0190_ sky130_fd_sc_hd__a21bo_1
XFILLER_0_74_141 VGND VGND VPWR VPWR sky130_fd_sc_hd__decap_4
X_7705_ net84 net87 VGND VGND VPWR VPWR _3235_ sky130_fd_sc_hd__or2_1
X_5897_ _1252_ _1257_ VGND VGND VPWR VPWR _1258_ sky130_fd_sc_hd__xnor2_1
X_7636_ _3156_ _3159_ VGND VGND VPWR VPWR _3160_ sky130_fd_sc_hd__xnor2_1
X_4848_ _3651_ _0089_ _0092_ _3606_ _0114_ VGND VGND VPWR VPWR _0115_ sky130_fd_sc_hd__o221a_1
XFILLER_0_90_645 VGND VGND VPWR VPWR sky130_fd_sc_hd__decap_6
XFILLER_0_7_474 VGND VGND VPWR VPWR sky130_fd_sc_hd__decap_8
XFILLER_0_28_580 VGND VGND VPWR VPWR sky130_fd_sc_hd__decap_8
XFILLER_0_99_71 VGND VGND VPWR VPWR sky130_fd_sc_hd__decap_6
X_7567_ _3082_ _3083_ VGND VGND VPWR VPWR _3084_ sky130_fd_sc_hd__and2b_1
XFILLER_0_15_252 VGND VGND VPWR VPWR sky130_fd_sc_hd__fill_2
X_4779_ _3508_ _3809_ _3810_ _3130_ VGND VGND VPWR VPWR _0040_ sky130_fd_sc_hd__a22oi_2
XFILLER_0_43_561 VPWR VGND VPWR VGND sky130_ef_sc_hd__decap_12
X_7498_ _3007_ _3008_ VGND VGND VPWR VPWR _3009_ sky130_fd_sc_hd__or2_1
X_6518_ _1935_ _1936_ VGND VGND VPWR VPWR _1937_ sky130_fd_sc_hd__xnor2_1
XFILLER_0_30_200 VPWR VGND VPWR VGND sky130_ef_sc_hd__decap_12
X_6449_ _1853_ _1854_ _1859_ VGND VGND VPWR VPWR _1862_ sky130_fd_sc_hd__o21ba_1
XFILLER_0_100_154 VGND VGND VPWR VPWR sky130_fd_sc_hd__fill_1
XFILLER_0_11_480 VGND VGND VPWR VPWR sky130_fd_sc_hd__decap_3
XTAP_TAPCELL_ROW_89_1259 VGND VPWR sky130_fd_sc_hd__tapvpwrvgnd_1
XFILLER_0_38_300 VGND VGND VPWR VPWR sky130_fd_sc_hd__decap_8
XFILLER_0_65_152 VGND VGND VPWR VPWR sky130_fd_sc_hd__fill_1
XFILLER_0_81_645 VGND VGND VPWR VPWR sky130_fd_sc_hd__decap_6
XFILLER_0_80_166 VGND VGND VPWR VPWR sky130_fd_sc_hd__fill_1
XFILLER_0_1_617 VPWR VGND VPWR VGND sky130_ef_sc_hd__decap_12
XFILLER_0_104_482 VPWR VGND VPWR VGND sky130_ef_sc_hd__decap_12
XFILLER_0_0_149 VGND VGND VPWR VPWR sky130_fd_sc_hd__decap_3
XFILLER_0_88_233 VGND VGND VPWR VPWR sky130_fd_sc_hd__decap_4
XTAP_TAPCELL_ROW_66_1001 VGND VPWR sky130_fd_sc_hd__tapvpwrvgnd_1
XTAP_TAPCELL_ROW_109_1495 VGND VPWR sky130_fd_sc_hd__tapvpwrvgnd_1
XFILLER_0_44_55 VPWR VGND VPWR VGND sky130_ef_sc_hd__decap_12
X_5820_ _1170_ _1174_ VGND VGND VPWR VPWR _1175_ sky130_fd_sc_hd__xnor2_1
XTAP_TAPCELL_ROW_17_431 VGND VPWR sky130_fd_sc_hd__tapvpwrvgnd_1
XTAP_TAPCELL_ROW_45_751 VGND VPWR sky130_fd_sc_hd__tapvpwrvgnd_1
X_5751_ _0953_ _1084_ _1087_ _1099_ VGND VGND VPWR VPWR _1100_ sky130_fd_sc_hd__o211a_1
XFILLER_0_8_227 VGND VGND VPWR VPWR sky130_fd_sc_hd__fill_1
X_4702_ _3711_ _3805_ _3806_ _3492_ VGND VGND VPWR VPWR _3807_ sky130_fd_sc_hd__o211a_1
XFILLER_0_72_601 VPWR VGND VPWR VGND sky130_ef_sc_hd__decap_12
XFILLER_0_56_152 VGND VGND VPWR VPWR sky130_fd_sc_hd__fill_1
XFILLER_0_17_528 VGND VGND VPWR VPWR sky130_fd_sc_hd__fill_1
XFILLER_0_29_388 VGND VGND VPWR VPWR sky130_fd_sc_hd__decap_4
XFILLER_0_97_7 VPWR VGND VPWR VGND sky130_ef_sc_hd__decap_12
XFILLER_0_72_645 VGND VGND VPWR VPWR sky130_fd_sc_hd__decap_6
XFILLER_0_71_111 VGND VGND VPWR VPWR sky130_fd_sc_hd__fill_1
X_7421_ _1424_ _3256_ _0769_ VGND VGND VPWR VPWR _2925_ sky130_fd_sc_hd__and3_1
X_5682_ _1022_ _1021_ _1003_ _0875_ VGND VGND VPWR VPWR _1024_ sky130_fd_sc_hd__o211a_1
XFILLER_0_44_336 VGND VGND VPWR VPWR sky130_fd_sc_hd__decap_3
X_4633_ _2430_ _3736_ _3651_ VGND VGND VPWR VPWR _3738_ sky130_fd_sc_hd__a21oi_1
XFILLER_0_25_561 VGND VGND VPWR VPWR sky130_fd_sc_hd__decap_8
X_4564_ _3395_ _3668_ _3670_ VGND VGND VPWR VPWR _3671_ sky130_fd_sc_hd__a21oi_2
X_7352_ _2695_ _2849_ VGND VGND VPWR VPWR _2850_ sky130_fd_sc_hd__xor2_1
X_7283_ _2772_ _2773_ VGND VGND VPWR VPWR _2774_ sky130_fd_sc_hd__or2_1
XFILLER_0_69_52 VGND VGND VPWR VPWR sky130_fd_sc_hd__decap_4
XFILLER_0_12_233 VPWR VGND VPWR VGND sky130_ef_sc_hd__decap_12
XFILLER_0_4_477 VGND VGND VPWR VPWR sky130_fd_sc_hd__decap_4
X_6303_ _1549_ _1554_ VGND VGND VPWR VPWR _1702_ sky130_fd_sc_hd__or2b_1
XFILLER_0_40_531 VGND VGND VPWR VPWR sky130_fd_sc_hd__fill_1
XFILLER_0_52_391 VPWR VGND VPWR VGND sky130_ef_sc_hd__decap_12
X_4495_ _3350_ _3302_ _3598_ _3602_ _3353_ VGND VGND VPWR VPWR _3603_ sky130_fd_sc_hd__a32o_1
X_6234_ _1587_ _1589_ net121 _1626_ VGND VGND VPWR VPWR _1627_ sky130_fd_sc_hd__or4_4
XFILLER_0_40_586 VGND VGND VPWR VPWR sky130_fd_sc_hd__fill_2
XFILLER_0_85_51 VGND VGND VPWR VPWR sky130_fd_sc_hd__fill_1
X_6165_ _2375_ _2441_ _2069_ _0693_ VGND VGND VPWR VPWR _1551_ sky130_fd_sc_hd__and4_1
XFILLER_0_40_3 VGND VGND VPWR VPWR sky130_fd_sc_hd__decap_8
X_5116_ _0108_ _0405_ _3743_ VGND VGND VPWR VPWR _0406_ sky130_fd_sc_hd__mux2_1
X_6096_ _1466_ _1474_ _1475_ VGND VGND VPWR VPWR _1476_ sky130_fd_sc_hd__nand3_2
XFILLER_0_109_91 VGND VGND VPWR VPWR sky130_fd_sc_hd__decap_3
X_5047_ _0323_ _0330_ VGND VGND VPWR VPWR _0331_ sky130_fd_sc_hd__xor2_1
XFILLER_0_39_108 VGND VGND VPWR VPWR sky130_fd_sc_hd__fill_1
X_6998_ _2286_ _2327_ _2460_ _2461_ VGND VGND VPWR VPWR _2462_ sky130_fd_sc_hd__o211a_1
X_5949_ _1312_ _1313_ _1311_ VGND VGND VPWR VPWR _1316_ sky130_fd_sc_hd__o21ai_1
XFILLER_0_75_461 VPWR VGND VPWR VGND sky130_ef_sc_hd__decap_12
XFILLER_0_62_133 VGND VGND VPWR VPWR sky130_fd_sc_hd__decap_6
Xclone24 net57 VGND VGND VPWR VPWR net142 sky130_fd_sc_hd__buf_2
XFILLER_0_90_475 VGND VGND VPWR VPWR sky130_fd_sc_hd__fill_1
X_7619_ _1501_ _0682_ _2926_ _2925_ _1184_ VGND VGND VPWR VPWR _3142_ sky130_fd_sc_hd__a32o_1
XFILLER_0_105_279 VGND VGND VPWR VPWR sky130_fd_sc_hd__fill_1
XFILLER_0_43_391 VGND VGND VPWR VPWR sky130_fd_sc_hd__fill_1
XFILLER_0_98_531 VGND VGND VPWR VPWR sky130_fd_sc_hd__fill_1
XFILLER_0_105_27 VPWR VGND VPWR VGND sky130_ef_sc_hd__decap_12
XTAP_TAPCELL_ROW_14_401 VGND VPWR sky130_fd_sc_hd__tapvpwrvgnd_1
XTAP_TAPCELL_ROW_42_721 VGND VPWR sky130_fd_sc_hd__tapvpwrvgnd_1
XFILLER_0_109_541 VPWR VGND VPWR VGND sky130_ef_sc_hd__decap_12
XFILLER_0_38_141 VPWR VGND VPWR VGND sky130_ef_sc_hd__decap_12
XFILLER_0_54_601 VGND VGND VPWR VPWR sky130_fd_sc_hd__decap_6
XFILLER_0_54_612 VGND VGND VPWR VPWR sky130_fd_sc_hd__decap_8
XFILLER_0_5_219 VGND VGND VPWR VPWR sky130_fd_sc_hd__decap_4
XFILLER_0_5_208 VGND VGND VPWR VPWR sky130_fd_sc_hd__decap_4
XFILLER_0_53_122 VGND VGND VPWR VPWR sky130_fd_sc_hd__decap_6
XFILLER_0_30_24 VGND VGND VPWR VPWR sky130_fd_sc_hd__decap_4
XFILLER_0_53_166 VGND VGND VPWR VPWR sky130_fd_sc_hd__fill_2
XFILLER_0_81_497 VGND VGND VPWR VPWR sky130_fd_sc_hd__fill_2
XFILLER_0_22_553 VGND VGND VPWR VPWR sky130_fd_sc_hd__fill_1
XFILLER_0_22_586 VGND VGND VPWR VPWR sky130_fd_sc_hd__fill_2
X_4280_ _3388_ _3390_ _3391_ VGND VGND VPWR VPWR _3392_ sky130_fd_sc_hd__mux2_1
XFILLER_0_1_469 VGND VGND VPWR VPWR sky130_fd_sc_hd__decap_4
XFILLER_0_39_55 VGND VGND VPWR VPWR sky130_fd_sc_hd__fill_1
XTAP_TAPCELL_ROW_72_1060 VGND VPWR sky130_fd_sc_hd__tapvpwrvgnd_1
XFILLER_0_55_43 VPWR VGND VPWR VGND sky130_ef_sc_hd__decap_12
X_6921_ _2376_ _2377_ VGND VGND VPWR VPWR _2378_ sky130_fd_sc_hd__xnor2_1
XFILLER_0_89_586 VGND VGND VPWR VPWR sky130_fd_sc_hd__fill_1
X_6852_ _0551_ _2000_ _2302_ _0529_ VGND VGND VPWR VPWR _2303_ sky130_fd_sc_hd__o211a_1
XFILLER_0_49_417 VGND VGND VPWR VPWR sky130_fd_sc_hd__fill_1
X_5803_ _1139_ _1141_ _1154_ VGND VGND VPWR VPWR _1156_ sky130_fd_sc_hd__nand3_2
XFILLER_0_9_514 VPWR VGND VPWR VGND sky130_ef_sc_hd__decap_12
X_3995_ _1686_ VGND VGND VPWR VPWR _1697_ sky130_fd_sc_hd__inv_2
XFILLER_0_57_461 VPWR VGND VPWR VGND sky130_ef_sc_hd__decap_12
X_6783_ _1490_ _1949_ VGND VGND VPWR VPWR _2227_ sky130_fd_sc_hd__nand2_1
XFILLER_0_91_239 VPWR VGND VPWR VGND sky130_ef_sc_hd__decap_12
X_5734_ _1249_ _1080_ VGND VGND VPWR VPWR _1081_ sky130_fd_sc_hd__xnor2_1
XFILLER_0_72_475 VGND VGND VPWR VPWR sky130_fd_sc_hd__fill_1
XFILLER_0_60_604 VGND VGND VPWR VPWR sky130_fd_sc_hd__decap_4
X_5665_ _0883_ _0891_ VGND VGND VPWR VPWR _1005_ sky130_fd_sc_hd__or2b_1
XFILLER_0_32_306 VGND VGND VPWR VPWR sky130_fd_sc_hd__fill_2
X_4616_ _3721_ _3388_ VGND VGND VPWR VPWR _3722_ sky130_fd_sc_hd__and2_1
X_7404_ _2364_ _2517_ _0181_ _0922_ VGND VGND VPWR VPWR _2906_ sky130_fd_sc_hd__and4_1
XFILLER_0_88_3 VPWR VGND VPWR VGND sky130_ef_sc_hd__decap_12
XFILLER_0_32_339 VGND VGND VPWR VPWR sky130_fd_sc_hd__fill_1
XFILLER_0_44_188 VGND VGND VPWR VPWR sky130_fd_sc_hd__decap_8
XFILLER_0_102_216 VPWR VGND VPWR VGND sky130_ef_sc_hd__decap_12
X_7335_ _2829_ _2830_ VGND VGND VPWR VPWR _2831_ sky130_fd_sc_hd__nor2_1
XFILLER_0_4_263 VGND VGND VPWR VPWR sky130_fd_sc_hd__decap_8
XFILLER_0_25_391 VGND VGND VPWR VPWR sky130_fd_sc_hd__fill_1
X_5596_ _0737_ _0738_ _0740_ VGND VGND VPWR VPWR _0930_ sky130_fd_sc_hd__a21bo_1
X_4547_ _3607_ _3653_ VGND VGND VPWR VPWR _3654_ sky130_fd_sc_hd__nor2_1
XFILLER_0_40_372 VGND VGND VPWR VPWR sky130_fd_sc_hd__fill_2
X_4478_ _3494_ _3526_ VGND VGND VPWR VPWR _3586_ sky130_fd_sc_hd__or2b_1
X_7266_ _2532_ _2558_ VGND VGND VPWR VPWR _2755_ sky130_fd_sc_hd__nor2_1
XPHY_EDGE_ROW_8_Left_118 VGND VGND VPWR VPWR sky130_fd_sc_hd__decap_3
XFILLER_0_13_597 VPWR VGND VPWR VGND sky130_ef_sc_hd__decap_12
XFILLER_0_96_83 VGND VGND VPWR VPWR sky130_fd_sc_hd__fill_1
X_7197_ _0442_ _2655_ _0420_ VGND VGND VPWR VPWR _2679_ sky130_fd_sc_hd__a21oi_1
X_6217_ _0463_ net148 net12 net10 VGND VGND VPWR VPWR _1608_ sky130_fd_sc_hd__and4_1
X_6148_ _1428_ _1429_ _1447_ _1448_ VGND VGND VPWR VPWR _1532_ sky130_fd_sc_hd__o211ai_2
XFILLER_0_99_306 VPWR VGND VPWR VGND sky130_ef_sc_hd__decap_12
X_6079_ _1381_ _1719_ VGND VGND VPWR VPWR _1458_ sky130_fd_sc_hd__nand2_1
XTAP_TAPCELL_ROW_86_1229 VGND VPWR sky130_fd_sc_hd__tapvpwrvgnd_1
XFILLER_0_67_225 VGND VGND VPWR VPWR sky130_fd_sc_hd__decap_4
XTAP_TAPCELL_ROW_56_879 VGND VPWR sky130_fd_sc_hd__tapvpwrvgnd_1
XTAP_TAPCELL_ROW_28_559 VGND VPWR sky130_fd_sc_hd__tapvpwrvgnd_1
XFILLER_0_36_612 VPWR VGND VPWR VGND sky130_ef_sc_hd__decap_12
XFILLER_0_35_111 VGND VGND VPWR VPWR sky130_fd_sc_hd__fill_1
XFILLER_0_36_645 VGND VGND VPWR VPWR sky130_fd_sc_hd__decap_6
XFILLER_0_106_533 VGND VGND VPWR VPWR sky130_fd_sc_hd__fill_2
XFILLER_0_35_133 VGND VGND VPWR VPWR sky130_fd_sc_hd__decap_3
XTAP_TAPCELL_ROW_97_1347 VGND VPWR sky130_fd_sc_hd__tapvpwrvgnd_1
XFILLER_0_63_497 VGND VGND VPWR VPWR sky130_fd_sc_hd__decap_6
XFILLER_0_35_199 VGND VGND VPWR VPWR sky130_fd_sc_hd__fill_1
XFILLER_0_92_19 VGND VGND VPWR VPWR sky130_fd_sc_hd__decap_8
XTAP_TAPCELL_ROW_106_1454 VGND VPWR sky130_fd_sc_hd__tapvpwrvgnd_1
XFILLER_0_98_361 VGND VGND VPWR VPWR sky130_fd_sc_hd__decap_3
XFILLER_0_86_512 VGND VGND VPWR VPWR sky130_fd_sc_hd__decap_6
XFILLER_0_25_57 VGND VGND VPWR VPWR sky130_fd_sc_hd__decap_8
XFILLER_0_86_567 VGND VGND VPWR VPWR sky130_fd_sc_hd__decap_3
XFILLER_0_86_589 VPWR VGND VPWR VGND sky130_ef_sc_hd__decap_12
XFILLER_0_39_461 VPWR VGND VPWR VGND sky130_ef_sc_hd__decap_12
XFILLER_0_73_228 VPWR VGND VPWR VGND sky130_ef_sc_hd__decap_12
XFILLER_0_6_517 VPWR VGND VPWR VGND sky130_ef_sc_hd__decap_12
XFILLER_0_26_133 VGND VGND VPWR VPWR sky130_fd_sc_hd__decap_4
XFILLER_0_109_393 VGND VGND VPWR VPWR sky130_fd_sc_hd__fill_2
X_5450_ _0753_ _0768_ _0770_ VGND VGND VPWR VPWR _0771_ sky130_fd_sc_hd__nand3_1
XFILLER_0_42_637 VGND VGND VPWR VPWR sky130_fd_sc_hd__decap_6
X_4401_ _3335_ _3321_ net117 _3510_ VGND VGND VPWR VPWR _3511_ sky130_fd_sc_hd__o22a_1
X_5381_ _0692_ _0694_ _0572_ _0628_ VGND VGND VPWR VPWR _0696_ sky130_fd_sc_hd__o211ai_2
XFILLER_0_10_501 VGND VGND VPWR VPWR sky130_fd_sc_hd__decap_4
XFILLER_0_41_169 VGND VGND VPWR VPWR sky130_fd_sc_hd__fill_2
X_4332_ _3345_ net24 VGND VGND VPWR VPWR _3443_ sky130_fd_sc_hd__and2_2
X_7120_ _2592_ _2593_ _2579_ VGND VGND VPWR VPWR _2596_ sky130_fd_sc_hd__o21ai_1
XFILLER_0_1_244 VGND VGND VPWR VPWR sky130_fd_sc_hd__fill_2
X_4263_ _0682_ _0780_ _3317_ VGND VGND VPWR VPWR _3375_ sky130_fd_sc_hd__mux2_1
X_7051_ _2353_ _2506_ _0856_ _1107_ VGND VGND VPWR VPWR _2520_ sky130_fd_sc_hd__and4_1
X_6002_ _1249_ _1348_ VGND VGND VPWR VPWR _1374_ sky130_fd_sc_hd__or2_1
XFILLER_0_10_589 VGND VGND VPWR VPWR sky130_fd_sc_hd__fill_1
X_4194_ _3086_ VGND VGND VPWR VPWR _3306_ sky130_fd_sc_hd__buf_8
XFILLER_0_66_64 VGND VGND VPWR VPWR sky130_fd_sc_hd__fill_1
XFILLER_0_82_41 VPWR VGND VPWR VGND sky130_ef_sc_hd__decap_12
X_6904_ _2347_ _2348_ _2358_ VGND VGND VPWR VPWR _2359_ sky130_fd_sc_hd__and3_1
XTAP_TAPCELL_ROW_25_529 VGND VPWR sky130_fd_sc_hd__tapvpwrvgnd_1
XTAP_TAPCELL_ROW_53_849 VGND VPWR sky130_fd_sc_hd__tapvpwrvgnd_1
XFILLER_0_92_515 VPWR VGND VPWR VGND sky130_ef_sc_hd__decap_12
X_6835_ _2245_ _2246_ _2282_ _2283_ VGND VGND VPWR VPWR _2284_ sky130_fd_sc_hd__nor4_4
XFILLER_0_92_548 VPWR VGND VPWR VGND sky130_ef_sc_hd__decap_12
XFILLER_0_64_239 VGND VGND VPWR VPWR sky130_fd_sc_hd__decap_8
XFILLER_0_64_228 VGND VGND VPWR VPWR sky130_fd_sc_hd__fill_1
X_3978_ _1501_ VGND VGND VPWR VPWR _1512_ sky130_fd_sc_hd__inv_2
XFILLER_0_9_377 VGND VGND VPWR VPWR sky130_fd_sc_hd__decap_8
XFILLER_0_18_645 VGND VGND VPWR VPWR sky130_fd_sc_hd__decap_6
X_6766_ _3810_ _0987_ _1260_ _2353_ VGND VGND VPWR VPWR _2208_ sky130_fd_sc_hd__a22oi_1
X_5717_ _0915_ net150 _1061_ _1060_ VGND VGND VPWR VPWR _1062_ sky130_fd_sc_hd__o211a_4
XFILLER_0_9_399 VGND VGND VPWR VPWR sky130_fd_sc_hd__decap_4
XFILLER_0_17_166 VGND VGND VPWR VPWR sky130_fd_sc_hd__fill_2
XFILLER_0_17_177 VGND VGND VPWR VPWR sky130_fd_sc_hd__fill_2
X_6697_ _1956_ net103 _2131_ _2132_ VGND VGND VPWR VPWR _2133_ sky130_fd_sc_hd__o211ai_4
XFILLER_0_60_445 VPWR VGND VPWR VGND sky130_ef_sc_hd__decap_12
XFILLER_0_32_125 VPWR VGND VPWR VGND sky130_ef_sc_hd__decap_12
X_5648_ _0870_ _0872_ _0871_ VGND VGND VPWR VPWR _0986_ sky130_fd_sc_hd__o21ba_1
XFILLER_0_33_648 VGND VGND VPWR VPWR sky130_fd_sc_hd__decap_4
XFILLER_0_60_489 VGND VGND VPWR VPWR sky130_fd_sc_hd__fill_1
X_5579_ _0907_ _0908_ _0909_ VGND VGND VPWR VPWR _0912_ sky130_fd_sc_hd__a21o_1
XFILLER_0_20_309 VPWR VGND VPWR VGND sky130_ef_sc_hd__decap_12
X_7318_ _2810_ _2811_ VGND VGND VPWR VPWR _2812_ sky130_fd_sc_hd__or2_1
X_7249_ _2047_ _1501_ VGND VGND VPWR VPWR _2737_ sky130_fd_sc_hd__nand2_1
XTAP_TAPCELL_ROW_92_1299 VGND VPWR sky130_fd_sc_hd__tapvpwrvgnd_1
XFILLER_0_99_125 VPWR VGND VPWR VGND sky130_ef_sc_hd__decap_12
XTAP_TAPCELL_ROW_5_298 VGND VPWR sky130_fd_sc_hd__tapvpwrvgnd_1
XFILLER_0_99_169 VPWR VGND VPWR VGND sky130_ef_sc_hd__decap_12
XFILLER_0_99_158 VGND VGND VPWR VPWR sky130_fd_sc_hd__decap_8
XFILLER_0_95_331 VGND VGND VPWR VPWR sky130_fd_sc_hd__decap_4
XFILLER_0_68_589 VPWR VGND VPWR VGND sky130_ef_sc_hd__decap_12
XFILLER_0_11_15 VPWR VGND VPWR VGND sky130_ef_sc_hd__decap_12
XFILLER_0_106_341 VGND VGND VPWR VPWR sky130_fd_sc_hd__decap_6
XTAP_TAPCELL_ROW_101_1395 VGND VPWR sky130_fd_sc_hd__tapvpwrvgnd_1
XFILLER_0_63_261 VPWR VGND VPWR VGND sky130_ef_sc_hd__decap_12
XFILLER_0_63_294 VPWR VGND VPWR VGND sky130_ef_sc_hd__decap_12
Xinput8 A[17] VGND VGND VPWR VPWR net8 sky130_fd_sc_hd__buf_6
XFILLER_0_78_309 VPWR VGND VPWR VGND sky130_ef_sc_hd__decap_12
XFILLER_0_59_501 VGND VGND VPWR VPWR sky130_fd_sc_hd__decap_3
X_4950_ _2353_ _3810_ _3621_ _2561_ VGND VGND VPWR VPWR _0226_ sky130_fd_sc_hd__nand4_1
XFILLER_0_59_589 VGND VGND VPWR VPWR sky130_fd_sc_hd__decap_6
X_3901_ _0660_ VGND VGND VPWR VPWR _0671_ sky130_fd_sc_hd__clkbuf_4
X_4881_ _0146_ _0147_ _0149_ VGND VGND VPWR VPWR _0151_ sky130_fd_sc_hd__a21o_1
X_6620_ _2043_ _2046_ _2048_ VGND VGND VPWR VPWR _2049_ sky130_fd_sc_hd__nand3_2
XTAP_TAPCELL_ROW_50_808 VGND VPWR sky130_fd_sc_hd__tapvpwrvgnd_1
X_6551_ _1965_ _1968_ _1972_ net130 VGND VGND VPWR VPWR _1974_ sky130_fd_sc_hd__nand4_1
X_5502_ _0588_ _0708_ _0709_ _0827_ VGND VGND VPWR VPWR _0828_ sky130_fd_sc_hd__o31a_1
XFILLER_0_14_114 VPWR VGND VPWR VGND sky130_ef_sc_hd__decap_12
X_6482_ _1895_ _1896_ _1897_ VGND VGND VPWR VPWR _1898_ sky130_fd_sc_hd__nand3b_1
XTAP_TAPCELL_ROW_30_576 VGND VPWR sky130_fd_sc_hd__tapvpwrvgnd_1
XTAP_TAPCELL_ROW_30_587 VGND VPWR sky130_fd_sc_hd__tapvpwrvgnd_1
XFILLER_0_42_456 VPWR VGND VPWR VGND sky130_ef_sc_hd__decap_12
X_5433_ _0639_ _0646_ _0751_ VGND VGND VPWR VPWR _0752_ sky130_fd_sc_hd__a21oi_1
XFILLER_0_100_506 VPWR VGND VPWR VGND sky130_ef_sc_hd__decap_12
X_5364_ _0674_ _0675_ _0676_ VGND VGND VPWR VPWR _0677_ sky130_fd_sc_hd__or3_1
X_4315_ _3424_ _3425_ _3312_ VGND VGND VPWR VPWR _3426_ sky130_fd_sc_hd__mux2_1
X_7103_ _2568_ _2576_ VGND VGND VPWR VPWR _2577_ sky130_fd_sc_hd__and2_1
X_5295_ _3468_ _3487_ _3743_ VGND VGND VPWR VPWR _0602_ sky130_fd_sc_hd__mux2_1
X_7034_ _3319_ _0094_ _0137_ _2878_ VGND VGND VPWR VPWR _2501_ sky130_fd_sc_hd__a22oi_1
X_4246_ _3357_ VGND VGND VPWR VPWR _3358_ sky130_fd_sc_hd__buf_2
XPHY_EDGE_ROW_98_Left_208 VGND VGND VPWR VPWR sky130_fd_sc_hd__decap_3
X_4177_ _3196_ _3043_ VGND VGND VPWR VPWR _3289_ sky130_fd_sc_hd__xnor2_4
XTAP_TAPCELL_ROW_58_908 VGND VPWR sky130_fd_sc_hd__tapvpwrvgnd_1
XFILLER_0_97_629 VPWR VGND VPWR VGND sky130_ef_sc_hd__decap_12
XFILLER_0_96_106 VPWR VGND VPWR VGND sky130_ef_sc_hd__decap_12
XTAP_TAPCELL_ROW_2_257 VGND VPWR sky130_fd_sc_hd__tapvpwrvgnd_1
XTAP_TAPCELL_ROW_66_996 VGND VPWR sky130_fd_sc_hd__tapvpwrvgnd_1
XTAP_TAPCELL_ROW_38_676 VGND VPWR sky130_fd_sc_hd__tapvpwrvgnd_1
X_6818_ _3255_ _0413_ VGND VGND VPWR VPWR _2265_ sky130_fd_sc_hd__nor2_1
XFILLER_0_107_105 VGND VGND VPWR VPWR sky130_fd_sc_hd__decap_6
XFILLER_0_18_453 VGND VGND VPWR VPWR sky130_fd_sc_hd__decap_8
XFILLER_0_73_581 VGND VGND VPWR VPWR sky130_fd_sc_hd__fill_1
X_6749_ _2185_ _2186_ _2187_ VGND VGND VPWR VPWR _2190_ sky130_fd_sc_hd__o21ai_1
XTAP_TAPCELL_ROW_94_1317 VGND VPWR sky130_fd_sc_hd__tapvpwrvgnd_1
XFILLER_0_60_253 VPWR VGND VPWR VGND sky130_ef_sc_hd__decap_12
XFILLER_0_21_629 VPWR VGND VPWR VGND sky130_ef_sc_hd__decap_12
XTAP_TAPCELL_ROW_103_1424 VGND VPWR sky130_fd_sc_hd__tapvpwrvgnd_1
XFILLER_0_96_651 VGND VGND VPWR VPWR sky130_fd_sc_hd__fill_1
XFILLER_0_56_526 VGND VGND VPWR VPWR sky130_fd_sc_hd__fill_2
XFILLER_0_83_356 VGND VGND VPWR VPWR sky130_fd_sc_hd__decap_6
XFILLER_0_64_581 VGND VGND VPWR VPWR sky130_fd_sc_hd__decap_6
XFILLER_0_36_250 VGND VGND VPWR VPWR sky130_fd_sc_hd__fill_2
XFILLER_0_98_29 VPWR VGND VPWR VGND sky130_ef_sc_hd__decap_12
XFILLER_0_24_456 VGND VGND VPWR VPWR sky130_fd_sc_hd__fill_2
XFILLER_0_24_489 VGND VGND VPWR VPWR sky130_fd_sc_hd__decap_8
XFILLER_0_11_139 VGND VGND VPWR VPWR sky130_fd_sc_hd__decap_6
XFILLER_0_20_651 VGND VGND VPWR VPWR sky130_fd_sc_hd__fill_1
X_5080_ _0364_ _0365_ _0267_ VGND VGND VPWR VPWR _0368_ sky130_fd_sc_hd__a21bo_1
X_4100_ net25 VGND VGND VPWR VPWR _2846_ sky130_fd_sc_hd__inv_2
X_4031_ _2080_ VGND VGND VPWR VPWR _2091_ sky130_fd_sc_hd__buf_2
XFILLER_0_78_117 VGND VGND VPWR VPWR sky130_fd_sc_hd__fill_2
XTAP_TAPCELL_ROW_69_1032 VGND VPWR sky130_fd_sc_hd__tapvpwrvgnd_1
XFILLER_0_63_32 VPWR VGND VPWR VGND sky130_ef_sc_hd__decap_12
X_5982_ _1076_ _1211_ _1349_ _1350_ _1351_ VGND VGND VPWR VPWR _1352_ sky130_fd_sc_hd__o311a_1
XTAP_TAPCELL_ROW_35_635 VGND VPWR sky130_fd_sc_hd__tapvpwrvgnd_1
X_4933_ _0130_ _0135_ VGND VGND VPWR VPWR _0207_ sky130_fd_sc_hd__or2b_1
XFILLER_0_74_301 VGND VGND VPWR VPWR sky130_fd_sc_hd__decap_6
XTAP_TAPCELL_ROW_63_966 VGND VPWR sky130_fd_sc_hd__tapvpwrvgnd_1
X_7652_ _1086_ _2952_ VGND VGND VPWR VPWR _3178_ sky130_fd_sc_hd__and2_1
XFILLER_0_74_345 VGND VGND VPWR VPWR sky130_fd_sc_hd__decap_4
X_4864_ _3130_ _3809_ _3810_ _2561_ VGND VGND VPWR VPWR _0132_ sky130_fd_sc_hd__and4_1
XANTENNA_13 _3809_ VGND VGND VPWR VPWR sky130_fd_sc_hd__diode_2
XFILLER_0_47_559 VGND VGND VPWR VPWR sky130_fd_sc_hd__fill_1
X_7583_ _1501_ _0780_ VGND VGND VPWR VPWR _3102_ sky130_fd_sc_hd__nand2_1
XFILLER_0_27_261 VGND VGND VPWR VPWR sky130_fd_sc_hd__decap_3
XFILLER_0_34_209 VPWR VGND VPWR VGND sky130_ef_sc_hd__decap_12
X_4795_ _0054_ _0055_ _0053_ VGND VGND VPWR VPWR _0057_ sky130_fd_sc_hd__o21ai_1
X_6603_ _2028_ _2029_ VGND VGND VPWR VPWR _2030_ sky130_fd_sc_hd__xnor2_1
XFILLER_0_6_177 VPWR VGND VPWR VGND sky130_ef_sc_hd__decap_12
XFILLER_0_15_445 VGND VGND VPWR VPWR sky130_fd_sc_hd__decap_3
X_6534_ _1952_ _1953_ _1843_ VGND VGND VPWR VPWR _1955_ sky130_fd_sc_hd__o21ai_1
X_6465_ _1863_ _1877_ _1878_ VGND VGND VPWR VPWR _1879_ sky130_fd_sc_hd__nor3_1
XFILLER_0_70_595 VGND VGND VPWR VPWR sky130_fd_sc_hd__fill_1
X_5416_ _0583_ _0705_ _0706_ VGND VGND VPWR VPWR _0733_ sky130_fd_sc_hd__and3_1
XFILLER_0_100_303 VGND VGND VPWR VPWR sky130_fd_sc_hd__decap_4
X_6396_ _1388_ _1639_ _1638_ VGND VGND VPWR VPWR _1804_ sky130_fd_sc_hd__o21bai_2
XFILLER_0_30_448 VPWR VGND VPWR VGND sky130_ef_sc_hd__decap_12
X_5347_ _2342_ _2495_ _1643_ _3267_ VGND VGND VPWR VPWR _0658_ sky130_fd_sc_hd__nand4_1
XTAP_TAPCELL_ROW_7_316 VGND VPWR sky130_fd_sc_hd__tapvpwrvgnd_1
X_5278_ _0490_ _0581_ _0582_ VGND VGND VPWR VPWR _0583_ sky130_fd_sc_hd__and3_1
X_4229_ _3327_ _3337_ _3340_ VGND VGND VPWR VPWR _3341_ sky130_fd_sc_hd__mux2_1
X_7017_ _0246_ _1360_ _3512_ _0508_ VGND VGND VPWR VPWR _2483_ sky130_fd_sc_hd__a2bb2o_1
XFILLER_0_69_117 VGND VGND VPWR VPWR sky130_fd_sc_hd__decap_4
XFILLER_0_78_651 VGND VGND VPWR VPWR sky130_fd_sc_hd__fill_1
XFILLER_0_108_469 VGND VGND VPWR VPWR sky130_fd_sc_hd__decap_6
XFILLER_0_92_197 VPWR VGND VPWR VGND sky130_ef_sc_hd__decap_12
XFILLER_0_92_186 VGND VGND VPWR VPWR sky130_fd_sc_hd__decap_8
XFILLER_0_46_581 VGND VGND VPWR VPWR sky130_fd_sc_hd__decap_6
XFILLER_0_61_573 VGND VGND VPWR VPWR sky130_fd_sc_hd__decap_8
XFILLER_0_61_551 VGND VGND VPWR VPWR sky130_fd_sc_hd__decap_8
XFILLER_0_0_309 VGND VGND VPWR VPWR sky130_fd_sc_hd__decap_6
XFILLER_0_108_27 VGND VGND VPWR VPWR sky130_fd_sc_hd__fill_1
XFILLER_0_84_621 VPWR VGND VPWR VGND sky130_ef_sc_hd__decap_12
XFILLER_0_56_301 VGND VGND VPWR VPWR sky130_fd_sc_hd__decap_6
XTAP_TAPCELL_ROW_32_605 VGND VPWR sky130_fd_sc_hd__tapvpwrvgnd_1
XFILLER_0_33_35 VPWR VGND VPWR VGND sky130_ef_sc_hd__decap_12
XFILLER_0_33_57 VPWR VGND VPWR VGND sky130_ef_sc_hd__decap_12
XTAP_TAPCELL_ROW_60_925 VGND VPWR sky130_fd_sc_hd__tapvpwrvgnd_1
XFILLER_0_56_345 VPWR VGND VPWR VGND sky130_ef_sc_hd__decap_12
XFILLER_0_56_389 VPWR VGND VPWR VGND sky130_ef_sc_hd__decap_12
XFILLER_0_71_337 VGND VGND VPWR VPWR sky130_fd_sc_hd__fill_2
X_4580_ _3449_ _2474_ _3623_ _3508_ VGND VGND VPWR VPWR _3686_ sky130_fd_sc_hd__a22o_1
Xinput22 A[2] VGND VGND VPWR VPWR net22 sky130_fd_sc_hd__buf_1
Xinput11 A[1] VGND VGND VPWR VPWR net11 sky130_fd_sc_hd__clkbuf_2
Xinput55 B[31] VGND VGND VPWR VPWR net55 sky130_fd_sc_hd__dlymetal6s2s_1
XFILLER_0_109_3 VPWR VGND VPWR VGND sky130_ef_sc_hd__decap_12
XTAP_TAPCELL_ROW_12_373 VGND VPWR sky130_fd_sc_hd__tapvpwrvgnd_1
XFILLER_0_4_637 VGND VGND VPWR VPWR sky130_fd_sc_hd__decap_6
Xinput33 B[11] VGND VGND VPWR VPWR net33 sky130_fd_sc_hd__buf_1
XFILLER_0_24_253 VGND VGND VPWR VPWR sky130_fd_sc_hd__decap_4
XTAP_TAPCELL_ROW_40_693 VGND VPWR sky130_fd_sc_hd__tapvpwrvgnd_1
Xinput44 B[21] VGND VGND VPWR VPWR net44 sky130_fd_sc_hd__buf_2
Xinput66 opcode[3] VGND VGND VPWR VPWR net66 sky130_fd_sc_hd__clkbuf_2
XFILLER_0_3_169 VPWR VGND VPWR VGND sky130_ef_sc_hd__decap_12
XFILLER_0_52_595 VGND VGND VPWR VPWR sky130_fd_sc_hd__fill_2
X_6250_ _1644_ _1642_ _1524_ VGND VGND VPWR VPWR _1645_ sky130_fd_sc_hd__and3_1
X_5201_ _0305_ _0373_ _0498_ VGND VGND VPWR VPWR _0500_ sky130_fd_sc_hd__or3_4
X_6181_ _1437_ _1444_ VGND VGND VPWR VPWR _1569_ sky130_fd_sc_hd__and2_1
X_5132_ _0316_ _0315_ VGND VGND VPWR VPWR _0424_ sky130_fd_sc_hd__or2b_1
XFILLER_0_42_7 VGND VGND VPWR VPWR sky130_fd_sc_hd__fill_1
X_5063_ _0346_ _0347_ _0338_ VGND VGND VPWR VPWR _0349_ sky130_fd_sc_hd__a21o_1
X_4014_ _1894_ _1544_ VGND VGND VPWR VPWR _1905_ sky130_fd_sc_hd__and2b_1
XFILLER_0_79_437 VGND VGND VPWR VPWR sky130_fd_sc_hd__decap_8
XFILLER_0_74_97 VPWR VGND VPWR VGND sky130_ef_sc_hd__decap_12
XTAP_TAPCELL_ROW_48_793 VGND VPWR sky130_fd_sc_hd__tapvpwrvgnd_1
XFILLER_0_59_183 VGND VGND VPWR VPWR sky130_fd_sc_hd__fill_2
X_5965_ _1330_ _1331_ _1192_ _1269_ VGND VGND VPWR VPWR _1333_ sky130_fd_sc_hd__a211o_1
XFILLER_0_90_85 VPWR VGND VPWR VGND sky130_ef_sc_hd__decap_12
XFILLER_0_74_131 VGND VGND VPWR VPWR sky130_fd_sc_hd__decap_8
X_4916_ _0187_ _0097_ _3751_ _3277_ _0188_ VGND VGND VPWR VPWR _0189_ sky130_fd_sc_hd__o221a_1
X_7704_ net82 net86 _3233_ _3232_ VGND VGND VPWR VPWR _3234_ sky130_fd_sc_hd__or4_4
X_5896_ _1255_ _1256_ VGND VGND VPWR VPWR _1257_ sky130_fd_sc_hd__xnor2_1
XFILLER_0_47_345 VGND VGND VPWR VPWR sky130_fd_sc_hd__fill_1
X_7635_ _3157_ _3158_ VGND VGND VPWR VPWR _3159_ sky130_fd_sc_hd__nor2_1
X_4847_ _3747_ _0095_ _0099_ _0113_ VGND VGND VPWR VPWR _0114_ sky130_fd_sc_hd__o211a_1
XFILLER_0_23_90 VGND VGND VPWR VPWR sky130_fd_sc_hd__decap_8
XFILLER_0_35_529 VGND VGND VPWR VPWR sky130_fd_sc_hd__decap_3
X_7566_ _3078_ _3079_ _3080_ _3081_ VGND VGND VPWR VPWR _3083_ sky130_fd_sc_hd__a22o_1
X_4778_ _2922_ _2703_ _3819_ _0037_ VGND VGND VPWR VPWR _0038_ sky130_fd_sc_hd__a31o_1
X_7497_ _3329_ net54 _3006_ VGND VGND VPWR VPWR _3008_ sky130_fd_sc_hd__and3_1
XFILLER_0_15_286 VPWR VGND VPWR VGND sky130_ef_sc_hd__decap_12
X_6517_ _1730_ _0671_ VGND VGND VPWR VPWR _1936_ sky130_fd_sc_hd__nand2_1
XFILLER_0_30_212 VPWR VGND VPWR VGND sky130_ef_sc_hd__decap_12
XFILLER_0_43_573 VPWR VGND VPWR VGND sky130_ef_sc_hd__decap_12
X_6448_ _1853_ _1854_ _1859_ VGND VGND VPWR VPWR _1860_ sky130_fd_sc_hd__nor3b_1
X_6379_ _1782_ _1783_ _1764_ VGND VGND VPWR VPWR _1786_ sky130_fd_sc_hd__a21oi_2
XFILLER_0_97_267 VGND VGND VPWR VPWR sky130_fd_sc_hd__decap_4
XFILLER_0_57_109 VGND VGND VPWR VPWR sky130_fd_sc_hd__decap_3
XFILLER_0_78_470 VGND VGND VPWR VPWR sky130_fd_sc_hd__decap_6
XFILLER_0_66_621 VGND VGND VPWR VPWR sky130_fd_sc_hd__fill_1
XFILLER_0_66_643 VGND VGND VPWR VPWR sky130_fd_sc_hd__fill_1
XFILLER_0_38_323 VPWR VGND VPWR VGND sky130_ef_sc_hd__decap_12
XFILLER_0_108_222 VGND VGND VPWR VPWR sky130_fd_sc_hd__decap_6
XFILLER_0_104_461 VGND VGND VPWR VPWR sky130_fd_sc_hd__decap_3
XFILLER_0_1_629 VPWR VGND VPWR VGND sky130_ef_sc_hd__decap_12
XFILLER_0_104_494 VPWR VGND VPWR VGND sky130_ef_sc_hd__decap_12
XFILLER_0_95_19 VPWR VGND VPWR VGND sky130_ef_sc_hd__decap_12
XTAP_TAPCELL_ROW_109_1496 VGND VPWR sky130_fd_sc_hd__tapvpwrvgnd_1
XTAP_TAPCELL_ROW_109_1485 VGND VPWR sky130_fd_sc_hd__tapvpwrvgnd_1
XFILLER_0_76_407 VPWR VGND VPWR VGND sky130_ef_sc_hd__decap_12
XFILLER_0_44_67 VPWR VGND VPWR VGND sky130_ef_sc_hd__decap_12
XFILLER_0_57_610 VGND VGND VPWR VPWR sky130_fd_sc_hd__decap_6
XTAP_TAPCELL_ROW_17_432 VGND VPWR sky130_fd_sc_hd__tapvpwrvgnd_1
XTAP_TAPCELL_ROW_45_752 VGND VPWR sky130_fd_sc_hd__tapvpwrvgnd_1
X_5750_ _1088_ _1093_ _1095_ _1098_ VGND VGND VPWR VPWR _1099_ sky130_fd_sc_hd__o211a_1
XFILLER_0_84_451 VGND VGND VPWR VPWR sky130_fd_sc_hd__decap_4
X_4701_ _3711_ _3805_ VGND VGND VPWR VPWR _3806_ sky130_fd_sc_hd__nand2_1
XFILLER_0_72_613 VPWR VGND VPWR VGND sky130_ef_sc_hd__decap_12
X_5681_ _1003_ _0875_ _1021_ _1022_ VGND VGND VPWR VPWR _1023_ sky130_fd_sc_hd__a211oi_4
X_7420_ _2715_ _2724_ VGND VGND VPWR VPWR _2924_ sky130_fd_sc_hd__nand2_1
X_4632_ _2430_ _3736_ VGND VGND VPWR VPWR _3737_ sky130_fd_sc_hd__or2_1
XFILLER_0_60_77 VGND VGND VPWR VPWR sky130_fd_sc_hd__decap_3
XFILLER_0_56_197 VGND VGND VPWR VPWR sky130_fd_sc_hd__decap_3
XFILLER_0_56_175 VGND VGND VPWR VPWR sky130_fd_sc_hd__decap_6
XFILLER_0_4_434 VGND VGND VPWR VPWR sky130_fd_sc_hd__decap_4
X_4563_ _3339_ _3436_ _3669_ _3342_ VGND VGND VPWR VPWR _3670_ sky130_fd_sc_hd__o211a_1
XTAP_TAPCELL_ROW_77_1120 VGND VPWR sky130_fd_sc_hd__tapvpwrvgnd_1
X_7351_ _2847_ _2848_ VGND VGND VPWR VPWR _2849_ sky130_fd_sc_hd__xnor2_1
XFILLER_0_4_445 VPWR VGND VPWR VGND sky130_ef_sc_hd__decap_12
X_4494_ _3407_ _3321_ _3108_ _3601_ VGND VGND VPWR VPWR _3602_ sky130_fd_sc_hd__a31o_1
X_7282_ _2763_ _2771_ VGND VGND VPWR VPWR _2773_ sky130_fd_sc_hd__nor2_1
XFILLER_0_12_245 VGND VGND VPWR VPWR sky130_fd_sc_hd__fill_1
X_6302_ _1699_ _1700_ VGND VGND VPWR VPWR _1701_ sky130_fd_sc_hd__or2_1
XFILLER_0_100_61 VGND VGND VPWR VPWR sky130_fd_sc_hd__fill_2
X_6233_ _1623_ _1624_ _1480_ _1590_ VGND VGND VPWR VPWR _1626_ sky130_fd_sc_hd__o211a_1
XFILLER_0_0_651 VGND VGND VPWR VPWR sky130_fd_sc_hd__fill_1
X_6164_ _3772_ _2069_ _0693_ _3777_ VGND VGND VPWR VPWR _1550_ sky130_fd_sc_hd__a22oi_1
X_5115_ _0285_ _0404_ _3482_ VGND VGND VPWR VPWR _0405_ sky130_fd_sc_hd__mux2_1
X_6095_ _1472_ _1471_ _1473_ VGND VGND VPWR VPWR _1475_ sky130_fd_sc_hd__a21o_1
X_5046_ _0324_ _0329_ VGND VGND VPWR VPWR _0330_ sky130_fd_sc_hd__xnor2_1
XFILLER_0_33_3 VPWR VGND VPWR VGND sky130_ef_sc_hd__decap_12
X_6997_ _2434_ _2435_ _2458_ _2459_ VGND VGND VPWR VPWR _2461_ sky130_fd_sc_hd__a22o_1
X_5948_ _1311_ _1312_ _1313_ VGND VGND VPWR VPWR _1314_ sky130_fd_sc_hd__or3_4
XFILLER_0_75_473 VPWR VGND VPWR VGND sky130_ef_sc_hd__decap_12
Xclone14 net42 VGND VGND VPWR VPWR net132 sky130_fd_sc_hd__buf_4
XFILLER_0_7_250 VGND VGND VPWR VPWR sky130_fd_sc_hd__fill_1
Xclone25 net56 VGND VGND VPWR VPWR net143 sky130_fd_sc_hd__buf_6
XFILLER_0_35_337 VGND VGND VPWR VPWR sky130_fd_sc_hd__decap_6
X_5879_ _0984_ _1113_ VGND VGND VPWR VPWR _1239_ sky130_fd_sc_hd__nor2_1
XFILLER_0_105_225 VPWR VGND VPWR VGND sky130_ef_sc_hd__decap_12
X_7618_ _2972_ _2978_ _2980_ VGND VGND VPWR VPWR _3140_ sky130_fd_sc_hd__a21oi_2
XFILLER_0_50_307 VGND VGND VPWR VPWR sky130_fd_sc_hd__fill_1
X_7549_ _0464_ _3063_ VGND VGND VPWR VPWR _3065_ sky130_fd_sc_hd__xnor2_1
XFILLER_0_90_487 VPWR VGND VPWR VGND sky130_ef_sc_hd__decap_12
XFILLER_0_98_565 VGND VGND VPWR VPWR sky130_fd_sc_hd__decap_4
XFILLER_0_58_407 VGND VGND VPWR VPWR sky130_fd_sc_hd__decap_8
XFILLER_0_105_39 VPWR VGND VPWR VGND sky130_ef_sc_hd__decap_12
XFILLER_0_14_15 VPWR VGND VPWR VGND sky130_ef_sc_hd__decap_12
XTAP_TAPCELL_ROW_14_402 VGND VPWR sky130_fd_sc_hd__tapvpwrvgnd_1
XTAP_TAPCELL_ROW_42_722 VGND VPWR sky130_fd_sc_hd__tapvpwrvgnd_1
XFILLER_0_109_531 VGND VGND VPWR VPWR sky130_fd_sc_hd__fill_1
XFILLER_0_66_462 VPWR VGND VPWR VGND sky130_ef_sc_hd__decap_12
XFILLER_0_38_153 VPWR VGND VPWR VGND sky130_ef_sc_hd__decap_12
XFILLER_0_109_553 VGND VGND VPWR VPWR sky130_fd_sc_hd__decap_6
XFILLER_0_81_410 VGND VGND VPWR VPWR sky130_fd_sc_hd__fill_2
XFILLER_0_26_315 VGND VGND VPWR VPWR sky130_fd_sc_hd__decap_3
XFILLER_0_38_175 VGND VGND VPWR VPWR sky130_fd_sc_hd__decap_8
XFILLER_0_38_197 VGND VGND VPWR VPWR sky130_fd_sc_hd__fill_1
XTAP_TAPCELL_ROW_22_490 VGND VPWR sky130_fd_sc_hd__tapvpwrvgnd_1
XFILLER_0_30_58 VGND VGND VPWR VPWR sky130_fd_sc_hd__decap_6
XFILLER_0_1_437 VGND VGND VPWR VPWR sky130_fd_sc_hd__fill_2
XTAP_TAPCELL_ROW_72_1061 VGND VPWR sky130_fd_sc_hd__tapvpwrvgnd_1
XFILLER_0_55_55 VGND VGND VPWR VPWR sky130_fd_sc_hd__fill_1
X_6920_ _1544_ _0671_ VGND VGND VPWR VPWR _2377_ sky130_fd_sc_hd__nand2_1
X_6851_ _0606_ _0617_ VGND VGND VPWR VPWR _2302_ sky130_fd_sc_hd__and2_1
XFILLER_0_71_54 VGND VGND VPWR VPWR sky130_fd_sc_hd__fill_2
X_5802_ _1139_ _1141_ _1154_ VGND VGND VPWR VPWR _1155_ sky130_fd_sc_hd__a21o_2
XFILLER_0_9_526 VGND VGND VPWR VPWR sky130_fd_sc_hd__decap_3
XTAP_TAPCELL_ROW_83_1190 VGND VPWR sky130_fd_sc_hd__tapvpwrvgnd_1
X_3994_ _1632_ _1675_ VGND VGND VPWR VPWR _1686_ sky130_fd_sc_hd__and2b_1
XFILLER_0_57_473 VPWR VGND VPWR VGND sky130_ef_sc_hd__decap_12
XFILLER_0_9_559 VGND VGND VPWR VPWR sky130_fd_sc_hd__fill_1
XFILLER_0_9_537 VGND VGND VPWR VPWR sky130_fd_sc_hd__decap_8
X_6782_ _2224_ _2225_ VGND VGND VPWR VPWR _2226_ sky130_fd_sc_hd__or2_1
XFILLER_0_91_229 VGND VGND VPWR VPWR sky130_fd_sc_hd__fill_1
XFILLER_0_84_270 VGND VGND VPWR VPWR sky130_fd_sc_hd__decap_3
XFILLER_0_72_421 VPWR VGND VPWR VGND sky130_ef_sc_hd__decap_12
X_5733_ _1079_ _0957_ _2233_ VGND VGND VPWR VPWR _1080_ sky130_fd_sc_hd__a21o_1
XFILLER_0_17_337 VPWR VGND VPWR VGND sky130_ef_sc_hd__decap_12
X_5664_ _0884_ _0890_ VGND VGND VPWR VPWR _1004_ sky130_fd_sc_hd__or2b_1
X_4615_ _3312_ _3320_ VGND VGND VPWR VPWR _3721_ sky130_fd_sc_hd__nor2_1
X_7403_ _2517_ _0181_ _0922_ _2364_ VGND VGND VPWR VPWR _2905_ sky130_fd_sc_hd__a22oi_1
X_5595_ _0923_ _0928_ VGND VGND VPWR VPWR _0929_ sky130_fd_sc_hd__xnor2_2
X_4546_ _2594_ _2638_ VGND VGND VPWR VPWR _3653_ sky130_fd_sc_hd__nor2_1
X_7334_ _2827_ _2828_ _2814_ _2815_ VGND VGND VPWR VPWR _2830_ sky130_fd_sc_hd__o211a_1
XFILLER_0_102_228 VGND VGND VPWR VPWR sky130_fd_sc_hd__decap_4
X_7265_ _2752_ _2753_ VGND VGND VPWR VPWR _2754_ sky130_fd_sc_hd__or2b_1
X_4477_ _3584_ _3582_ VGND VGND VPWR VPWR _3585_ sky130_fd_sc_hd__xnor2_2
X_7196_ _0333_ _0355_ VGND VGND VPWR VPWR _2678_ sky130_fd_sc_hd__nor2_1
X_6216_ _1605_ _1606_ VGND VGND VPWR VPWR _1607_ sky130_fd_sc_hd__xor2_1
X_6147_ _1418_ net115 VGND VGND VPWR VPWR _1531_ sky130_fd_sc_hd__nor2_1
XFILLER_0_99_318 VPWR VGND VPWR VGND sky130_ef_sc_hd__decap_12
X_6078_ _1454_ _1455_ VGND VGND VPWR VPWR _1456_ sky130_fd_sc_hd__nor2_1
X_5029_ _2911_ _2889_ _1796_ _1610_ VGND VGND VPWR VPWR _0312_ sky130_fd_sc_hd__and4_1
XFILLER_0_95_502 VGND VGND VPWR VPWR sky130_fd_sc_hd__fill_2
XFILLER_0_67_237 VPWR VGND VPWR VGND sky130_ef_sc_hd__decap_12
XPHY_EDGE_ROW_109_Left_219 VGND VGND VPWR VPWR sky130_fd_sc_hd__decap_3
XFILLER_0_48_451 VPWR VGND VPWR VGND sky130_ef_sc_hd__decap_12
XFILLER_0_75_281 VPWR VGND VPWR VGND sky130_ef_sc_hd__decap_12
XFILLER_0_36_624 VGND VGND VPWR VPWR sky130_fd_sc_hd__fill_1
XFILLER_0_35_145 VPWR VGND VPWR VGND sky130_ef_sc_hd__decap_12
XFILLER_0_51_605 VGND VGND VPWR VPWR sky130_fd_sc_hd__decap_8
XTAP_TAPCELL_ROW_97_1348 VGND VPWR sky130_fd_sc_hd__tapvpwrvgnd_1
XFILLER_0_106_589 VPWR VGND VPWR VGND sky130_ef_sc_hd__decap_12
XFILLER_0_50_137 VGND VGND VPWR VPWR sky130_fd_sc_hd__decap_3
XFILLER_0_51_649 VGND VGND VPWR VPWR sky130_fd_sc_hd__decap_3
XFILLER_0_31_384 VGND VGND VPWR VPWR sky130_fd_sc_hd__decap_8
XFILLER_0_86_524 VGND VGND VPWR VPWR sky130_fd_sc_hd__decap_8
XTAP_TAPCELL_ROW_106_1455 VGND VPWR sky130_fd_sc_hd__tapvpwrvgnd_1
XFILLER_0_58_248 VGND VGND VPWR VPWR sky130_fd_sc_hd__decap_4
XFILLER_0_41_46 VGND VGND VPWR VPWR sky130_fd_sc_hd__decap_3
XFILLER_0_41_57 VGND VGND VPWR VPWR sky130_fd_sc_hd__decap_8
XFILLER_0_54_421 VGND VGND VPWR VPWR sky130_fd_sc_hd__decap_4
XFILLER_0_6_529 VGND VGND VPWR VPWR sky130_fd_sc_hd__decap_3
XFILLER_0_14_329 VGND VGND VPWR VPWR sky130_fd_sc_hd__fill_1
X_4400_ _3405_ _3509_ VGND VGND VPWR VPWR _3510_ sky130_fd_sc_hd__nor2_1
X_5380_ _0572_ _0628_ _0692_ _0694_ VGND VGND VPWR VPWR _0695_ sky130_fd_sc_hd__a211o_4
X_4331_ _3353_ _3423_ _3440_ _3441_ VGND VGND VPWR VPWR _3442_ sky130_fd_sc_hd__a22o_1
XFILLER_0_22_384 VPWR VGND VPWR VGND sky130_ef_sc_hd__decap_12
X_4262_ _3371_ _3373_ VGND VGND VPWR VPWR _3374_ sky130_fd_sc_hd__nand2_4
X_7050_ _2340_ _2341_ VGND VGND VPWR VPWR _2519_ sky130_fd_sc_hd__nor2_1
X_6001_ _3300_ _3612_ _1363_ _1372_ VGND VGND VPWR VPWR _1373_ sky130_fd_sc_hd__o211a_1
XFILLER_0_5_57 VPWR VGND VPWR VGND sky130_ef_sc_hd__decap_12
X_4193_ _1675_ VGND VGND VPWR VPWR _3305_ sky130_fd_sc_hd__clkbuf_4
XFILLER_0_82_53 VGND VGND VPWR VPWR sky130_fd_sc_hd__decap_8
X_6903_ _2349_ _2357_ VGND VGND VPWR VPWR _2358_ sky130_fd_sc_hd__xnor2_1
XFILLER_0_82_97 VGND VGND VPWR VPWR sky130_fd_sc_hd__fill_2
XFILLER_0_77_535 VPWR VGND VPWR VGND sky130_ef_sc_hd__decap_12
XTAP_TAPCELL_ROW_25_519 VGND VPWR sky130_fd_sc_hd__tapvpwrvgnd_1
X_6834_ _2280_ _2281_ _2247_ _2056_ VGND VGND VPWR VPWR _2283_ sky130_fd_sc_hd__o211a_1
XFILLER_0_107_309 VGND VGND VPWR VPWR sky130_fd_sc_hd__fill_1
XFILLER_0_92_527 VGND VGND VPWR VPWR sky130_fd_sc_hd__decap_4
XFILLER_0_57_281 VGND VGND VPWR VPWR sky130_fd_sc_hd__fill_2
XFILLER_0_17_101 VGND VGND VPWR VPWR sky130_fd_sc_hd__decap_8
X_6765_ _3809_ _3810_ _0987_ _1260_ VGND VGND VPWR VPWR _2207_ sky130_fd_sc_hd__and4_1
X_3977_ _1490_ VGND VGND VPWR VPWR _1501_ sky130_fd_sc_hd__buf_4
X_5716_ _1023_ _1024_ _1058_ _1059_ VGND VGND VPWR VPWR _1061_ sky130_fd_sc_hd__o22ai_2
XFILLER_0_45_443 VGND VGND VPWR VPWR sky130_fd_sc_hd__decap_4
XFILLER_0_72_251 VGND VGND VPWR VPWR sky130_fd_sc_hd__fill_1
XFILLER_0_60_402 VGND VGND VPWR VPWR sky130_fd_sc_hd__decap_4
X_6696_ _2129_ _2130_ _2004_ VGND VGND VPWR VPWR _2132_ sky130_fd_sc_hd__a21o_1
XFILLER_0_103_515 VGND VGND VPWR VPWR sky130_fd_sc_hd__fill_2
XFILLER_0_60_457 VGND VGND VPWR VPWR sky130_fd_sc_hd__decap_4
XFILLER_0_32_137 VGND VGND VPWR VPWR sky130_fd_sc_hd__decap_3
X_5647_ _3287_ _0802_ _0926_ _0925_ VGND VGND VPWR VPWR _0985_ sky130_fd_sc_hd__a31oi_2
XFILLER_0_103_559 VGND VGND VPWR VPWR sky130_fd_sc_hd__fill_1
X_5578_ _0907_ _0908_ _0909_ VGND VGND VPWR VPWR _0910_ sky130_fd_sc_hd__nand3_4
X_7317_ _2803_ _2809_ VGND VGND VPWR VPWR _2811_ sky130_fd_sc_hd__nor2_1
X_4529_ _3633_ _3634_ _3627_ VGND VGND VPWR VPWR _3636_ sky130_fd_sc_hd__a21o_1
X_7248_ _2733_ _2734_ VGND VGND VPWR VPWR _2735_ sky130_fd_sc_hd__nor2_1
XTAP_TAPCELL_ROW_92_1289 VGND VPWR sky130_fd_sc_hd__tapvpwrvgnd_1
X_7179_ _0382_ _1367_ _2659_ _1985_ VGND VGND VPWR VPWR _2661_ sky130_fd_sc_hd__a211o_1
XFILLER_0_99_137 VPWR VGND VPWR VGND sky130_ef_sc_hd__decap_12
XTAP_TAPCELL_ROW_5_299 VGND VPWR sky130_fd_sc_hd__tapvpwrvgnd_1
XFILLER_0_95_310 VGND VGND VPWR VPWR sky130_fd_sc_hd__fill_1
XFILLER_0_83_516 VGND VGND VPWR VPWR sky130_fd_sc_hd__decap_6
XFILLER_0_83_505 VGND VGND VPWR VPWR sky130_fd_sc_hd__decap_6
XFILLER_0_83_527 VGND VGND VPWR VPWR sky130_fd_sc_hd__fill_1
XFILLER_0_102_29 VPWR VGND VPWR VGND sky130_ef_sc_hd__decap_12
XTAP_TAPCELL_ROW_101_1396 VGND VPWR sky130_fd_sc_hd__tapvpwrvgnd_1
XFILLER_0_91_571 VGND VGND VPWR VPWR sky130_fd_sc_hd__decap_3
XFILLER_0_63_273 VGND VGND VPWR VPWR sky130_fd_sc_hd__decap_6
XFILLER_0_11_27 VPWR VGND VPWR VGND sky130_ef_sc_hd__decap_12
XFILLER_0_106_353 VGND VGND VPWR VPWR sky130_fd_sc_hd__decap_8
XFILLER_0_106_397 VGND VGND VPWR VPWR sky130_fd_sc_hd__fill_2
Xinput9 A[18] VGND VGND VPWR VPWR net9 sky130_fd_sc_hd__clkbuf_4
XFILLER_0_59_535 VPWR VGND VPWR VGND sky130_ef_sc_hd__decap_12
XFILLER_0_59_524 VGND VGND VPWR VPWR sky130_fd_sc_hd__fill_1
XFILLER_0_86_365 VGND VGND VPWR VPWR sky130_fd_sc_hd__decap_3
XFILLER_0_86_354 VGND VGND VPWR VPWR sky130_fd_sc_hd__fill_1
X_3900_ net7 VGND VGND VPWR VPWR _0660_ sky130_fd_sc_hd__buf_8
X_4880_ _0146_ _0147_ _0149_ VGND VGND VPWR VPWR _0150_ sky130_fd_sc_hd__nand3_1
XTAP_TAPCELL_ROW_50_809 VGND VPWR sky130_fd_sc_hd__tapvpwrvgnd_1
XTAP_TAPCELL_ROW_80_1160 VGND VPWR sky130_fd_sc_hd__tapvpwrvgnd_1
XFILLER_0_6_304 VGND VGND VPWR VPWR sky130_fd_sc_hd__decap_4
XFILLER_0_39_281 VPWR VGND VPWR VGND sky130_ef_sc_hd__decap_12
X_6550_ _0831_ _1347_ _1969_ _1967_ VGND VGND VPWR VPWR _1973_ sky130_fd_sc_hd__or4_4
XFILLER_0_15_605 VGND VGND VPWR VPWR sky130_fd_sc_hd__decap_8
X_5501_ _0492_ _0586_ _0705_ _0706_ VGND VGND VPWR VPWR _0827_ sky130_fd_sc_hd__nand4_1
XFILLER_0_54_251 VGND VGND VPWR VPWR sky130_fd_sc_hd__fill_1
XFILLER_0_14_126 VPWR VGND VPWR VGND sky130_ef_sc_hd__decap_12
XFILLER_0_15_649 VGND VGND VPWR VPWR sky130_fd_sc_hd__decap_3
XTAP_TAPCELL_ROW_30_577 VGND VPWR sky130_fd_sc_hd__tapvpwrvgnd_1
X_6481_ _2036_ _1457_ _1807_ _1610_ VGND VGND VPWR VPWR _1897_ sky130_fd_sc_hd__nand4_1
XFILLER_0_72_7 VPWR VGND VPWR VGND sky130_ef_sc_hd__decap_12
XFILLER_0_2_510 VGND VGND VPWR VPWR sky130_fd_sc_hd__fill_1
XFILLER_0_2_521 VGND VGND VPWR VPWR sky130_fd_sc_hd__fill_1
X_5432_ _0645_ _0644_ VGND VGND VPWR VPWR _0751_ sky130_fd_sc_hd__and2b_1
XFILLER_0_42_468 VGND VGND VPWR VPWR sky130_fd_sc_hd__fill_1
XFILLER_0_77_20 VGND VGND VPWR VPWR sky130_fd_sc_hd__fill_1
X_5363_ _3520_ net4 _1927_ _0242_ VGND VGND VPWR VPWR _0676_ sky130_fd_sc_hd__a22oi_2
XFILLER_0_22_170 VPWR VGND VPWR VGND sky130_ef_sc_hd__decap_12
X_4314_ _1271_ _1009_ _3307_ VGND VGND VPWR VPWR _3425_ sky130_fd_sc_hd__mux2_1
X_7102_ _2574_ _2575_ VGND VGND VPWR VPWR _2576_ sky130_fd_sc_hd__xnor2_1
X_5294_ _3262_ _0599_ _0600_ VGND VGND VPWR VPWR _0601_ sky130_fd_sc_hd__a21bo_1
XFILLER_0_10_365 VPWR VGND VPWR VGND sky130_ef_sc_hd__decap_12
X_4245_ net66 _3294_ net65 VGND VGND VPWR VPWR _3357_ sky130_fd_sc_hd__or3b_2
X_7033_ _2878_ _3319_ _0094_ _0137_ VGND VGND VPWR VPWR _2500_ sky130_fd_sc_hd__and4_1
XFILLER_0_10_398 VPWR VGND VPWR VGND sky130_ef_sc_hd__decap_12
XFILLER_0_93_41 VGND VGND VPWR VPWR sky130_fd_sc_hd__fill_2
X_4176_ _3086_ VGND VGND VPWR VPWR _3288_ sky130_fd_sc_hd__inv_2
XTAP_TAPCELL_ROW_58_909 VGND VPWR sky130_fd_sc_hd__tapvpwrvgnd_1
XFILLER_0_96_118 VGND VGND VPWR VPWR sky130_fd_sc_hd__decap_8
XTAP_TAPCELL_ROW_2_258 VGND VPWR sky130_fd_sc_hd__tapvpwrvgnd_1
XTAP_TAPCELL_ROW_66_997 VGND VPWR sky130_fd_sc_hd__tapvpwrvgnd_1
XTAP_TAPCELL_ROW_38_677 VGND VPWR sky130_fd_sc_hd__tapvpwrvgnd_1
XFILLER_0_65_538 VGND VGND VPWR VPWR sky130_fd_sc_hd__fill_2
XFILLER_0_9_120 VGND VGND VPWR VPWR sky130_fd_sc_hd__decap_3
X_6817_ _2044_ _2046_ VGND VGND VPWR VPWR _2264_ sky130_fd_sc_hd__nand2_1
XFILLER_0_18_421 VGND VGND VPWR VPWR sky130_fd_sc_hd__decap_8
XFILLER_0_18_487 VGND VGND VPWR VPWR sky130_fd_sc_hd__decap_8
X_6748_ _2185_ _2186_ _2187_ VGND VGND VPWR VPWR _2188_ sky130_fd_sc_hd__or3_1
X_6679_ _2098_ _2099_ _2112_ VGND VGND VPWR VPWR _2114_ sky130_fd_sc_hd__a21oi_1
XFILLER_0_33_435 VGND VGND VPWR VPWR sky130_fd_sc_hd__fill_2
XTAP_TAPCELL_ROW_94_1318 VGND VPWR sky130_fd_sc_hd__tapvpwrvgnd_1
XFILLER_0_60_265 VPWR VGND VPWR VGND sky130_ef_sc_hd__decap_12
XFILLER_0_68_321 VPWR VGND VPWR VGND sky130_ef_sc_hd__decap_12
XTAP_TAPCELL_ROW_103_1425 VGND VPWR sky130_fd_sc_hd__tapvpwrvgnd_1
XFILLER_0_68_365 VGND VGND VPWR VPWR sky130_fd_sc_hd__decap_3
XFILLER_0_68_376 VGND VGND VPWR VPWR sky130_fd_sc_hd__decap_6
XFILLER_0_22_15 VGND VGND VPWR VPWR sky130_fd_sc_hd__decap_4
XFILLER_0_83_335 VGND VGND VPWR VPWR sky130_fd_sc_hd__fill_1
XFILLER_0_71_508 VPWR VGND VPWR VGND sky130_ef_sc_hd__decap_12
XFILLER_0_22_59 VPWR VGND VPWR VGND sky130_ef_sc_hd__decap_12
XFILLER_0_24_402 VPWR VGND VPWR VGND sky130_ef_sc_hd__decap_12
XFILLER_0_64_593 VGND VGND VPWR VPWR sky130_fd_sc_hd__fill_1
XPHY_EDGE_ROW_10_Right_10 VGND VGND VPWR VPWR sky130_fd_sc_hd__decap_3
X_4030_ _2069_ VGND VGND VPWR VPWR _2080_ sky130_fd_sc_hd__clkbuf_4
XTAP_TAPCELL_ROW_69_1033 VGND VPWR sky130_fd_sc_hd__tapvpwrvgnd_1
XFILLER_0_87_641 VGND VGND VPWR VPWR sky130_fd_sc_hd__decap_8
X_5981_ _1103_ _1208_ _1209_ VGND VGND VPWR VPWR _1351_ sky130_fd_sc_hd__or3_1
X_7720_ _0506_ _3211_ _3245_ _3249_ VGND VGND VPWR VPWR net67 sky130_fd_sc_hd__a31o_1
X_4932_ _0078_ _0171_ VGND VGND VPWR VPWR _0206_ sky130_fd_sc_hd__nor2_1
XFILLER_0_63_99 VGND VGND VPWR VPWR sky130_fd_sc_hd__decap_3
XTAP_TAPCELL_ROW_63_956 VGND VPWR sky130_fd_sc_hd__tapvpwrvgnd_1
XTAP_TAPCELL_ROW_35_636 VGND VPWR sky130_fd_sc_hd__tapvpwrvgnd_1
XFILLER_0_47_505 VGND VGND VPWR VPWR sky130_fd_sc_hd__fill_2
X_7651_ _3175_ _3176_ VGND VGND VPWR VPWR _3177_ sky130_fd_sc_hd__xnor2_1
XFILLER_0_74_313 VGND VGND VPWR VPWR sky130_fd_sc_hd__fill_1
XFILLER_0_47_527 VGND VGND VPWR VPWR sky130_fd_sc_hd__decap_8
XFILLER_0_86_195 VGND VGND VPWR VPWR sky130_fd_sc_hd__fill_1
XFILLER_0_6_101 VPWR VGND VPWR VGND sky130_ef_sc_hd__decap_12
XANTENNA_14 net143 VGND VGND VPWR VPWR sky130_fd_sc_hd__diode_2
X_4863_ _2922_ _2353_ _2506_ _2561_ VGND VGND VPWR VPWR _0131_ sky130_fd_sc_hd__a22oi_1
X_6602_ _3334_ net46 VGND VGND VPWR VPWR _2029_ sky130_fd_sc_hd__nand2_1
X_7582_ _3099_ _3100_ VGND VGND VPWR VPWR _3101_ sky130_fd_sc_hd__nand2_1
X_4794_ _0053_ _0054_ _0055_ VGND VGND VPWR VPWR _0056_ sky130_fd_sc_hd__or3_1
XFILLER_0_27_284 VPWR VGND VPWR VGND sky130_ef_sc_hd__decap_12
X_6533_ _1843_ _1952_ _1953_ VGND VGND VPWR VPWR _1954_ sky130_fd_sc_hd__or3_1
XFILLER_0_6_189 VGND VGND VPWR VPWR sky130_fd_sc_hd__decap_6
X_6464_ _1874_ _1875_ _1876_ VGND VGND VPWR VPWR _1878_ sky130_fd_sc_hd__a21oi_2
XFILLER_0_42_243 VGND VGND VPWR VPWR sky130_fd_sc_hd__decap_8
XFILLER_0_88_41 VGND VGND VPWR VPWR sky130_fd_sc_hd__decap_4
X_5415_ _3492_ _0711_ _0712_ _0732_ VGND VGND VPWR VPWR net75 sky130_fd_sc_hd__a31o_1
XFILLER_0_88_85 VGND VGND VPWR VPWR sky130_fd_sc_hd__decap_6
XFILLER_0_63_3 VGND VGND VPWR VPWR sky130_fd_sc_hd__fill_1
XFILLER_0_11_641 VGND VGND VPWR VPWR sky130_fd_sc_hd__decap_8
X_6395_ _1800_ _1801_ _1527_ VGND VGND VPWR VPWR _1803_ sky130_fd_sc_hd__a21o_1
X_5346_ _2375_ _1719_ VGND VGND VPWR VPWR _0657_ sky130_fd_sc_hd__nand2_1
XTAP_TAPCELL_ROW_7_317 VGND VPWR sky130_fd_sc_hd__tapvpwrvgnd_1
XFILLER_0_10_173 VGND VGND VPWR VPWR sky130_fd_sc_hd__fill_1
X_5277_ _0579_ _0580_ _0485_ _0488_ VGND VGND VPWR VPWR _0582_ sky130_fd_sc_hd__a211o_1
X_4228_ _3339_ VGND VGND VPWR VPWR _3340_ sky130_fd_sc_hd__clkbuf_4
X_7016_ _0246_ _0257_ VGND VGND VPWR VPWR _2482_ sky130_fd_sc_hd__or2_1
XPHY_EDGE_ROW_106_Right_106 VGND VGND VPWR VPWR sky130_fd_sc_hd__decap_3
X_4159_ _3269_ VGND VGND VPWR VPWR _3271_ sky130_fd_sc_hd__clkbuf_4
XFILLER_0_97_449 VGND VGND VPWR VPWR sky130_fd_sc_hd__decap_3
XFILLER_0_77_184 VGND VGND VPWR VPWR sky130_fd_sc_hd__decap_4
XFILLER_0_18_251 VGND VGND VPWR VPWR sky130_fd_sc_hd__fill_1
XFILLER_0_18_273 VGND VGND VPWR VPWR sky130_fd_sc_hd__fill_1
XFILLER_0_104_643 VGND VGND VPWR VPWR sky130_fd_sc_hd__fill_1
XFILLER_0_21_405 VPWR VGND VPWR VGND sky130_ef_sc_hd__decap_12
XFILLER_0_21_449 VGND VGND VPWR VPWR sky130_fd_sc_hd__decap_8
XFILLER_0_17_15 VPWR VGND VPWR VGND sky130_ef_sc_hd__decap_12
XFILLER_0_29_505 VGND VGND VPWR VPWR sky130_fd_sc_hd__decap_8
XTAP_TAPCELL_ROW_32_606 VGND VPWR sky130_fd_sc_hd__tapvpwrvgnd_1
XFILLER_0_33_47 VGND VGND VPWR VPWR sky130_fd_sc_hd__decap_8
XFILLER_0_84_633 VGND VGND VPWR VPWR sky130_fd_sc_hd__fill_1
XTAP_TAPCELL_ROW_60_926 VGND VPWR sky130_fd_sc_hd__tapvpwrvgnd_1
XFILLER_0_33_69 VPWR VGND VPWR VGND sky130_ef_sc_hd__decap_12
XFILLER_0_83_154 VPWR VGND VPWR VGND sky130_ef_sc_hd__decap_12
XFILLER_0_71_316 VPWR VGND VPWR VGND sky130_ef_sc_hd__decap_12
XFILLER_0_71_305 VGND VGND VPWR VPWR sky130_fd_sc_hd__decap_3
Xinput12 A[20] VGND VGND VPWR VPWR net12 sky130_fd_sc_hd__buf_1
Xinput23 A[30] VGND VGND VPWR VPWR net23 sky130_fd_sc_hd__clkbuf_2
XFILLER_0_107_470 VGND VGND VPWR VPWR sky130_fd_sc_hd__decap_8
XTAP_TAPCELL_ROW_12_374 VGND VPWR sky130_fd_sc_hd__tapvpwrvgnd_1
Xinput34 B[12] VGND VGND VPWR VPWR net34 sky130_fd_sc_hd__buf_2
XTAP_TAPCELL_ROW_40_694 VGND VPWR sky130_fd_sc_hd__tapvpwrvgnd_1
Xinput45 B[22] VGND VGND VPWR VPWR net45 sky130_fd_sc_hd__clkbuf_2
Xinput56 B[3] VGND VGND VPWR VPWR net56 sky130_fd_sc_hd__buf_6
XFILLER_0_24_265 VGND VGND VPWR VPWR sky130_fd_sc_hd__decap_3
XFILLER_0_52_585 VGND VGND VPWR VPWR sky130_fd_sc_hd__decap_3
X_5200_ _0305_ _0373_ _0498_ _0371_ VGND VGND VPWR VPWR _0499_ sky130_fd_sc_hd__o211ai_1
X_6180_ _1443_ _1442_ VGND VGND VPWR VPWR _1568_ sky130_fd_sc_hd__and2b_1
X_5131_ _0215_ _0319_ _0422_ VGND VGND VPWR VPWR _0423_ sky130_fd_sc_hd__a21oi_1
X_5062_ _0338_ _0346_ _0347_ VGND VGND VPWR VPWR _0348_ sky130_fd_sc_hd__nand3_1
X_4013_ _1577_ VGND VGND VPWR VPWR _1894_ sky130_fd_sc_hd__clkbuf_4
XFILLER_0_35_7 VGND VGND VPWR VPWR sky130_fd_sc_hd__fill_1
XFILLER_0_79_405 VGND VGND VPWR VPWR sky130_fd_sc_hd__decap_8
XFILLER_0_79_449 VPWR VGND VPWR VGND sky130_ef_sc_hd__decap_12
XTAP_TAPCELL_ROW_48_783 VGND VPWR sky130_fd_sc_hd__tapvpwrvgnd_1
XTAP_TAPCELL_ROW_48_794 VGND VPWR sky130_fd_sc_hd__tapvpwrvgnd_1
XFILLER_0_94_419 VGND VGND VPWR VPWR sky130_fd_sc_hd__fill_1
X_7703_ net79 net83 VGND VGND VPWR VPWR _3233_ sky130_fd_sc_hd__or2_1
X_5964_ _1192_ net111 _1330_ _1331_ VGND VGND VPWR VPWR _1332_ sky130_fd_sc_hd__o211ai_4
XFILLER_0_47_313 VGND VGND VPWR VPWR sky130_fd_sc_hd__fill_2
XFILLER_0_90_97 VPWR VGND VPWR VGND sky130_ef_sc_hd__decap_12
X_4915_ _1872_ _3358_ _3747_ _3275_ VGND VGND VPWR VPWR _0188_ sky130_fd_sc_hd__o22a_1
X_5895_ _3130_ _0791_ VGND VGND VPWR VPWR _1256_ sky130_fd_sc_hd__nand2_1
XFILLER_0_47_335 VGND VGND VPWR VPWR sky130_fd_sc_hd__fill_1
X_4846_ _3370_ _0101_ _0103_ _0104_ _0112_ VGND VGND VPWR VPWR _0113_ sky130_fd_sc_hd__a32o_1
X_7634_ _2950_ _2992_ VGND VGND VPWR VPWR _3158_ sky130_fd_sc_hd__and2b_1
XFILLER_0_62_305 VGND VGND VPWR VPWR sky130_fd_sc_hd__decap_3
XFILLER_0_7_421 VGND VGND VPWR VPWR sky130_fd_sc_hd__decap_8
X_7565_ _3078_ _3079_ _3080_ _3081_ VGND VGND VPWR VPWR _3082_ sky130_fd_sc_hd__and4_1
XFILLER_0_7_454 VPWR VGND VPWR VGND sky130_ef_sc_hd__decap_12
XFILLER_0_105_418 VGND VGND VPWR VPWR sky130_fd_sc_hd__fill_1
XFILLER_0_99_51 VGND VGND VPWR VPWR sky130_fd_sc_hd__decap_4
X_6516_ _1933_ _1934_ VGND VGND VPWR VPWR _1935_ sky130_fd_sc_hd__nor2_1
XFILLER_0_43_530 VPWR VGND VPWR VGND sky130_ef_sc_hd__decap_12
X_4777_ _2758_ _3450_ VGND VGND VPWR VPWR _0037_ sky130_fd_sc_hd__nor2_1
X_7496_ _3330_ net54 _3006_ VGND VGND VPWR VPWR _3007_ sky130_fd_sc_hd__a21oi_1
XFILLER_0_15_276 VGND VGND VPWR VPWR sky130_fd_sc_hd__decap_4
XFILLER_0_43_585 VPWR VGND VPWR VGND sky130_ef_sc_hd__decap_12
XFILLER_0_101_602 VPWR VGND VPWR VGND sky130_ef_sc_hd__decap_12
XFILLER_0_70_393 VPWR VGND VPWR VGND sky130_ef_sc_hd__decap_12
XFILLER_0_15_298 VPWR VGND VPWR VGND sky130_ef_sc_hd__decap_12
XFILLER_0_30_224 VPWR VGND VPWR VGND sky130_ef_sc_hd__decap_12
X_6447_ _1857_ _1858_ VGND VGND VPWR VPWR _1859_ sky130_fd_sc_hd__xnor2_1
XFILLER_0_100_134 VGND VGND VPWR VPWR sky130_fd_sc_hd__decap_6
X_6378_ _1783_ _1782_ _1764_ VGND VGND VPWR VPWR _1784_ sky130_fd_sc_hd__and3_1
XFILLER_0_30_279 VPWR VGND VPWR VGND sky130_ef_sc_hd__decap_12
X_5329_ _0636_ _0637_ VGND VGND VPWR VPWR _0639_ sky130_fd_sc_hd__xnor2_2
XFILLER_0_38_335 VGND VGND VPWR VPWR sky130_fd_sc_hd__decap_4
XFILLER_0_93_496 VGND VGND VPWR VPWR sky130_fd_sc_hd__decap_8
XFILLER_0_81_625 VGND VGND VPWR VPWR sky130_fd_sc_hd__fill_2
XFILLER_0_21_202 VGND VGND VPWR VPWR sky130_fd_sc_hd__decap_3
XFILLER_0_34_585 VGND VGND VPWR VPWR sky130_fd_sc_hd__decap_3
XFILLER_0_34_596 VGND VGND VPWR VPWR sky130_fd_sc_hd__decap_8
XFILLER_0_61_393 VPWR VGND VPWR VGND sky130_ef_sc_hd__decap_12
XTAP_TAPCELL_ROW_109_1497 VGND VPWR sky130_fd_sc_hd__tapvpwrvgnd_1
XTAP_TAPCELL_ROW_109_1486 VGND VPWR sky130_fd_sc_hd__tapvpwrvgnd_1
XFILLER_0_76_419 VGND VGND VPWR VPWR sky130_fd_sc_hd__fill_1
XFILLER_0_69_482 VPWR VGND VPWR VGND sky130_ef_sc_hd__decap_12
XTAP_TAPCELL_ROW_17_433 VGND VPWR sky130_fd_sc_hd__tapvpwrvgnd_1
XFILLER_0_44_79 VGND VGND VPWR VPWR sky130_fd_sc_hd__decap_4
XTAP_TAPCELL_ROW_45_753 VGND VPWR sky130_fd_sc_hd__tapvpwrvgnd_1
XFILLER_0_56_110 VPWR VGND VPWR VGND sky130_ef_sc_hd__decap_12
XFILLER_0_84_463 VPWR VGND VPWR VGND sky130_ef_sc_hd__decap_12
X_4700_ _3800_ _3804_ VGND VGND VPWR VPWR _3805_ sky130_fd_sc_hd__or2_1
XFILLER_0_56_165 VGND VGND VPWR VPWR sky130_fd_sc_hd__decap_4
X_5680_ _1004_ _1005_ _1019_ VGND VGND VPWR VPWR _1022_ sky130_fd_sc_hd__and3_1
X_4631_ _2539_ _3663_ _3731_ _2463_ VGND VGND VPWR VPWR _3736_ sky130_fd_sc_hd__o31a_1
XFILLER_0_72_625 VPWR VGND VPWR VGND sky130_ef_sc_hd__decap_12
XFILLER_0_71_113 VPWR VGND VPWR VGND sky130_ef_sc_hd__decap_12
X_4562_ _3321_ _3429_ VGND VGND VPWR VPWR _3669_ sky130_fd_sc_hd__or2_1
XTAP_TAPCELL_ROW_77_1121 VGND VPWR sky130_fd_sc_hd__tapvpwrvgnd_1
X_7350_ _2646_ _2648_ _2645_ VGND VGND VPWR VPWR _2848_ sky130_fd_sc_hd__a21o_1
XFILLER_0_4_457 VGND VGND VPWR VPWR sky130_fd_sc_hd__fill_2
X_4493_ _3338_ _3600_ VGND VGND VPWR VPWR _3601_ sky130_fd_sc_hd__and2_1
X_7281_ _2763_ _2771_ VGND VGND VPWR VPWR _2772_ sky130_fd_sc_hd__and2_1
XFILLER_0_40_522 VGND VGND VPWR VPWR sky130_fd_sc_hd__decap_6
XFILLER_0_40_533 VPWR VGND VPWR VGND sky130_ef_sc_hd__decap_12
X_6301_ _1690_ _1698_ VGND VGND VPWR VPWR _1700_ sky130_fd_sc_hd__nor2_1
X_6232_ _1480_ _1590_ _1624_ _1623_ VGND VGND VPWR VPWR _1625_ sky130_fd_sc_hd__a211oi_4
XFILLER_0_40_577 VGND VGND VPWR VPWR sky130_fd_sc_hd__fill_2
XFILLER_0_0_641 VGND VGND VPWR VPWR sky130_fd_sc_hd__decap_3
X_6163_ _1432_ _1436_ _1433_ VGND VGND VPWR VPWR _1549_ sky130_fd_sc_hd__o21ba_1
X_5114_ _3316_ _1960_ _3360_ VGND VGND VPWR VPWR _0404_ sky130_fd_sc_hd__mux2_1
X_6094_ _1471_ _1472_ _1473_ VGND VGND VPWR VPWR _1474_ sky130_fd_sc_hd__nand3_1
X_5045_ _0325_ _0328_ VGND VGND VPWR VPWR _0329_ sky130_fd_sc_hd__xnor2_1
XTAP_TAPCELL_ROW_88_1250 VGND VPWR sky130_fd_sc_hd__tapvpwrvgnd_1
XFILLER_0_26_3 VPWR VGND VPWR VGND sky130_ef_sc_hd__decap_12
XFILLER_0_79_279 VGND VGND VPWR VPWR sky130_fd_sc_hd__fill_1
X_6996_ _2434_ _2435_ _2458_ _2459_ VGND VGND VPWR VPWR _2460_ sky130_fd_sc_hd__nand4_1
X_5947_ net140 net9 net8 net143 VGND VGND VPWR VPWR _1313_ sky130_fd_sc_hd__a22oi_2
XFILLER_0_34_90 VPWR VGND VPWR VGND sky130_ef_sc_hd__decap_12
XFILLER_0_75_441 VGND VGND VPWR VPWR sky130_fd_sc_hd__decap_6
XFILLER_0_63_603 VGND VGND VPWR VPWR sky130_fd_sc_hd__decap_8
X_7617_ _2902_ _2913_ _2910_ VGND VGND VPWR VPWR _3139_ sky130_fd_sc_hd__a21oi_1
XFILLER_0_75_485 VPWR VGND VPWR VGND sky130_ef_sc_hd__decap_12
X_5878_ _1137_ _1138_ _1155_ _1156_ VGND VGND VPWR VPWR _1237_ sky130_fd_sc_hd__o211ai_2
Xclone26 net3 VGND VGND VPWR VPWR net144 sky130_fd_sc_hd__buf_2
XFILLER_0_47_176 VPWR VGND VPWR VGND sky130_ef_sc_hd__decap_12
XFILLER_0_7_284 VGND VGND VPWR VPWR sky130_fd_sc_hd__decap_4
X_4829_ net31 _0093_ VGND VGND VPWR VPWR _0095_ sky130_fd_sc_hd__nand2_2
XFILLER_0_105_237 VPWR VGND VPWR VGND sky130_ef_sc_hd__decap_12
X_7548_ _2858_ _2859_ _2863_ VGND VGND VPWR VPWR _3063_ sky130_fd_sc_hd__o21ai_1
XFILLER_0_90_499 VGND VGND VPWR VPWR sky130_fd_sc_hd__decap_3
XFILLER_0_90_477 VGND VGND VPWR VPWR sky130_fd_sc_hd__decap_3
XFILLER_0_31_500 VGND VGND VPWR VPWR sky130_fd_sc_hd__decap_4
XFILLER_0_31_511 VGND VGND VPWR VPWR sky130_fd_sc_hd__fill_1
X_7479_ _2748_ _2750_ _2987_ VGND VGND VPWR VPWR _2989_ sky130_fd_sc_hd__a21o_1
XFILLER_0_43_393 VPWR VGND VPWR VGND sky130_ef_sc_hd__decap_12
XFILLER_0_98_533 VGND VGND VPWR VPWR sky130_fd_sc_hd__decap_4
XFILLER_0_14_27 VGND VGND VPWR VPWR sky130_fd_sc_hd__fill_1
XFILLER_0_85_249 VGND VGND VPWR VPWR sky130_fd_sc_hd__decap_4
XTAP_TAPCELL_ROW_14_403 VGND VPWR sky130_fd_sc_hd__tapvpwrvgnd_1
XFILLER_0_38_132 VGND VGND VPWR VPWR sky130_fd_sc_hd__decap_8
XTAP_TAPCELL_ROW_42_723 VGND VPWR sky130_fd_sc_hd__tapvpwrvgnd_1
XFILLER_0_66_474 VGND VGND VPWR VPWR sky130_fd_sc_hd__fill_2
XFILLER_0_38_165 VGND VGND VPWR VPWR sky130_fd_sc_hd__decap_6
XFILLER_0_109_587 VGND VGND VPWR VPWR sky130_fd_sc_hd__fill_1
XTAP_TAPCELL_ROW_22_491 VGND VPWR sky130_fd_sc_hd__tapvpwrvgnd_1
XFILLER_0_22_533 VPWR VGND VPWR VGND sky130_ef_sc_hd__decap_12
XFILLER_0_39_57 VPWR VGND VPWR VGND sky130_ef_sc_hd__decap_12
XTAP_TAPCELL_ROW_72_1062 VGND VPWR sky130_fd_sc_hd__tapvpwrvgnd_1
XFILLER_0_55_78 VPWR VGND VPWR VGND sky130_ef_sc_hd__decap_12
X_6850_ _2136_ _2140_ _2298_ VGND VGND VPWR VPWR _2301_ sky130_fd_sc_hd__o21ai_1
XFILLER_0_76_238 VGND VGND VPWR VPWR sky130_fd_sc_hd__decap_8
XPHY_EDGE_ROW_8_Right_8 VGND VGND VPWR VPWR sky130_fd_sc_hd__decap_3
X_5801_ _1146_ _1153_ VGND VGND VPWR VPWR _1154_ sky130_fd_sc_hd__xnor2_1
X_6781_ _1457_ _3254_ _0413_ VGND VGND VPWR VPWR _2225_ sky130_fd_sc_hd__a21boi_1
X_5732_ _2200_ VGND VGND VPWR VPWR _1079_ sky130_fd_sc_hd__inv_2
XFILLER_0_57_441 VGND VGND VPWR VPWR sky130_fd_sc_hd__fill_1
X_3993_ _1665_ VGND VGND VPWR VPWR _1675_ sky130_fd_sc_hd__clkbuf_4
XTAP_TAPCELL_ROW_83_1191 VGND VPWR sky130_fd_sc_hd__tapvpwrvgnd_1
XFILLER_0_57_485 VPWR VGND VPWR VGND sky130_ef_sc_hd__decap_12
XFILLER_0_17_305 VPWR VGND VPWR VGND sky130_ef_sc_hd__decap_12
XFILLER_0_29_176 VGND VGND VPWR VPWR sky130_fd_sc_hd__fill_2
XFILLER_0_44_102 VPWR VGND VPWR VGND sky130_ef_sc_hd__decap_12
XFILLER_0_45_647 VGND VGND VPWR VPWR sky130_fd_sc_hd__fill_1
XFILLER_0_72_433 VPWR VGND VPWR VGND sky130_ef_sc_hd__decap_12
X_5663_ _0868_ VGND VGND VPWR VPWR _1003_ sky130_fd_sc_hd__inv_2
XFILLER_0_17_349 VGND VGND VPWR VPWR sky130_fd_sc_hd__decap_4
X_7402_ _2714_ _0181_ _2707_ VGND VGND VPWR VPWR _2904_ sky130_fd_sc_hd__and3_1
X_4614_ _3563_ _3717_ _3719_ VGND VGND VPWR VPWR _3720_ sky130_fd_sc_hd__o21ai_1
XFILLER_0_72_477 VPWR VGND VPWR VGND sky130_ef_sc_hd__decap_12
X_5594_ _0924_ _0927_ VGND VGND VPWR VPWR _0928_ sky130_fd_sc_hd__xnor2_2
X_4545_ _2758_ _2824_ _3595_ _3651_ VGND VGND VPWR VPWR _3652_ sky130_fd_sc_hd__a31o_1
X_7333_ _2814_ _2815_ _2827_ _2828_ VGND VGND VPWR VPWR _2829_ sky130_fd_sc_hd__a211oi_2
XFILLER_0_25_393 VGND VGND VPWR VPWR sky130_fd_sc_hd__fill_1
XFILLER_0_96_41 VGND VGND VPWR VPWR sky130_fd_sc_hd__decap_6
X_7264_ _2729_ _2730_ _2750_ _2751_ VGND VGND VPWR VPWR _2753_ sky130_fd_sc_hd__a2bb2o_1
X_4476_ _2758_ _3355_ _3583_ VGND VGND VPWR VPWR _3584_ sky130_fd_sc_hd__o21a_1
XFILLER_0_96_85 VGND VGND VPWR VPWR sky130_fd_sc_hd__decap_8
X_7195_ _0596_ _2675_ _2676_ VGND VGND VPWR VPWR _2677_ sky130_fd_sc_hd__or3_1
X_6215_ _2692_ _0758_ VGND VGND VPWR VPWR _1606_ sky130_fd_sc_hd__nand2_1
XPHY_EDGE_ROW_39_Right_39 VGND VGND VPWR VPWR sky130_fd_sc_hd__decap_3
X_6146_ _1425_ _1426_ _1489_ _1488_ VGND VGND VPWR VPWR _1530_ sky130_fd_sc_hd__or4bb_4
X_6077_ net60 net59 net6 net5 VGND VGND VPWR VPWR _1455_ sky130_fd_sc_hd__and4_1
X_5028_ _3010_ _1533_ VGND VGND VPWR VPWR _0310_ sky130_fd_sc_hd__nand2_1
XFILLER_0_67_249 VPWR VGND VPWR VGND sky130_ef_sc_hd__decap_12
X_6979_ _2439_ _2440_ VGND VGND VPWR VPWR _2442_ sky130_fd_sc_hd__nor2_1
XFILLER_0_48_463 VPWR VGND VPWR VGND sky130_ef_sc_hd__decap_12
XPHY_EDGE_ROW_48_Right_48 VGND VGND VPWR VPWR sky130_fd_sc_hd__decap_3
XFILLER_0_63_411 VGND VGND VPWR VPWR sky130_fd_sc_hd__fill_2
XFILLER_0_63_400 VGND VGND VPWR VPWR sky130_fd_sc_hd__decap_8
XFILLER_0_35_113 VPWR VGND VPWR VGND sky130_ef_sc_hd__decap_12
XFILLER_0_106_524 VGND VGND VPWR VPWR sky130_fd_sc_hd__decap_8
XFILLER_0_106_502 VGND VGND VPWR VPWR sky130_fd_sc_hd__decap_3
XFILLER_0_90_241 VGND VGND VPWR VPWR sky130_fd_sc_hd__fill_2
XFILLER_0_75_293 VPWR VGND VPWR VGND sky130_ef_sc_hd__decap_12
XFILLER_0_106_557 VPWR VGND VPWR VGND sky130_ef_sc_hd__decap_12
XFILLER_0_35_157 VGND VGND VPWR VPWR sky130_fd_sc_hd__decap_8
XFILLER_0_51_617 VGND VGND VPWR VPWR sky130_fd_sc_hd__decap_6
XTAP_TAPCELL_ROW_97_1349 VGND VPWR sky130_fd_sc_hd__tapvpwrvgnd_1
XPHY_EDGE_ROW_57_Right_57 VGND VGND VPWR VPWR sky130_fd_sc_hd__decap_3
XFILLER_0_25_15 VPWR VGND VPWR VGND sky130_ef_sc_hd__decap_12
XFILLER_0_58_216 VPWR VGND VPWR VGND sky130_ef_sc_hd__decap_12
XTAP_TAPCELL_ROW_106_1456 VGND VPWR sky130_fd_sc_hd__tapvpwrvgnd_1
XFILLER_0_86_547 VPWR VGND VPWR VGND sky130_ef_sc_hd__decap_12
XPHY_EDGE_ROW_66_Right_66 VGND VGND VPWR VPWR sky130_fd_sc_hd__decap_3
XTAP_TAPCELL_ROW_55_870 VGND VPWR sky130_fd_sc_hd__tapvpwrvgnd_1
XTAP_TAPCELL_ROW_27_550 VGND VPWR sky130_fd_sc_hd__tapvpwrvgnd_1
XFILLER_0_66_282 VGND VGND VPWR VPWR sky130_fd_sc_hd__fill_1
XFILLER_0_54_477 VPWR VGND VPWR VGND sky130_ef_sc_hd__decap_12
XPHY_EDGE_ROW_75_Right_75 VGND VGND VPWR VPWR sky130_fd_sc_hd__decap_3
XFILLER_0_22_341 VGND VGND VPWR VPWR sky130_fd_sc_hd__decap_6
X_4330_ _3297_ _3371_ VGND VGND VPWR VPWR _3441_ sky130_fd_sc_hd__nor2_2
XFILLER_0_1_235 VGND VGND VPWR VPWR sky130_fd_sc_hd__decap_3
XFILLER_0_22_396 VGND VGND VPWR VPWR sky130_fd_sc_hd__decap_3
X_4261_ _3372_ VGND VGND VPWR VPWR _3373_ sky130_fd_sc_hd__buf_2
X_6000_ _1088_ _1368_ _1371_ VGND VGND VPWR VPWR _1372_ sky130_fd_sc_hd__o21ai_1
XFILLER_0_5_69 VPWR VGND VPWR VGND sky130_ef_sc_hd__decap_12
X_4192_ _3300_ _3303_ VGND VGND VPWR VPWR _3304_ sky130_fd_sc_hd__nand2_4
XPHY_EDGE_ROW_84_Right_84 VGND VGND VPWR VPWR sky130_fd_sc_hd__decap_3
X_6902_ _2350_ _2356_ VGND VGND VPWR VPWR _2357_ sky130_fd_sc_hd__xnor2_1
XFILLER_0_77_547 VPWR VGND VPWR VGND sky130_ef_sc_hd__decap_12
X_6833_ _2247_ _2056_ _2280_ _2281_ VGND VGND VPWR VPWR _2282_ sky130_fd_sc_hd__a211oi_2
XFILLER_0_106_83 VGND VGND VPWR VPWR sky130_fd_sc_hd__fill_1
XFILLER_0_15_81 VGND VGND VPWR VPWR sky130_fd_sc_hd__decap_6
XFILLER_0_9_357 VGND VGND VPWR VPWR sky130_fd_sc_hd__fill_1
XFILLER_0_17_113 VGND VGND VPWR VPWR sky130_fd_sc_hd__decap_4
X_3976_ net36 VGND VGND VPWR VPWR _1490_ sky130_fd_sc_hd__clkbuf_4
X_6764_ _2073_ _2076_ _2074_ VGND VGND VPWR VPWR _2206_ sky130_fd_sc_hd__o21ba_1
XFILLER_0_72_241 VGND VGND VPWR VPWR sky130_fd_sc_hd__fill_1
X_5715_ _1023_ _1024_ _1059_ _1058_ VGND VGND VPWR VPWR _1060_ sky130_fd_sc_hd__or4_4
X_6695_ _2004_ _2129_ _2130_ VGND VGND VPWR VPWR _2131_ sky130_fd_sc_hd__nand3_2
XFILLER_0_93_3 VPWR VGND VPWR VGND sky130_ef_sc_hd__decap_12
XFILLER_0_60_414 VGND VGND VPWR VPWR sky130_fd_sc_hd__decap_6
X_5646_ _3414_ _1206_ VGND VGND VPWR VPWR _0984_ sky130_fd_sc_hd__nand2_1
XPHY_EDGE_ROW_93_Right_93 VGND VGND VPWR VPWR sky130_fd_sc_hd__decap_3
X_5577_ _0799_ _0790_ _0798_ VGND VGND VPWR VPWR _0909_ sky130_fd_sc_hd__a21bo_1
X_7316_ _2803_ _2809_ VGND VGND VPWR VPWR _2810_ sky130_fd_sc_hd__and2_1
X_4528_ _3627_ _3633_ _3634_ VGND VGND VPWR VPWR _3635_ sky130_fd_sc_hd__nand3_1
XFILLER_0_40_171 VGND VGND VPWR VPWR sky130_fd_sc_hd__decap_6
X_4459_ _3141_ _3558_ _3562_ _3567_ VGND VGND VPWR VPWR _3568_ sky130_fd_sc_hd__a211o_1
X_7247_ _1413_ _3256_ _0769_ _0671_ VGND VGND VPWR VPWR _2734_ sky130_fd_sc_hd__and4_1
X_7178_ _1366_ _1987_ _2658_ _1369_ VGND VGND VPWR VPWR _2659_ sky130_fd_sc_hd__o211a_1
X_6129_ _3379_ _1086_ VGND VGND VPWR VPWR _1513_ sky130_fd_sc_hd__nor2_1
XTAP_TAPCELL_ROW_5_289 VGND VPWR sky130_fd_sc_hd__tapvpwrvgnd_1
XFILLER_0_99_149 VGND VGND VPWR VPWR sky130_fd_sc_hd__decap_3
XFILLER_0_95_344 VPWR VGND VPWR VGND sky130_ef_sc_hd__decap_12
XFILLER_0_68_558 VGND VGND VPWR VPWR sky130_fd_sc_hd__decap_3
XTAP_TAPCELL_ROW_52_840 VGND VPWR sky130_fd_sc_hd__tapvpwrvgnd_1
XTAP_TAPCELL_ROW_101_1397 VGND VPWR sky130_fd_sc_hd__tapvpwrvgnd_1
XFILLER_0_11_39 VPWR VGND VPWR VGND sky130_ef_sc_hd__decap_12
XFILLER_0_24_628 VPWR VGND VPWR VGND sky130_ef_sc_hd__decap_12
XFILLER_0_36_488 VGND VGND VPWR VPWR sky130_fd_sc_hd__decap_6
XFILLER_0_51_403 VGND VGND VPWR VPWR sky130_fd_sc_hd__fill_1
XFILLER_0_106_365 VPWR VGND VPWR VGND sky130_ef_sc_hd__decap_12
XFILLER_0_36_36 VPWR VGND VPWR VGND sky130_ef_sc_hd__decap_12
XFILLER_0_36_58 VPWR VGND VPWR VGND sky130_ef_sc_hd__decap_12
XFILLER_0_59_569 VGND VGND VPWR VPWR sky130_fd_sc_hd__fill_1
XTAP_TAPCELL_ROW_80_1161 VGND VPWR sky130_fd_sc_hd__tapvpwrvgnd_1
XFILLER_0_6_316 VGND VGND VPWR VPWR sky130_fd_sc_hd__decap_8
XFILLER_0_39_293 VPWR VGND VPWR VGND sky130_ef_sc_hd__decap_12
XFILLER_0_109_181 VPWR VGND VPWR VGND sky130_ef_sc_hd__decap_12
XFILLER_0_82_561 VPWR VGND VPWR VGND sky130_ef_sc_hd__decap_12
XFILLER_0_15_617 VPWR VGND VPWR VGND sky130_ef_sc_hd__decap_12
XFILLER_0_27_455 VGND VGND VPWR VPWR sky130_fd_sc_hd__fill_1
X_5500_ _0733_ _0825_ VGND VGND VPWR VPWR _0826_ sky130_fd_sc_hd__xnor2_2
XFILLER_0_14_138 VGND VGND VPWR VPWR sky130_fd_sc_hd__fill_2
XFILLER_0_14_105 VGND VGND VPWR VPWR sky130_fd_sc_hd__decap_3
X_6480_ _1457_ _1796_ _1610_ _2036_ VGND VGND VPWR VPWR _1896_ sky130_fd_sc_hd__a22o_1
XTAP_TAPCELL_ROW_30_578 VGND VPWR sky130_fd_sc_hd__tapvpwrvgnd_1
XFILLER_0_14_149 VPWR VGND VPWR VGND sky130_ef_sc_hd__decap_12
X_5431_ _0568_ _0653_ _0688_ _0689_ VGND VGND VPWR VPWR _0750_ sky130_fd_sc_hd__a211oi_2
XFILLER_0_30_609 VGND VGND VPWR VPWR sky130_fd_sc_hd__fill_1
XFILLER_0_10_300 VGND VGND VPWR VPWR sky130_fd_sc_hd__decap_8
X_5362_ _0463_ net148 net4 net3 VGND VGND VPWR VPWR _0675_ sky130_fd_sc_hd__and4_1
X_4313_ _0780_ _1184_ _3307_ VGND VGND VPWR VPWR _3424_ sky130_fd_sc_hd__mux2_1
XFILLER_0_65_7 VGND VGND VPWR VPWR sky130_fd_sc_hd__decap_3
X_7101_ _2401_ _2403_ _2400_ VGND VGND VPWR VPWR _2575_ sky130_fd_sc_hd__o21ba_1
X_7032_ _2347_ _2348_ _2358_ VGND VGND VPWR VPWR _2499_ sky130_fd_sc_hd__nand3_1
X_5293_ _3262_ _0599_ _0506_ VGND VGND VPWR VPWR _0600_ sky130_fd_sc_hd__o21a_1
XFILLER_0_10_377 VPWR VGND VPWR VGND sky130_ef_sc_hd__decap_12
X_4244_ net63 net64 VGND VGND VPWR VPWR _3356_ sky130_fd_sc_hd__nand2b_2
X_4175_ _3097_ VGND VGND VPWR VPWR _3287_ sky130_fd_sc_hd__buf_4
XTAP_TAPCELL_ROW_2_259 VGND VPWR sky130_fd_sc_hd__tapvpwrvgnd_1
XFILLER_0_89_160 VGND VGND VPWR VPWR sky130_fd_sc_hd__decap_8
XTAP_TAPCELL_ROW_66_998 VGND VPWR sky130_fd_sc_hd__tapvpwrvgnd_1
XTAP_TAPCELL_ROW_38_678 VGND VPWR sky130_fd_sc_hd__tapvpwrvgnd_1
XFILLER_0_77_355 VGND VGND VPWR VPWR sky130_fd_sc_hd__decap_4
X_6816_ _2253_ _2262_ VGND VGND VPWR VPWR _2263_ sky130_fd_sc_hd__xnor2_2
X_6747_ _3032_ net17 VGND VGND VPWR VPWR _2187_ sky130_fd_sc_hd__nand2_1
XFILLER_0_73_561 VPWR VGND VPWR VGND sky130_ef_sc_hd__decap_12
X_3959_ _1293_ VGND VGND VPWR VPWR _1304_ sky130_fd_sc_hd__buf_2
XFILLER_0_60_222 VGND VGND VPWR VPWR sky130_fd_sc_hd__fill_1
X_6678_ _2104_ _2111_ VGND VGND VPWR VPWR _2112_ sky130_fd_sc_hd__xnor2_1
XFILLER_0_45_274 VGND VGND VPWR VPWR sky130_fd_sc_hd__decap_6
X_5629_ _0390_ _0965_ _0386_ VGND VGND VPWR VPWR _0967_ sky130_fd_sc_hd__a21o_1
XTAP_TAPCELL_ROW_94_1319 VGND VPWR sky130_fd_sc_hd__tapvpwrvgnd_1
XFILLER_0_103_357 VGND VGND VPWR VPWR sky130_fd_sc_hd__decap_6
XFILLER_0_103_335 VGND VGND VPWR VPWR sky130_fd_sc_hd__fill_1
XFILLER_0_60_288 VPWR VGND VPWR VGND sky130_ef_sc_hd__decap_12
XFILLER_0_60_277 VGND VGND VPWR VPWR sky130_fd_sc_hd__decap_4
XTAP_TAPCELL_ROW_103_1426 VGND VPWR sky130_fd_sc_hd__tapvpwrvgnd_1
XFILLER_0_68_333 VPWR VGND VPWR VGND sky130_ef_sc_hd__decap_12
XFILLER_0_95_196 VPWR VGND VPWR VGND sky130_ef_sc_hd__decap_12
XFILLER_0_49_580 VGND VGND VPWR VPWR sky130_fd_sc_hd__fill_2
XFILLER_0_107_641 VGND VGND VPWR VPWR sky130_fd_sc_hd__decap_8
XFILLER_0_24_414 VGND VGND VPWR VPWR sky130_fd_sc_hd__decap_6
XFILLER_0_24_436 VPWR VGND VPWR VGND sky130_ef_sc_hd__decap_12
XFILLER_0_11_119 VGND VGND VPWR VPWR sky130_fd_sc_hd__decap_8
XFILLER_0_47_57 VGND VGND VPWR VPWR sky130_fd_sc_hd__decap_6
XFILLER_0_2_15 VPWR VGND VPWR VGND sky130_ef_sc_hd__decap_12
XTAP_TAPCELL_ROW_69_1034 VGND VPWR sky130_fd_sc_hd__tapvpwrvgnd_1
X_5980_ _0943_ _1208_ _1209_ _1074_ VGND VGND VPWR VPWR _1350_ sky130_fd_sc_hd__or4b_1
XFILLER_0_86_141 VPWR VGND VPWR VGND sky130_ef_sc_hd__decap_12
X_4931_ _3275_ _3279_ _0184_ _3651_ VGND VGND VPWR VPWR _0205_ sky130_fd_sc_hd__a31o_1
XTAP_TAPCELL_ROW_35_637 VGND VPWR sky130_fd_sc_hd__tapvpwrvgnd_1
X_7650_ _3330_ net55 VGND VGND VPWR VPWR _3176_ sky130_fd_sc_hd__nand2_1
XTAP_TAPCELL_ROW_63_957 VGND VPWR sky130_fd_sc_hd__tapvpwrvgnd_1
XFILLER_0_59_366 VPWR VGND VPWR VGND sky130_ef_sc_hd__decap_12
X_4862_ _0047_ _0049_ _0048_ VGND VGND VPWR VPWR _0130_ sky130_fd_sc_hd__o21ba_1
XFILLER_0_47_517 VGND VGND VPWR VPWR sky130_fd_sc_hd__decap_6
X_6601_ _2026_ _2027_ VGND VGND VPWR VPWR _2028_ sky130_fd_sc_hd__and2b_1
X_7581_ _3309_ net24 _0246_ _3350_ VGND VGND VPWR VPWR _3100_ sky130_fd_sc_hd__a22o_1
XFILLER_0_103_51 VGND VGND VPWR VPWR sky130_fd_sc_hd__decap_4
XANTENNA_15 _2687_ VGND VGND VPWR VPWR sky130_fd_sc_hd__diode_2
XFILLER_0_55_561 VGND VGND VPWR VPWR sky130_fd_sc_hd__decap_8
XFILLER_0_6_113 VGND VGND VPWR VPWR sky130_fd_sc_hd__fill_2
X_4793_ _3521_ _3772_ _3777_ _3518_ VGND VGND VPWR VPWR _0055_ sky130_fd_sc_hd__a22oi_2
XFILLER_0_70_531 VGND VGND VPWR VPWR sky130_fd_sc_hd__fill_1
XFILLER_0_27_296 VPWR VGND VPWR VGND sky130_ef_sc_hd__decap_12
X_6532_ net107 _1951_ _1791_ _1793_ VGND VGND VPWR VPWR _1953_ sky130_fd_sc_hd__o211a_1
XFILLER_0_12_82 VGND VGND VPWR VPWR sky130_fd_sc_hd__fill_2
X_6463_ _1874_ _1875_ _1876_ VGND VGND VPWR VPWR _1877_ sky130_fd_sc_hd__and3_1
X_5414_ _0506_ _0714_ _0723_ _0731_ VGND VGND VPWR VPWR _0732_ sky130_fd_sc_hd__a211o_1
Xoutput100 net100 VGND VGND VPWR VPWR result[9] sky130_fd_sc_hd__buf_2
XFILLER_0_42_288 VGND VGND VPWR VPWR sky130_fd_sc_hd__fill_1
X_6394_ _1527_ _1800_ _1801_ VGND VGND VPWR VPWR _1802_ sky130_fd_sc_hd__nand3_2
XFILLER_0_10_141 VPWR VGND VPWR VGND sky130_ef_sc_hd__decap_12
XTAP_TAPCELL_ROW_7_318 VGND VPWR sky130_fd_sc_hd__tapvpwrvgnd_1
X_5345_ _0332_ _1654_ _0553_ _0552_ _0240_ VGND VGND VPWR VPWR _0656_ sky130_fd_sc_hd__a32o_1
X_5276_ _0485_ _0488_ _0579_ _0580_ VGND VGND VPWR VPWR _0581_ sky130_fd_sc_hd__o211ai_2
X_4227_ _3338_ VGND VGND VPWR VPWR _3339_ sky130_fd_sc_hd__clkbuf_4
X_7015_ _0282_ _2480_ _1088_ VGND VGND VPWR VPWR _2481_ sky130_fd_sc_hd__a21oi_1
X_4158_ _3269_ _1752_ VGND VGND VPWR VPWR _3270_ sky130_fd_sc_hd__and2_1
X_4089_ _2681_ _2714_ VGND VGND VPWR VPWR _2725_ sky130_fd_sc_hd__and2b_1
XFILLER_0_92_100 VPWR VGND VPWR VGND sky130_ef_sc_hd__decap_12
XPHY_EDGE_ROW_12_Left_122 VGND VGND VPWR VPWR sky130_fd_sc_hd__decap_3
XFILLER_0_73_391 VGND VGND VPWR VPWR sky130_fd_sc_hd__fill_1
XFILLER_0_33_233 VGND VGND VPWR VPWR sky130_fd_sc_hd__decap_6
XFILLER_0_103_110 VGND VGND VPWR VPWR sky130_fd_sc_hd__fill_2
XFILLER_0_21_417 VGND VGND VPWR VPWR sky130_fd_sc_hd__decap_8
XFILLER_0_33_277 VGND VGND VPWR VPWR sky130_fd_sc_hd__decap_3
XFILLER_0_103_143 VPWR VGND VPWR VGND sky130_ef_sc_hd__decap_12
XFILLER_0_21_439 VGND VGND VPWR VPWR sky130_fd_sc_hd__decap_8
XFILLER_0_108_29 VPWR VGND VPWR VGND sky130_ef_sc_hd__decap_12
XFILLER_0_17_27 VGND VGND VPWR VPWR sky130_fd_sc_hd__decap_4
XFILLER_0_17_38 VGND VGND VPWR VPWR sky130_fd_sc_hd__decap_4
XPHY_EDGE_ROW_21_Left_131 VGND VGND VPWR VPWR sky130_fd_sc_hd__decap_3
XFILLER_0_88_417 VGND VGND VPWR VPWR sky130_fd_sc_hd__decap_3
XFILLER_0_33_15 VPWR VGND VPWR VGND sky130_ef_sc_hd__decap_12
XFILLER_0_96_483 VGND VGND VPWR VPWR sky130_fd_sc_hd__fill_2
XFILLER_0_96_472 VGND VGND VPWR VPWR sky130_fd_sc_hd__decap_4
XFILLER_0_68_174 VPWR VGND VPWR VGND sky130_ef_sc_hd__decap_12
XFILLER_0_68_141 VGND VGND VPWR VPWR sky130_fd_sc_hd__decap_8
XFILLER_0_84_645 VGND VGND VPWR VPWR sky130_fd_sc_hd__decap_6
XTAP_TAPCELL_ROW_60_927 VGND VPWR sky130_fd_sc_hd__tapvpwrvgnd_1
XTAP_TAPCELL_ROW_32_607 VGND VPWR sky130_fd_sc_hd__tapvpwrvgnd_1
XFILLER_0_83_166 VGND VGND VPWR VPWR sky130_fd_sc_hd__fill_2
XPHY_EDGE_ROW_30_Left_140 VGND VGND VPWR VPWR sky130_fd_sc_hd__decap_3
XFILLER_0_71_328 VGND VGND VPWR VPWR sky130_fd_sc_hd__decap_8
Xinput13 A[21] VGND VGND VPWR VPWR net13 sky130_fd_sc_hd__buf_1
Xinput24 A[31] VGND VGND VPWR VPWR net24 sky130_fd_sc_hd__buf_2
XTAP_TAPCELL_ROW_12_375 VGND VPWR sky130_fd_sc_hd__tapvpwrvgnd_1
Xinput35 B[13] VGND VGND VPWR VPWR net35 sky130_fd_sc_hd__buf_1
XFILLER_0_3_105 VGND VGND VPWR VPWR sky130_fd_sc_hd__fill_1
XTAP_TAPCELL_ROW_40_695 VGND VPWR sky130_fd_sc_hd__tapvpwrvgnd_1
Xinput46 B[23] VGND VGND VPWR VPWR net46 sky130_fd_sc_hd__clkbuf_4
XFILLER_0_12_417 VGND VGND VPWR VPWR sky130_fd_sc_hd__decap_3
Xinput57 B[4] VGND VGND VPWR VPWR net57 sky130_fd_sc_hd__clkbuf_2
XFILLER_0_3_127 VPWR VGND VPWR VGND sky130_ef_sc_hd__decap_12
XFILLER_0_24_288 VPWR VGND VPWR VGND sky130_ef_sc_hd__decap_12
XFILLER_0_20_450 VGND VGND VPWR VPWR sky130_fd_sc_hd__fill_1
XFILLER_0_20_461 VPWR VGND VPWR VGND sky130_ef_sc_hd__decap_12
XFILLER_0_20_494 VGND VGND VPWR VPWR sky130_fd_sc_hd__fill_1
X_5130_ _0308_ _0318_ VGND VGND VPWR VPWR _0422_ sky130_fd_sc_hd__and2b_1
X_5061_ _0343_ _0342_ _0345_ VGND VGND VPWR VPWR _0347_ sky130_fd_sc_hd__a21o_1
X_4012_ _1872_ _1818_ VGND VGND VPWR VPWR _1883_ sky130_fd_sc_hd__and2b_1
X_5963_ _1292_ _1294_ _1328_ _1329_ VGND VGND VPWR VPWR _1331_ sky130_fd_sc_hd__o22ai_4
XTAP_TAPCELL_ROW_48_784 VGND VPWR sky130_fd_sc_hd__tapvpwrvgnd_1
X_4914_ _1872_ _1818_ VGND VGND VPWR VPWR _0187_ sky130_fd_sc_hd__nor2_1
X_7702_ net78 net81 _3231_ net85 VGND VGND VPWR VPWR _3232_ sky130_fd_sc_hd__or4_4
XFILLER_0_59_141 VPWR VGND VPWR VGND sky130_ef_sc_hd__decap_12
XFILLER_0_90_76 VGND VGND VPWR VPWR sky130_fd_sc_hd__decap_8
X_5894_ _1253_ _1254_ VGND VGND VPWR VPWR _1255_ sky130_fd_sc_hd__nor2_1
X_4845_ _3374_ _0106_ _0111_ VGND VGND VPWR VPWR _0112_ sky130_fd_sc_hd__a21oi_1
X_7633_ _2949_ _2948_ VGND VGND VPWR VPWR _3157_ sky130_fd_sc_hd__and2b_1
X_7564_ _1424_ _3256_ _3376_ _1184_ VGND VGND VPWR VPWR _3081_ sky130_fd_sc_hd__nand4_1
XFILLER_0_7_466 VGND VGND VPWR VPWR sky130_fd_sc_hd__fill_1
X_4776_ _3812_ _3814_ _3811_ VGND VGND VPWR VPWR _0036_ sky130_fd_sc_hd__o21ba_1
XFILLER_0_55_391 VGND VGND VPWR VPWR sky130_fd_sc_hd__fill_1
XFILLER_0_15_244 VGND VGND VPWR VPWR sky130_fd_sc_hd__decap_8
X_6515_ _3810_ _1162_ _0758_ _3809_ VGND VGND VPWR VPWR _1934_ sky130_fd_sc_hd__a22oi_2
XFILLER_0_43_542 VPWR VGND VPWR VGND sky130_ef_sc_hd__decap_12
X_7495_ _3004_ _3005_ VGND VGND VPWR VPWR _3006_ sky130_fd_sc_hd__xor2_1
XFILLER_0_43_597 VGND VGND VPWR VPWR sky130_fd_sc_hd__fill_2
XFILLER_0_101_614 VGND VGND VPWR VPWR sky130_fd_sc_hd__fill_2
XFILLER_0_30_236 VPWR VGND VPWR VGND sky130_ef_sc_hd__decap_12
X_6446_ _3332_ net46 VGND VGND VPWR VPWR _1858_ sky130_fd_sc_hd__nand2_1
XFILLER_0_100_102 VGND VGND VPWR VPWR sky130_fd_sc_hd__decap_3
X_6377_ _1780_ _1779_ _1781_ VGND VGND VPWR VPWR _1783_ sky130_fd_sc_hd__a21o_1
X_5328_ _3010_ _1490_ VGND VGND VPWR VPWR _0637_ sky130_fd_sc_hd__nand2_1
X_5259_ _0559_ _0560_ _0561_ VGND VGND VPWR VPWR _0563_ sky130_fd_sc_hd__nand3_1
XFILLER_0_97_225 VPWR VGND VPWR VGND sky130_ef_sc_hd__decap_12
XFILLER_0_97_247 VGND VGND VPWR VPWR sky130_fd_sc_hd__decap_4
XFILLER_0_66_601 VGND VGND VPWR VPWR sky130_fd_sc_hd__decap_8
XFILLER_0_78_494 VPWR VGND VPWR VGND sky130_ef_sc_hd__decap_12
XFILLER_0_66_645 VGND VGND VPWR VPWR sky130_fd_sc_hd__decap_3
XFILLER_0_65_111 VGND VGND VPWR VPWR sky130_fd_sc_hd__fill_1
XFILLER_0_81_615 VGND VGND VPWR VPWR sky130_fd_sc_hd__fill_1
XFILLER_0_65_177 VGND VGND VPWR VPWR sky130_fd_sc_hd__fill_2
XFILLER_0_19_594 VGND VGND VPWR VPWR sky130_fd_sc_hd__decap_3
XFILLER_0_80_158 VGND VGND VPWR VPWR sky130_fd_sc_hd__decap_8
XFILLER_0_34_553 VPWR VGND VPWR VGND sky130_ef_sc_hd__decap_12
XFILLER_0_104_430 VGND VGND VPWR VPWR sky130_fd_sc_hd__decap_8
XFILLER_0_104_452 VGND VGND VPWR VPWR sky130_fd_sc_hd__decap_4
XFILLER_0_21_225 VGND VGND VPWR VPWR sky130_fd_sc_hd__fill_2
XFILLER_0_28_15 VPWR VGND VPWR VGND sky130_ef_sc_hd__decap_12
XFILLER_0_44_25 VGND VGND VPWR VPWR sky130_fd_sc_hd__decap_3
XTAP_TAPCELL_ROW_109_1487 VGND VPWR sky130_fd_sc_hd__tapvpwrvgnd_1
XTAP_TAPCELL_ROW_109_1498 VGND VPWR sky130_fd_sc_hd__tapvpwrvgnd_1
XFILLER_0_69_461 VPWR VGND VPWR VGND sky130_ef_sc_hd__decap_12
XTAP_TAPCELL_ROW_17_434 VGND VPWR sky130_fd_sc_hd__tapvpwrvgnd_1
XTAP_TAPCELL_ROW_45_754 VGND VPWR sky130_fd_sc_hd__tapvpwrvgnd_1
XFILLER_0_96_280 VPWR VGND VPWR VGND sky130_ef_sc_hd__decap_12
XFILLER_0_69_494 VGND VGND VPWR VPWR sky130_fd_sc_hd__decap_8
XFILLER_0_56_122 VGND VGND VPWR VPWR sky130_fd_sc_hd__decap_6
XFILLER_0_84_442 VGND VGND VPWR VPWR sky130_fd_sc_hd__fill_1
XFILLER_0_56_144 VGND VGND VPWR VPWR sky130_fd_sc_hd__decap_8
XFILLER_0_84_475 VGND VGND VPWR VPWR sky130_fd_sc_hd__fill_1
X_4630_ _3677_ _3680_ _3735_ VGND VGND VPWR VPWR net97 sky130_fd_sc_hd__a21o_1
XFILLER_0_72_637 VGND VGND VPWR VPWR sky130_fd_sc_hd__decap_6
XFILLER_0_71_125 VPWR VGND VPWR VGND sky130_ef_sc_hd__decap_12
XFILLER_0_25_520 VGND VGND VPWR VPWR sky130_fd_sc_hd__decap_4
X_4561_ _3339_ _3444_ VGND VGND VPWR VPWR _3668_ sky130_fd_sc_hd__and2_1
XTAP_TAPCELL_ROW_77_1122 VGND VPWR sky130_fd_sc_hd__tapvpwrvgnd_1
XFILLER_0_40_501 VPWR VGND VPWR VGND sky130_ef_sc_hd__decap_12
X_6300_ _1690_ _1698_ VGND VGND VPWR VPWR _1699_ sky130_fd_sc_hd__and2_1
X_4492_ _3480_ _3599_ _3391_ VGND VGND VPWR VPWR _3600_ sky130_fd_sc_hd__mux2_1
X_7280_ _2768_ _2770_ VGND VGND VPWR VPWR _2771_ sky130_fd_sc_hd__xnor2_1
XFILLER_0_40_545 VPWR VGND VPWR VGND sky130_ef_sc_hd__decap_12
XFILLER_0_100_41 VPWR VGND VPWR VGND sky130_ef_sc_hd__decap_12
X_6231_ _1620_ _1622_ _1602_ VGND VGND VPWR VPWR _1624_ sky130_fd_sc_hd__a21oi_2
X_6162_ _2583_ _0802_ _1412_ _1411_ VGND VGND VPWR VPWR _1548_ sky130_fd_sc_hd__a31o_1
X_5113_ _3426_ _3436_ _3456_ _3429_ _3742_ _0402_ VGND VGND VPWR VPWR _0403_ sky130_fd_sc_hd__mux4_1
X_6093_ _1311_ _1313_ _1312_ VGND VGND VPWR VPWR _1473_ sky130_fd_sc_hd__o21bai_1
X_5044_ _0326_ _0327_ VGND VGND VPWR VPWR _0328_ sky130_fd_sc_hd__and2b_1
XTAP_TAPCELL_ROW_88_1251 VGND VPWR sky130_fd_sc_hd__tapvpwrvgnd_1
XFILLER_0_79_225 VGND VGND VPWR VPWR sky130_fd_sc_hd__fill_1
XFILLER_0_79_203 VGND VGND VPWR VPWR sky130_fd_sc_hd__fill_1
XFILLER_0_19_3 VPWR VGND VPWR VGND sky130_ef_sc_hd__decap_12
X_6995_ _2179_ _2456_ _2457_ VGND VGND VPWR VPWR _2459_ sky130_fd_sc_hd__or3_1
X_5946_ net56 net148 net9 net8 VGND VGND VPWR VPWR _1312_ sky130_fd_sc_hd__and4_1
XFILLER_0_48_645 VGND VGND VPWR VPWR sky130_fd_sc_hd__decap_6
X_5877_ _1132_ _1134_ VGND VGND VPWR VPWR _1236_ sky130_fd_sc_hd__nor2_1
X_7616_ _3127_ _3137_ VGND VGND VPWR VPWR _3138_ sky130_fd_sc_hd__xnor2_1
XFILLER_0_75_497 VGND VGND VPWR VPWR sky130_fd_sc_hd__decap_6
XFILLER_0_63_637 VGND VGND VPWR VPWR sky130_fd_sc_hd__decap_3
X_4828_ net62 VGND VGND VPWR VPWR _0093_ sky130_fd_sc_hd__buf_2
XFILLER_0_47_188 VPWR VGND VPWR VGND sky130_ef_sc_hd__decap_12
Xclone27 net5 VGND VGND VPWR VPWR net145 sky130_fd_sc_hd__buf_2
XFILLER_0_105_249 VPWR VGND VPWR VGND sky130_ef_sc_hd__decap_12
XTAP_TAPCELL_ROW_99_1380 VGND VPWR sky130_fd_sc_hd__tapvpwrvgnd_1
X_7547_ _1214_ _3060_ _3061_ VGND VGND VPWR VPWR _3062_ sky130_fd_sc_hd__and3_1
X_4759_ _3272_ _3408_ _3417_ _0019_ VGND VGND VPWR VPWR _0020_ sky130_fd_sc_hd__o22a_1
XFILLER_0_16_564 VGND VGND VPWR VPWR sky130_fd_sc_hd__fill_1
XFILLER_0_16_575 VPWR VGND VPWR VGND sky130_ef_sc_hd__decap_12
X_7478_ _2985_ _2986_ VGND VGND VPWR VPWR _2987_ sky130_fd_sc_hd__or2_1
XFILLER_0_43_383 VGND VGND VPWR VPWR sky130_fd_sc_hd__fill_1
XFILLER_0_31_567 VGND VGND VPWR VPWR sky130_fd_sc_hd__fill_1
X_6429_ _1833_ _1699_ _1837_ VGND VGND VPWR VPWR _1840_ sky130_fd_sc_hd__or3_1
XFILLER_0_101_455 VGND VGND VPWR VPWR sky130_fd_sc_hd__decap_6
XFILLER_0_101_477 VPWR VGND VPWR VGND sky130_ef_sc_hd__decap_12
XFILLER_0_98_589 VPWR VGND VPWR VGND sky130_ef_sc_hd__decap_12
XFILLER_0_109_511 VGND VGND VPWR VPWR sky130_fd_sc_hd__decap_8
XTAP_TAPCELL_ROW_42_724 VGND VPWR sky130_fd_sc_hd__tapvpwrvgnd_1
XFILLER_0_109_533 VGND VGND VPWR VPWR sky130_fd_sc_hd__fill_2
XTAP_TAPCELL_ROW_22_492 VGND VPWR sky130_fd_sc_hd__tapvpwrvgnd_1
XFILLER_0_53_169 VGND VGND VPWR VPWR sky130_fd_sc_hd__decap_6
XFILLER_0_22_545 VGND VGND VPWR VPWR sky130_fd_sc_hd__decap_8
XFILLER_0_104_293 VGND VGND VPWR VPWR sky130_fd_sc_hd__fill_1
XFILLER_0_39_69 VPWR VGND VPWR VGND sky130_ef_sc_hd__decap_12
XTAP_TAPCELL_ROW_72_1063 VGND VPWR sky130_fd_sc_hd__tapvpwrvgnd_1
XFILLER_0_89_512 VGND VGND VPWR VPWR sky130_fd_sc_hd__decap_6
XFILLER_0_55_57 VGND VGND VPWR VPWR sky130_fd_sc_hd__decap_3
XFILLER_0_89_578 VGND VGND VPWR VPWR sky130_fd_sc_hd__decap_8
XFILLER_0_71_12 VPWR VGND VPWR VGND sky130_ef_sc_hd__decap_12
XFILLER_0_71_34 VPWR VGND VPWR VGND sky130_ef_sc_hd__decap_12
X_5800_ _1150_ _1152_ VGND VGND VPWR VPWR _1153_ sky130_fd_sc_hd__xnor2_1
X_3992_ _1654_ VGND VGND VPWR VPWR _1665_ sky130_fd_sc_hd__clkbuf_4
X_6780_ _1457_ _1381_ _1413_ _3254_ VGND VGND VPWR VPWR _2224_ sky130_fd_sc_hd__and4_1
X_5731_ _0947_ _0951_ _1076_ VGND VGND VPWR VPWR _1078_ sky130_fd_sc_hd__a21o_1
XFILLER_0_45_604 VPWR VGND VPWR VGND sky130_ef_sc_hd__decap_12
XTAP_TAPCELL_ROW_83_1192 VGND VPWR sky130_fd_sc_hd__tapvpwrvgnd_1
XFILLER_0_72_401 VPWR VGND VPWR VGND sky130_ef_sc_hd__decap_12
XFILLER_0_57_497 VGND VGND VPWR VPWR sky130_fd_sc_hd__decap_6
XFILLER_0_17_317 VPWR VGND VPWR VGND sky130_ef_sc_hd__decap_12
XFILLER_0_44_114 VGND VGND VPWR VPWR sky130_fd_sc_hd__decap_4
XFILLER_0_95_7 VPWR VGND VPWR VGND sky130_ef_sc_hd__decap_12
XFILLER_0_72_445 VPWR VGND VPWR VGND sky130_ef_sc_hd__decap_12
X_5662_ _0880_ _0881_ _0915_ _0916_ VGND VGND VPWR VPWR _1002_ sky130_fd_sc_hd__nor4_1
XFILLER_0_29_199 VPWR VGND VPWR VGND sky130_ef_sc_hd__decap_12
X_7401_ _2638_ _0137_ _3389_ VGND VGND VPWR VPWR _2903_ sky130_fd_sc_hd__and3_1
X_4613_ _2539_ _3405_ _3417_ _2463_ _3718_ VGND VGND VPWR VPWR _3719_ sky130_fd_sc_hd__o221a_1
XFILLER_0_72_489 VGND VGND VPWR VPWR sky130_fd_sc_hd__decap_8
XFILLER_0_4_233 VGND VGND VPWR VPWR sky130_fd_sc_hd__fill_1
XFILLER_0_32_309 VGND VGND VPWR VPWR sky130_fd_sc_hd__decap_6
X_5593_ _0925_ _0926_ VGND VGND VPWR VPWR _0927_ sky130_fd_sc_hd__and2b_1
X_4544_ _3650_ VGND VGND VPWR VPWR _3651_ sky130_fd_sc_hd__clkbuf_4
X_7332_ _2816_ _2577_ _2826_ VGND VGND VPWR VPWR _2828_ sky130_fd_sc_hd__nor3_1
Xmax_cap110 _1427_ VGND VGND VPWR VPWR net110 sky130_fd_sc_hd__buf_1
X_7263_ _2729_ _2730_ _2750_ _2751_ VGND VGND VPWR VPWR _2752_ sky130_fd_sc_hd__and4bb_1
XFILLER_0_4_277 VPWR VGND VPWR VGND sky130_ef_sc_hd__decap_12
X_4475_ _3086_ _2561_ _2627_ _3097_ VGND VGND VPWR VPWR _3583_ sky130_fd_sc_hd__a22o_1
X_6214_ _1162_ _1603_ _1604_ VGND VGND VPWR VPWR _1605_ sky130_fd_sc_hd__a21bo_1
X_7194_ _2674_ _2672_ _0453_ VGND VGND VPWR VPWR _2676_ sky130_fd_sc_hd__a21oi_1
X_6145_ _1527_ _1528_ VGND VGND VPWR VPWR _1529_ sky130_fd_sc_hd__and2b_1
X_6076_ _2452_ net124 net145 _3748_ VGND VGND VPWR VPWR _1454_ sky130_fd_sc_hd__a22oi_1
X_5027_ _3328_ _3256_ VGND VGND VPWR VPWR _0309_ sky130_fd_sc_hd__nand2_2
XFILLER_0_95_559 VGND VGND VPWR VPWR sky130_fd_sc_hd__fill_1
XFILLER_0_82_209 VPWR VGND VPWR VGND sky130_ef_sc_hd__decap_12
X_6978_ _2922_ _3524_ net48 net47 VGND VGND VPWR VPWR _2440_ sky130_fd_sc_hd__and4_1
XFILLER_0_63_423 VPWR VGND VPWR VGND sky130_ef_sc_hd__decap_12
XFILLER_0_0_81 VGND VGND VPWR VPWR sky130_fd_sc_hd__decap_3
X_5929_ _1290_ _1291_ _1270_ _1272_ VGND VGND VPWR VPWR _1294_ sky130_fd_sc_hd__a211oi_2
XFILLER_0_48_475 VGND VGND VPWR VPWR sky130_fd_sc_hd__fill_1
XFILLER_0_90_231 VGND VGND VPWR VPWR sky130_fd_sc_hd__fill_1
XFILLER_0_8_572 VGND VGND VPWR VPWR sky130_fd_sc_hd__fill_1
XFILLER_0_35_125 VGND VGND VPWR VPWR sky130_fd_sc_hd__decap_8
XFILLER_0_16_361 VGND VGND VPWR VPWR sky130_fd_sc_hd__decap_3
XFILLER_0_35_169 VGND VGND VPWR VPWR sky130_fd_sc_hd__decap_8
XFILLER_0_106_569 VPWR VGND VPWR VGND sky130_ef_sc_hd__decap_12
XFILLER_0_31_320 VPWR VGND VPWR VGND sky130_ef_sc_hd__decap_12
XFILLER_0_8_3 VPWR VGND VPWR VGND sky130_ef_sc_hd__decap_12
XFILLER_0_25_27 VPWR VGND VPWR VGND sky130_ef_sc_hd__decap_12
XFILLER_0_98_353 VGND VGND VPWR VPWR sky130_fd_sc_hd__decap_8
XTAP_TAPCELL_ROW_106_1457 VGND VPWR sky130_fd_sc_hd__tapvpwrvgnd_1
XFILLER_0_58_228 VGND VGND VPWR VPWR sky130_fd_sc_hd__decap_3
XTAP_TAPCELL_ROW_55_871 VGND VPWR sky130_fd_sc_hd__tapvpwrvgnd_1
XTAP_TAPCELL_ROW_27_551 VGND VPWR sky130_fd_sc_hd__tapvpwrvgnd_1
XFILLER_0_86_559 VGND VGND VPWR VPWR sky130_fd_sc_hd__decap_8
XFILLER_0_73_209 VPWR VGND VPWR VGND sky130_ef_sc_hd__decap_12
XFILLER_0_6_509 VGND VGND VPWR VPWR sky130_fd_sc_hd__fill_2
XPHY_EDGE_ROW_4_Left_114 VGND VGND VPWR VPWR sky130_fd_sc_hd__decap_3
XFILLER_0_41_15 VPWR VGND VPWR VGND sky130_ef_sc_hd__decap_12
XFILLER_0_109_363 VGND VGND VPWR VPWR sky130_fd_sc_hd__fill_1
XFILLER_0_54_445 VGND VGND VPWR VPWR sky130_fd_sc_hd__decap_4
XFILLER_0_54_456 VPWR VGND VPWR VGND sky130_ef_sc_hd__decap_12
XFILLER_0_14_309 VPWR VGND VPWR VGND sky130_ef_sc_hd__decap_12
XFILLER_0_26_169 VGND VGND VPWR VPWR sky130_fd_sc_hd__fill_2
XFILLER_0_54_489 VPWR VGND VPWR VGND sky130_ef_sc_hd__decap_12
XFILLER_0_1_225 VGND VGND VPWR VPWR sky130_fd_sc_hd__fill_2
XFILLER_0_10_526 VGND VGND VPWR VPWR sky130_fd_sc_hd__decap_6
X_4260_ _0039_ _3361_ net65 VGND VGND VPWR VPWR _3372_ sky130_fd_sc_hd__or3b_1
XFILLER_0_5_15 VPWR VGND VPWR VGND sky130_ef_sc_hd__decap_12
X_4191_ _3297_ _3302_ VGND VGND VPWR VPWR _3303_ sky130_fd_sc_hd__nand2_2
XFILLER_0_82_11 VGND VGND VPWR VPWR sky130_fd_sc_hd__fill_1
XTAP_TAPCELL_ROW_85_1210 VGND VPWR sky130_fd_sc_hd__tapvpwrvgnd_1
X_6901_ _2354_ _2355_ VGND VGND VPWR VPWR _2356_ sky130_fd_sc_hd__xnor2_1
XFILLER_0_89_397 VPWR VGND VPWR VGND sky130_ef_sc_hd__decap_12
XFILLER_0_82_77 VGND VGND VPWR VPWR sky130_fd_sc_hd__decap_4
XFILLER_0_77_526 VGND VGND VPWR VPWR sky130_fd_sc_hd__decap_6
X_6832_ _2278_ _2279_ _2248_ _2116_ VGND VGND VPWR VPWR _2281_ sky130_fd_sc_hd__o211a_1
XFILLER_0_77_559 VGND VGND VPWR VPWR sky130_fd_sc_hd__fill_1
XPHY_EDGE_ROW_59_Left_169 VGND VGND VPWR VPWR sky130_fd_sc_hd__decap_3
X_3975_ _1468_ VGND VGND VPWR VPWR _1479_ sky130_fd_sc_hd__buf_2
XFILLER_0_18_615 VPWR VGND VPWR VGND sky130_ef_sc_hd__decap_12
X_6763_ _2087_ _2089_ _2086_ VGND VGND VPWR VPWR _2205_ sky130_fd_sc_hd__o21ba_1
X_5714_ _1057_ _1056_ _0910_ _1025_ VGND VGND VPWR VPWR _1059_ sky130_fd_sc_hd__o211a_1
X_6694_ _2127_ _2128_ _1952_ _2005_ VGND VGND VPWR VPWR _2130_ sky130_fd_sc_hd__a211o_1
XFILLER_0_72_253 VGND VGND VPWR VPWR sky130_fd_sc_hd__fill_2
X_5645_ _0877_ _0880_ VGND VGND VPWR VPWR _0983_ sky130_fd_sc_hd__or2_1
XFILLER_0_17_169 VGND VGND VPWR VPWR sky130_fd_sc_hd__decap_8
XFILLER_0_45_489 VGND VGND VPWR VPWR sky130_fd_sc_hd__fill_1
XFILLER_0_86_3 VGND VGND VPWR VPWR sky130_fd_sc_hd__decap_8
XFILLER_0_72_297 VGND VGND VPWR VPWR sky130_fd_sc_hd__decap_8
XFILLER_0_31_81 VPWR VGND VPWR VGND sky130_ef_sc_hd__decap_12
X_5576_ _0905_ _0906_ _0897_ VGND VGND VPWR VPWR _0908_ sky130_fd_sc_hd__a21o_1
X_7315_ _2807_ _2808_ VGND VGND VPWR VPWR _2809_ sky130_fd_sc_hd__nor2_1
X_4527_ _3630_ _3631_ _3632_ VGND VGND VPWR VPWR _3634_ sky130_fd_sc_hd__a21o_1
XFILLER_0_13_375 VGND VGND VPWR VPWR sky130_fd_sc_hd__fill_1
X_4458_ _3563_ _3566_ VGND VGND VPWR VPWR _3567_ sky130_fd_sc_hd__nor2_1
XPHY_EDGE_ROW_68_Left_178 VGND VGND VPWR VPWR sky130_fd_sc_hd__decap_3
X_7246_ _3256_ _0769_ _0671_ _1424_ VGND VGND VPWR VPWR _2733_ sky130_fd_sc_hd__a22oi_1
XFILLER_0_40_194 VGND VGND VPWR VPWR sky130_fd_sc_hd__fill_2
X_7177_ _3553_ _2311_ _2657_ _3348_ VGND VGND VPWR VPWR _2658_ sky130_fd_sc_hd__o22a_1
X_4389_ _3413_ _3498_ VGND VGND VPWR VPWR _3499_ sky130_fd_sc_hd__or2_1
X_6128_ _0011_ _1506_ _1510_ _1088_ VGND VGND VPWR VPWR _1511_ sky130_fd_sc_hd__o22ai_1
X_6059_ _2386_ net36 VGND VGND VPWR VPWR _1436_ sky130_fd_sc_hd__nand2_1
XPHY_EDGE_ROW_77_Left_187 VGND VGND VPWR VPWR sky130_fd_sc_hd__decap_3
XFILLER_0_95_356 VGND VGND VPWR VPWR sky130_fd_sc_hd__decap_3
XTAP_TAPCELL_ROW_24_510 VGND VPWR sky130_fd_sc_hd__tapvpwrvgnd_1
XFILLER_0_76_581 VGND VGND VPWR VPWR sky130_fd_sc_hd__decap_6
XFILLER_0_36_412 VGND VGND VPWR VPWR sky130_fd_sc_hd__fill_2
XTAP_TAPCELL_ROW_52_830 VGND VPWR sky130_fd_sc_hd__tapvpwrvgnd_1
XFILLER_0_48_283 VGND VGND VPWR VPWR sky130_fd_sc_hd__decap_3
XTAP_TAPCELL_ROW_101_1398 VGND VPWR sky130_fd_sc_hd__tapvpwrvgnd_1
XFILLER_0_36_456 VGND VGND VPWR VPWR sky130_fd_sc_hd__decap_8
XFILLER_0_23_128 VPWR VGND VPWR VGND sky130_ef_sc_hd__decap_12
XFILLER_0_106_377 VPWR VGND VPWR VGND sky130_ef_sc_hd__decap_12
XFILLER_0_32_640 VGND VGND VPWR VPWR sky130_fd_sc_hd__decap_4
XFILLER_0_32_651 VGND VGND VPWR VPWR sky130_fd_sc_hd__fill_1
XPHY_EDGE_ROW_86_Left_196 VGND VGND VPWR VPWR sky130_fd_sc_hd__decap_3
XFILLER_0_36_15 VPWR VGND VPWR VGND sky130_ef_sc_hd__decap_12
XFILLER_0_36_48 VGND VGND VPWR VPWR sky130_fd_sc_hd__decap_4
XFILLER_0_59_559 VGND VGND VPWR VPWR sky130_fd_sc_hd__fill_1
XTAP_TAPCELL_ROW_80_1162 VGND VPWR sky130_fd_sc_hd__tapvpwrvgnd_1
XTAP_TAPCELL_ROW_80_1151 VGND VPWR sky130_fd_sc_hd__tapvpwrvgnd_1
XFILLER_0_82_573 VGND VGND VPWR VPWR sky130_fd_sc_hd__fill_2
XFILLER_0_42_404 VGND VGND VPWR VPWR sky130_fd_sc_hd__decap_6
XFILLER_0_54_253 VGND VGND VPWR VPWR sky130_fd_sc_hd__decap_4
XFILLER_0_109_193 VGND VGND VPWR VPWR sky130_fd_sc_hd__decap_3
XFILLER_0_82_584 VGND VGND VPWR VPWR sky130_fd_sc_hd__decap_4
X_5430_ _0746_ _0748_ VGND VGND VPWR VPWR _0749_ sky130_fd_sc_hd__nor2_1
XFILLER_0_15_629 VPWR VGND VPWR VGND sky130_ef_sc_hd__decap_12
XTAP_TAPCELL_ROW_30_579 VGND VPWR sky130_fd_sc_hd__tapvpwrvgnd_1
XFILLER_0_42_426 VGND VGND VPWR VPWR sky130_fd_sc_hd__decap_4
X_5361_ _3021_ _1446_ VGND VGND VPWR VPWR _0674_ sky130_fd_sc_hd__nand2_1
XFILLER_0_2_545 VGND VGND VPWR VPWR sky130_fd_sc_hd__decap_6
X_4312_ _3348_ _3422_ VGND VGND VPWR VPWR _3423_ sky130_fd_sc_hd__nor2_1
X_5292_ _0414_ _0598_ VGND VGND VPWR VPWR _0599_ sky130_fd_sc_hd__or2_1
X_7100_ _2571_ _2573_ VGND VGND VPWR VPWR _2574_ sky130_fd_sc_hd__xnor2_1
XFILLER_0_10_312 VPWR VGND VPWR VGND sky130_ef_sc_hd__decap_12
XFILLER_0_2_589 VPWR VGND VPWR VGND sky130_ef_sc_hd__decap_12
X_7031_ _2494_ _2497_ VGND VGND VPWR VPWR _2498_ sky130_fd_sc_hd__nand2_1
X_4243_ _3097_ _3086_ VGND VGND VPWR VPWR _3355_ sky130_fd_sc_hd__nand2_4
XTAP_TAPCELL_ROW_91_1280 VGND VPWR sky130_fd_sc_hd__tapvpwrvgnd_1
XFILLER_0_10_389 VGND VGND VPWR VPWR sky130_fd_sc_hd__decap_6
X_4174_ _2430_ _2539_ _2780_ _2824_ VGND VGND VPWR VPWR _3286_ sky130_fd_sc_hd__and4_1
XFILLER_0_93_65 VGND VGND VPWR VPWR sky130_fd_sc_hd__fill_2
XFILLER_0_89_183 VGND VGND VPWR VPWR sky130_fd_sc_hd__fill_1
XTAP_TAPCELL_ROW_38_668 VGND VPWR sky130_fd_sc_hd__tapvpwrvgnd_1
XTAP_TAPCELL_ROW_38_679 VGND VPWR sky130_fd_sc_hd__tapvpwrvgnd_1
XTAP_TAPCELL_ROW_66_999 VGND VPWR sky130_fd_sc_hd__tapvpwrvgnd_1
XFILLER_0_9_133 VPWR VGND VPWR VGND sky130_ef_sc_hd__decap_12
XFILLER_0_37_209 VPWR VGND VPWR VGND sky130_ef_sc_hd__decap_12
X_6815_ _2260_ _2261_ VGND VGND VPWR VPWR _2262_ sky130_fd_sc_hd__nor2_1
XFILLER_0_45_220 VGND VGND VPWR VPWR sky130_fd_sc_hd__decap_4
X_6746_ _3521_ net16 net15 _2867_ VGND VGND VPWR VPWR _2186_ sky130_fd_sc_hd__a22oi_2
XFILLER_0_73_573 VGND VGND VPWR VPWR sky130_fd_sc_hd__decap_8
XFILLER_0_45_253 VGND VGND VPWR VPWR sky130_fd_sc_hd__decap_6
X_3958_ _1282_ VGND VGND VPWR VPWR _1293_ sky130_fd_sc_hd__buf_2
X_3889_ _0529_ VGND VGND VPWR VPWR _0540_ sky130_fd_sc_hd__inv_2
X_6677_ _2109_ _2110_ VGND VGND VPWR VPWR _2111_ sky130_fd_sc_hd__xor2_1
X_5628_ _0405_ _0964_ _3743_ VGND VGND VPWR VPWR _0965_ sky130_fd_sc_hd__mux2_1
XFILLER_0_14_651 VGND VGND VPWR VPWR sky130_fd_sc_hd__fill_1
XFILLER_0_13_161 VGND VGND VPWR VPWR sky130_fd_sc_hd__decap_6
X_5559_ _0885_ _0888_ VGND VGND VPWR VPWR _0890_ sky130_fd_sc_hd__xnor2_2
XFILLER_0_13_183 VGND VGND VPWR VPWR sky130_fd_sc_hd__fill_1
X_7229_ _1752_ _0998_ _2522_ _2520_ VGND VGND VPWR VPWR _2715_ sky130_fd_sc_hd__a31o_1
XTAP_TAPCELL_ROW_103_1416 VGND VPWR sky130_fd_sc_hd__tapvpwrvgnd_1
XFILLER_0_68_345 VPWR VGND VPWR VGND sky130_ef_sc_hd__decap_12
XFILLER_0_56_507 VGND VGND VPWR VPWR sky130_fd_sc_hd__fill_1
XFILLER_0_83_348 VGND VGND VPWR VPWR sky130_fd_sc_hd__fill_1
XFILLER_0_83_326 VGND VGND VPWR VPWR sky130_fd_sc_hd__decap_4
XFILLER_0_36_253 VPWR VGND VPWR VGND sky130_ef_sc_hd__decap_12
XFILLER_0_106_141 VPWR VGND VPWR VGND sky130_ef_sc_hd__decap_12
XPHY_EDGE_ROW_94_Left_204 VGND VGND VPWR VPWR sky130_fd_sc_hd__decap_3
XFILLER_0_51_201 VGND VGND VPWR VPWR sky130_fd_sc_hd__fill_1
XFILLER_0_24_448 VGND VGND VPWR VPWR sky130_fd_sc_hd__decap_8
XFILLER_0_51_223 VGND VGND VPWR VPWR sky130_fd_sc_hd__fill_1
XFILLER_0_51_234 VGND VGND VPWR VPWR sky130_fd_sc_hd__fill_2
XFILLER_0_20_643 VGND VGND VPWR VPWR sky130_fd_sc_hd__fill_1
XFILLER_0_47_69 VPWR VGND VPWR VGND sky130_ef_sc_hd__decap_12
XTAP_TAPCELL_ROW_69_1035 VGND VPWR sky130_fd_sc_hd__tapvpwrvgnd_1
XFILLER_0_2_27 VGND VGND VPWR VPWR sky130_fd_sc_hd__fill_1
XFILLER_0_99_470 VGND VGND VPWR VPWR sky130_fd_sc_hd__decap_8
X_4930_ _3275_ _0184_ _3279_ VGND VGND VPWR VPWR _0204_ sky130_fd_sc_hd__a21oi_1
XFILLER_0_59_334 VGND VGND VPWR VPWR sky130_fd_sc_hd__fill_2
XTAP_TAPCELL_ROW_35_638 VGND VPWR sky130_fd_sc_hd__tapvpwrvgnd_1
XFILLER_0_86_153 VPWR VGND VPWR VGND sky130_ef_sc_hd__decap_12
XTAP_TAPCELL_ROW_63_958 VGND VPWR sky130_fd_sc_hd__tapvpwrvgnd_1
XFILLER_0_59_378 VPWR VGND VPWR VGND sky130_ef_sc_hd__decap_12
X_4861_ _0040_ _0043_ _0041_ VGND VGND VPWR VPWR _0129_ sky130_fd_sc_hd__o21ba_1
XFILLER_0_7_604 VPWR VGND VPWR VGND sky130_ef_sc_hd__decap_12
X_6600_ _2922_ net45 net44 _2572_ VGND VGND VPWR VPWR _2027_ sky130_fd_sc_hd__a22o_1
X_7580_ _3309_ _3350_ net24 _0246_ VGND VGND VPWR VPWR _3099_ sky130_fd_sc_hd__nand4_1
XANTENNA_16 _3281_ VGND VGND VPWR VPWR sky130_fd_sc_hd__diode_2
XFILLER_0_74_359 VGND VGND VPWR VPWR sky130_fd_sc_hd__decap_4
XFILLER_0_55_540 VGND VGND VPWR VPWR sky130_fd_sc_hd__fill_2
XFILLER_0_6_125 VPWR VGND VPWR VGND sky130_ef_sc_hd__decap_12
X_4792_ _2857_ _2966_ _3772_ _3777_ VGND VGND VPWR VPWR _0054_ sky130_fd_sc_hd__and4_1
X_6531_ _1791_ _1793_ net107 _1951_ VGND VGND VPWR VPWR _1952_ sky130_fd_sc_hd__a211oi_4
X_6462_ _1704_ _1713_ _1712_ VGND VGND VPWR VPWR _1876_ sky130_fd_sc_hd__a21o_1
Xoutput101 net101 VGND VGND VPWR VPWR zero sky130_fd_sc_hd__buf_6
X_5413_ _3364_ _0725_ _0730_ _0011_ VGND VGND VPWR VPWR _0731_ sky130_fd_sc_hd__a22o_1
XFILLER_0_2_320 VGND VGND VPWR VPWR sky130_fd_sc_hd__fill_1
X_6393_ _1799_ _1798_ _1673_ _1636_ VGND VGND VPWR VPWR _1801_ sky130_fd_sc_hd__a211o_1
X_5344_ _2474_ _1730_ _0546_ _0654_ VGND VGND VPWR VPWR _0655_ sky130_fd_sc_hd__a31o_1
XFILLER_0_10_153 VPWR VGND VPWR VGND sky130_ef_sc_hd__decap_12
XTAP_TAPCELL_ROW_7_319 VGND VPWR sky130_fd_sc_hd__tapvpwrvgnd_1
X_5275_ _0577_ _0578_ _0514_ VGND VGND VPWR VPWR _0580_ sky130_fd_sc_hd__a21o_1
X_7014_ _0382_ _1225_ _2479_ _1369_ VGND VGND VPWR VPWR _2480_ sky130_fd_sc_hd__a22oi_1
X_4226_ _2988_ VGND VGND VPWR VPWR _3338_ sky130_fd_sc_hd__clkbuf_4
XFILLER_0_10_197 VPWR VGND VPWR VGND sky130_ef_sc_hd__decap_12
X_4157_ _3268_ VGND VGND VPWR VPWR _3269_ sky130_fd_sc_hd__clkbuf_4
X_4088_ _2703_ VGND VGND VPWR VPWR _2714_ sky130_fd_sc_hd__buf_4
XFILLER_0_78_643 VGND VGND VPWR VPWR sky130_fd_sc_hd__fill_1
XFILLER_0_92_112 VGND VGND VPWR VPWR sky130_fd_sc_hd__decap_8
XFILLER_0_80_307 VGND VGND VPWR VPWR sky130_fd_sc_hd__fill_1
XFILLER_0_18_220 VGND VGND VPWR VPWR sky130_fd_sc_hd__fill_1
X_6729_ _3196_ net48 net47 _3524_ VGND VGND VPWR VPWR _2168_ sky130_fd_sc_hd__a22o_1
XFILLER_0_104_601 VPWR VGND VPWR VGND sky130_ef_sc_hd__decap_12
XFILLER_0_33_245 VPWR VGND VPWR VGND sky130_ef_sc_hd__decap_12
XFILLER_0_104_645 VGND VGND VPWR VPWR sky130_fd_sc_hd__decap_6
XFILLER_0_103_155 VPWR VGND VPWR VGND sky130_ef_sc_hd__decap_12
XFILLER_0_33_27 VGND VGND VPWR VPWR sky130_fd_sc_hd__decap_4
XFILLER_0_96_495 VGND VGND VPWR VPWR sky130_fd_sc_hd__fill_1
XFILLER_0_68_197 VGND VGND VPWR VPWR sky130_fd_sc_hd__decap_3
XFILLER_0_68_186 VGND VGND VPWR VPWR sky130_fd_sc_hd__fill_1
XTAP_TAPCELL_ROW_60_928 VGND VPWR sky130_fd_sc_hd__tapvpwrvgnd_1
XTAP_TAPCELL_ROW_32_608 VGND VPWR sky130_fd_sc_hd__tapvpwrvgnd_1
XFILLER_0_37_540 VPWR VGND VPWR VGND sky130_ef_sc_hd__decap_12
XFILLER_0_83_178 VGND VGND VPWR VPWR sky130_fd_sc_hd__decap_6
Xinput14 A[22] VGND VGND VPWR VPWR net14 sky130_fd_sc_hd__clkbuf_4
XTAP_TAPCELL_ROW_12_376 VGND VPWR sky130_fd_sc_hd__tapvpwrvgnd_1
Xinput36 B[14] VGND VGND VPWR VPWR net36 sky130_fd_sc_hd__buf_2
Xinput25 A[3] VGND VGND VPWR VPWR net25 sky130_fd_sc_hd__buf_2
XTAP_TAPCELL_ROW_40_696 VGND VPWR sky130_fd_sc_hd__tapvpwrvgnd_1
XFILLER_0_107_483 VGND VGND VPWR VPWR sky130_fd_sc_hd__decap_8
Xinput58 B[5] VGND VGND VPWR VPWR net58 sky130_fd_sc_hd__buf_1
XFILLER_0_3_139 VGND VGND VPWR VPWR sky130_fd_sc_hd__decap_4
Xinput47 B[24] VGND VGND VPWR VPWR net47 sky130_fd_sc_hd__buf_2
XTAP_TAPCELL_ROW_75_1094 VGND VPWR sky130_fd_sc_hd__tapvpwrvgnd_1
XFILLER_0_20_473 VGND VGND VPWR VPWR sky130_fd_sc_hd__decap_3
XFILLER_0_20_484 VGND VGND VPWR VPWR sky130_fd_sc_hd__decap_3
X_5060_ _0342_ _0343_ _0345_ VGND VGND VPWR VPWR _0346_ sky130_fd_sc_hd__nand3_1
X_4011_ _1850_ VGND VGND VPWR VPWR _1872_ sky130_fd_sc_hd__clkbuf_4
XFILLER_0_74_23 VGND VGND VPWR VPWR sky130_fd_sc_hd__fill_1
X_5962_ _1292_ _1294_ _1328_ _1329_ VGND VGND VPWR VPWR _1330_ sky130_fd_sc_hd__or4_4
XTAP_TAPCELL_ROW_48_785 VGND VPWR sky130_fd_sc_hd__tapvpwrvgnd_1
XFILLER_0_90_44 VPWR VGND VPWR VGND sky130_ef_sc_hd__decap_12
XFILLER_0_75_613 VGND VGND VPWR VPWR sky130_fd_sc_hd__decap_3
X_4913_ _3277_ _0182_ _0183_ _0185_ VGND VGND VPWR VPWR _0186_ sky130_fd_sc_hd__a31o_1
X_7701_ net75 net76 net77 _3230_ VGND VGND VPWR VPWR _3231_ sky130_fd_sc_hd__or4_4
XFILLER_0_59_153 VPWR VGND VPWR VGND sky130_ef_sc_hd__decap_12
XFILLER_0_47_304 VGND VGND VPWR VPWR sky130_fd_sc_hd__decap_6
X_5893_ _2649_ net26 net37 net38 VGND VGND VPWR VPWR _1254_ sky130_fd_sc_hd__and4_1
XFILLER_0_47_337 VGND VGND VPWR VPWR sky130_fd_sc_hd__decap_8
X_4844_ _3423_ _0107_ _0109_ _0110_ VGND VGND VPWR VPWR _0111_ sky130_fd_sc_hd__a22o_1
X_7632_ _3110_ _3155_ VGND VGND VPWR VPWR _3156_ sky130_fd_sc_hd__xnor2_1
XFILLER_0_90_605 VPWR VGND VPWR VGND sky130_ef_sc_hd__decap_12
XFILLER_0_74_145 VGND VGND VPWR VPWR sky130_fd_sc_hd__fill_1
XFILLER_0_28_540 VPWR VGND VPWR VGND sky130_ef_sc_hd__decap_12
X_7563_ _3256_ _1271_ _1184_ _1424_ VGND VGND VPWR VPWR _3080_ sky130_fd_sc_hd__a22o_1
X_4775_ _0033_ _0034_ VGND VGND VPWR VPWR _0035_ sky130_fd_sc_hd__nor2_1
XFILLER_0_15_223 VGND VGND VPWR VPWR sky130_fd_sc_hd__fill_1
X_6514_ _2342_ _2495_ net9 _0758_ VGND VGND VPWR VPWR _1933_ sky130_fd_sc_hd__and4_1
XFILLER_0_43_554 VGND VGND VPWR VPWR sky130_fd_sc_hd__decap_6
X_7494_ _3329_ _0311_ _2804_ _2806_ VGND VGND VPWR VPWR _3005_ sky130_fd_sc_hd__a31o_1
X_6445_ _1855_ _1856_ VGND VGND VPWR VPWR _1857_ sky130_fd_sc_hd__nor2_1
XFILLER_0_100_114 VGND VGND VPWR VPWR sky130_fd_sc_hd__decap_6
XFILLER_0_2_172 VPWR VGND VPWR VGND sky130_ef_sc_hd__decap_12
X_6376_ _1779_ _1780_ _1781_ VGND VGND VPWR VPWR _1782_ sky130_fd_sc_hd__nand3_2
XFILLER_0_30_248 VGND VGND VPWR VPWR sky130_fd_sc_hd__decap_4
X_5327_ _0633_ _0635_ VGND VGND VPWR VPWR _0636_ sky130_fd_sc_hd__nor2_1
XFILLER_0_11_495 VGND VGND VPWR VPWR sky130_fd_sc_hd__decap_8
X_5258_ _0462_ _0467_ _0466_ VGND VGND VPWR VPWR _0561_ sky130_fd_sc_hd__o21bai_1
X_4209_ _3320_ VGND VGND VPWR VPWR _3321_ sky130_fd_sc_hd__clkbuf_4
X_5189_ net127 _0484_ _0356_ _0358_ VGND VGND VPWR VPWR _0487_ sky130_fd_sc_hd__a211oi_2
XFILLER_0_3_81 VPWR VGND VPWR VGND sky130_ef_sc_hd__decap_12
XFILLER_0_97_237 VGND VGND VPWR VPWR sky130_fd_sc_hd__decap_4
XFILLER_0_38_315 VGND VGND VPWR VPWR sky130_fd_sc_hd__fill_1
XFILLER_0_93_465 VPWR VGND VPWR VGND sky130_ef_sc_hd__decap_12
XFILLER_0_93_443 VGND VGND VPWR VPWR sky130_fd_sc_hd__decap_4
XFILLER_0_61_362 VPWR VGND VPWR VGND sky130_ef_sc_hd__decap_12
XFILLER_0_34_565 VPWR VGND VPWR VGND sky130_ef_sc_hd__decap_12
XFILLER_0_0_109 VGND VGND VPWR VPWR sky130_fd_sc_hd__decap_3
XFILLER_0_104_475 VGND VGND VPWR VPWR sky130_fd_sc_hd__fill_1
XFILLER_0_21_259 VGND VGND VPWR VPWR sky130_fd_sc_hd__decap_3
XFILLER_0_28_27 VGND VGND VPWR VPWR sky130_fd_sc_hd__fill_1
XTAP_TAPCELL_ROW_109_1488 VGND VPWR sky130_fd_sc_hd__tapvpwrvgnd_1
XTAP_TAPCELL_ROW_109_1499 VGND VPWR sky130_fd_sc_hd__tapvpwrvgnd_1
XFILLER_0_69_440 VGND VGND VPWR VPWR sky130_fd_sc_hd__decap_8
XTAP_TAPCELL_ROW_17_435 VGND VPWR sky130_fd_sc_hd__tapvpwrvgnd_1
XTAP_TAPCELL_ROW_45_755 VGND VPWR sky130_fd_sc_hd__tapvpwrvgnd_1
XFILLER_0_84_421 VPWR VGND VPWR VGND sky130_ef_sc_hd__decap_12
XFILLER_0_69_473 VGND VGND VPWR VPWR sky130_fd_sc_hd__fill_2
XFILLER_0_96_292 VPWR VGND VPWR VGND sky130_ef_sc_hd__decap_12
XFILLER_0_56_134 VGND VGND VPWR VPWR sky130_fd_sc_hd__decap_6
XFILLER_0_44_307 VGND VGND VPWR VPWR sky130_fd_sc_hd__fill_1
X_4560_ _3350_ _3302_ VGND VGND VPWR VPWR _3667_ sky130_fd_sc_hd__nand2_1
XFILLER_0_71_137 VPWR VGND VPWR VGND sky130_ef_sc_hd__decap_12
XFILLER_0_107_3 VPWR VGND VPWR VGND sky130_ef_sc_hd__decap_12
XFILLER_0_8_15 VPWR VGND VPWR VGND sky130_ef_sc_hd__decap_12
X_4491_ _3308_ _2594_ _3517_ VGND VGND VPWR VPWR _3599_ sky130_fd_sc_hd__o21ai_1
XTAP_TAPCELL_ROW_77_1123 VGND VPWR sky130_fd_sc_hd__tapvpwrvgnd_1
XFILLER_0_40_513 VGND VGND VPWR VPWR sky130_fd_sc_hd__fill_2
XFILLER_0_52_373 VGND VGND VPWR VPWR sky130_fd_sc_hd__fill_1
XFILLER_0_100_53 VGND VGND VPWR VPWR sky130_fd_sc_hd__decap_8
X_6230_ _1622_ _1620_ _1602_ VGND VGND VPWR VPWR _1623_ sky130_fd_sc_hd__and3_1
XFILLER_0_40_557 VPWR VGND VPWR VGND sky130_ef_sc_hd__decap_12
X_6161_ _1408_ _1416_ VGND VGND VPWR VPWR _1547_ sky130_fd_sc_hd__nand2_1
X_5112_ _3743_ VGND VGND VPWR VPWR _0402_ sky130_fd_sc_hd__clkbuf_4
XFILLER_0_20_281 VGND VGND VPWR VPWR sky130_fd_sc_hd__fill_1
XFILLER_0_85_55 VGND VGND VPWR VPWR sky130_fd_sc_hd__fill_1
X_6092_ _1469_ _1470_ _1467_ VGND VGND VPWR VPWR _1472_ sky130_fd_sc_hd__o21ai_1
X_5043_ _2441_ _2452_ _2649_ _3748_ VGND VGND VPWR VPWR _0327_ sky130_fd_sc_hd__a22o_1
XFILLER_0_18_93 VGND VGND VPWR VPWR sky130_fd_sc_hd__fill_2
XTAP_TAPCELL_ROW_88_1252 VGND VPWR sky130_fd_sc_hd__tapvpwrvgnd_1
X_6994_ _2456_ _2457_ _2179_ VGND VGND VPWR VPWR _2458_ sky130_fd_sc_hd__o21ai_1
XFILLER_0_87_281 VPWR VGND VPWR VGND sky130_ef_sc_hd__decap_12
X_5945_ net42 net10 VGND VGND VPWR VPWR _1311_ sky130_fd_sc_hd__nand2_1
XFILLER_0_34_81 VGND VGND VPWR VPWR sky130_fd_sc_hd__decap_3
XFILLER_0_47_101 VGND VGND VPWR VPWR sky130_fd_sc_hd__fill_1
X_5876_ _0977_ _1212_ _1213_ _1235_ VGND VGND VPWR VPWR net79 sky130_fd_sc_hd__a31o_1
X_7615_ _3135_ _3136_ VGND VGND VPWR VPWR _3137_ sky130_fd_sc_hd__xnor2_1
X_4827_ _0087_ _0091_ VGND VGND VPWR VPWR _0092_ sky130_fd_sc_hd__xnor2_1
XFILLER_0_16_521 VGND VGND VPWR VPWR sky130_fd_sc_hd__decap_8
X_7546_ _0399_ _2875_ _3059_ VGND VGND VPWR VPWR _3061_ sky130_fd_sc_hd__o21ai_1
XTAP_TAPCELL_ROW_99_1370 VGND VPWR sky130_fd_sc_hd__tapvpwrvgnd_1
X_4758_ _0018_ _1719_ VGND VGND VPWR VPWR _0019_ sky130_fd_sc_hd__nand2_4
X_7477_ _2983_ _2984_ _2968_ VGND VGND VPWR VPWR _2986_ sky130_fd_sc_hd__o21a_1
X_4689_ _3791_ _3792_ _3763_ _3704_ VGND VGND VPWR VPWR _3794_ sky130_fd_sc_hd__a211o_1
XFILLER_0_16_587 VGND VGND VPWR VPWR sky130_fd_sc_hd__fill_1
XFILLER_0_101_412 VPWR VGND VPWR VGND sky130_ef_sc_hd__decap_12
X_6428_ _1833_ _1699_ _1837_ VGND VGND VPWR VPWR _1838_ sky130_fd_sc_hd__o21ai_1
XFILLER_0_101_489 VPWR VGND VPWR VGND sky130_ef_sc_hd__decap_12
X_6359_ _1753_ _1762_ VGND VGND VPWR VPWR _1764_ sky130_fd_sc_hd__xor2_1
XFILLER_0_85_207 VPWR VGND VPWR VGND sky130_ef_sc_hd__decap_12
XFILLER_0_66_421 VGND VGND VPWR VPWR sky130_fd_sc_hd__decap_6
XFILLER_0_14_29 VPWR VGND VPWR VGND sky130_ef_sc_hd__decap_12
XFILLER_0_39_613 VGND VGND VPWR VPWR sky130_fd_sc_hd__decap_3
XTAP_TAPCELL_ROW_42_714 VGND VPWR sky130_fd_sc_hd__tapvpwrvgnd_1
XTAP_TAPCELL_ROW_42_725 VGND VPWR sky130_fd_sc_hd__tapvpwrvgnd_1
XFILLER_0_109_589 VPWR VGND VPWR VGND sky130_ef_sc_hd__decap_12
XFILLER_0_19_381 VGND VGND VPWR VPWR sky130_fd_sc_hd__decap_8
XTAP_TAPCELL_ROW_22_493 VGND VPWR sky130_fd_sc_hd__tapvpwrvgnd_1
XFILLER_0_30_39 VGND VGND VPWR VPWR sky130_fd_sc_hd__fill_2
XFILLER_0_61_181 VPWR VGND VPWR VGND sky130_ef_sc_hd__decap_12
XFILLER_0_39_15 VPWR VGND VPWR VGND sky130_ef_sc_hd__decap_12
XTAP_TAPCELL_ROW_72_1064 VGND VPWR sky130_fd_sc_hd__tapvpwrvgnd_1
XFILLER_0_71_46 VGND VGND VPWR VPWR sky130_fd_sc_hd__decap_8
XFILLER_0_71_24 VGND VGND VPWR VPWR sky130_fd_sc_hd__fill_1
XFILLER_0_69_281 VGND VGND VPWR VPWR sky130_fd_sc_hd__fill_1
XFILLER_0_57_421 VGND VGND VPWR VPWR sky130_fd_sc_hd__decap_8
X_3991_ _1643_ VGND VGND VPWR VPWR _1654_ sky130_fd_sc_hd__buf_6
XFILLER_0_71_57 VPWR VGND VPWR VGND sky130_ef_sc_hd__decap_12
X_5730_ _0947_ _0951_ _1076_ VGND VGND VPWR VPWR _1077_ sky130_fd_sc_hd__nand3_1
XFILLER_0_84_262 VGND VGND VPWR VPWR sky130_fd_sc_hd__decap_8
XFILLER_0_84_251 VGND VGND VPWR VPWR sky130_fd_sc_hd__fill_1
XTAP_TAPCELL_ROW_83_1193 VGND VPWR sky130_fd_sc_hd__tapvpwrvgnd_1
XFILLER_0_72_413 VGND VGND VPWR VPWR sky130_fd_sc_hd__decap_6
XFILLER_0_17_329 VGND VGND VPWR VPWR sky130_fd_sc_hd__decap_6
X_7400_ _1752_ _3379_ _2719_ _2718_ VGND VGND VPWR VPWR _2902_ sky130_fd_sc_hd__a31o_1
XFILLER_0_72_457 VPWR VGND VPWR VGND sky130_ef_sc_hd__decap_12
X_5661_ _0982_ _1000_ VGND VGND VPWR VPWR _1001_ sky130_fd_sc_hd__xnor2_1
X_4612_ _2528_ net117 _3358_ _3325_ VGND VGND VPWR VPWR _3718_ sky130_fd_sc_hd__o2bb2a_1
X_5592_ net22 net37 net38 net11 VGND VGND VPWR VPWR _0926_ sky130_fd_sc_hd__a22o_1
X_4543_ net63 net64 _3354_ _0039_ VGND VGND VPWR VPWR _3650_ sky130_fd_sc_hd__or4_1
X_7331_ _2816_ _2577_ _2826_ VGND VGND VPWR VPWR _2827_ sky130_fd_sc_hd__o21a_1
XFILLER_0_13_513 VGND VGND VPWR VPWR sky130_fd_sc_hd__decap_3
X_7262_ _2748_ _2749_ _2731_ _2551_ VGND VGND VPWR VPWR _2751_ sky130_fd_sc_hd__a211o_1
XFILLER_0_4_289 VPWR VGND VPWR VGND sky130_ef_sc_hd__decap_12
XFILLER_0_13_546 VGND VGND VPWR VPWR sky130_fd_sc_hd__decap_8
XFILLER_0_13_557 VGND VGND VPWR VPWR sky130_fd_sc_hd__decap_3
XFILLER_0_13_568 VGND VGND VPWR VPWR sky130_fd_sc_hd__fill_1
Xmax_cap111 _1269_ VGND VGND VPWR VPWR net111 sky130_fd_sc_hd__buf_1
X_4474_ _3580_ _3581_ VGND VGND VPWR VPWR _3582_ sky130_fd_sc_hd__and2b_1
X_6213_ _3064_ net14 net9 net142 VGND VGND VPWR VPWR _1604_ sky130_fd_sc_hd__a22o_1
X_7193_ _0453_ _2674_ _2672_ VGND VGND VPWR VPWR _2675_ sky130_fd_sc_hd__and3_1
X_6144_ _1422_ _1425_ _1526_ VGND VGND VPWR VPWR _1528_ sky130_fd_sc_hd__or3b_1
X_6075_ _1306_ _1309_ _1307_ VGND VGND VPWR VPWR _1453_ sky130_fd_sc_hd__o21ba_1
XFILLER_0_31_3 VGND VGND VPWR VPWR sky130_fd_sc_hd__decap_8
X_5026_ _0222_ _0232_ _0230_ VGND VGND VPWR VPWR _0308_ sky130_fd_sc_hd__a21oi_1
XFILLER_0_95_505 VPWR VGND VPWR VGND sky130_ef_sc_hd__decap_12
XFILLER_0_67_229 VGND VGND VPWR VPWR sky130_fd_sc_hd__fill_1
X_6977_ _3524_ net48 net47 _2922_ VGND VGND VPWR VPWR _2439_ sky130_fd_sc_hd__a22oi_1
XFILLER_0_48_421 VGND VGND VPWR VPWR sky130_fd_sc_hd__decap_8
X_5928_ _1270_ _1272_ _1290_ _1291_ VGND VGND VPWR VPWR _1292_ sky130_fd_sc_hd__o211a_1
X_5859_ _1348_ _1215_ VGND VGND VPWR VPWR _1218_ sky130_fd_sc_hd__or2_1
XFILLER_0_63_435 VPWR VGND VPWR VGND sky130_ef_sc_hd__decap_12
X_7529_ _2879_ _2880_ _3042_ VGND VGND VPWR VPWR _3044_ sky130_fd_sc_hd__a21o_1
XFILLER_0_31_332 VGND VGND VPWR VPWR sky130_fd_sc_hd__decap_4
XFILLER_0_101_231 VGND VGND VPWR VPWR sky130_fd_sc_hd__decap_6
XFILLER_0_98_365 VGND VGND VPWR VPWR sky130_fd_sc_hd__fill_2
XFILLER_0_25_39 VGND VGND VPWR VPWR sky130_fd_sc_hd__fill_2
XTAP_TAPCELL_ROW_106_1458 VGND VPWR sky130_fd_sc_hd__tapvpwrvgnd_1
XFILLER_0_98_376 VPWR VGND VPWR VGND sky130_ef_sc_hd__decap_12
XTAP_TAPCELL_ROW_27_552 VGND VPWR sky130_fd_sc_hd__tapvpwrvgnd_1
XTAP_TAPCELL_ROW_55_872 VGND VPWR sky130_fd_sc_hd__tapvpwrvgnd_1
XFILLER_0_94_571 VGND VGND VPWR VPWR sky130_fd_sc_hd__decap_4
XFILLER_0_94_560 VGND VGND VPWR VPWR sky130_fd_sc_hd__fill_1
XFILLER_0_41_27 VPWR VGND VPWR VGND sky130_ef_sc_hd__decap_12
XFILLER_0_109_353 VGND VGND VPWR VPWR sky130_fd_sc_hd__fill_1
XFILLER_0_81_232 VGND VGND VPWR VPWR sky130_fd_sc_hd__decap_4
XFILLER_0_54_468 VGND VGND VPWR VPWR sky130_fd_sc_hd__decap_8
XFILLER_0_10_505 VGND VGND VPWR VPWR sky130_fd_sc_hd__fill_1
XFILLER_0_22_365 VGND VGND VPWR VPWR sky130_fd_sc_hd__fill_2
XFILLER_0_5_27 VPWR VGND VPWR VGND sky130_ef_sc_hd__decap_12
XPHY_EDGE_ROW_105_Left_215 VGND VGND VPWR VPWR sky130_fd_sc_hd__decap_3
X_4190_ _3301_ VGND VGND VPWR VPWR _3302_ sky130_fd_sc_hd__clkbuf_4
XFILLER_0_66_46 VPWR VGND VPWR VGND sky130_ef_sc_hd__decap_12
XTAP_TAPCELL_ROW_85_1211 VGND VPWR sky130_fd_sc_hd__tapvpwrvgnd_1
XFILLER_0_77_505 VGND VGND VPWR VPWR sky130_fd_sc_hd__decap_4
X_6900_ _1741_ _1271_ VGND VGND VPWR VPWR _2355_ sky130_fd_sc_hd__nand2_1
XFILLER_0_106_41 VPWR VGND VPWR VGND sky130_ef_sc_hd__decap_12
XFILLER_0_77_516 VGND VGND VPWR VPWR sky130_fd_sc_hd__decap_3
XFILLER_0_15_50 VGND VGND VPWR VPWR sky130_fd_sc_hd__decap_6
X_6831_ _2248_ _2116_ _2278_ _2279_ VGND VGND VPWR VPWR _2280_ sky130_fd_sc_hd__a211oi_2
XFILLER_0_106_85 VPWR VGND VPWR VGND sky130_ef_sc_hd__decap_12
XFILLER_0_57_251 VPWR VGND VPWR VGND sky130_ef_sc_hd__decap_12
XFILLER_0_9_337 VPWR VGND VPWR VGND sky130_ef_sc_hd__decap_12
XFILLER_0_18_627 VPWR VGND VPWR VGND sky130_ef_sc_hd__decap_12
XFILLER_0_45_402 VPWR VGND VPWR VGND sky130_ef_sc_hd__decap_12
X_6762_ _2199_ _2201_ _2202_ VGND VGND VPWR VPWR _2204_ sky130_fd_sc_hd__a21o_1
X_3974_ _1457_ VGND VGND VPWR VPWR _1468_ sky130_fd_sc_hd__clkbuf_4
XFILLER_0_72_221 VGND VGND VPWR VPWR sky130_fd_sc_hd__decap_3
X_5713_ _0910_ _1025_ net138 _1057_ VGND VGND VPWR VPWR _1058_ sky130_fd_sc_hd__a211oi_4
X_6693_ _1952_ net105 _2127_ _2128_ VGND VGND VPWR VPWR _2129_ sky130_fd_sc_hd__o211ai_4
X_5644_ _0981_ VGND VGND VPWR VPWR _0982_ sky130_fd_sc_hd__inv_2
XFILLER_0_60_427 VGND VGND VPWR VPWR sky130_fd_sc_hd__fill_1
XFILLER_0_31_93 VPWR VGND VPWR VGND sky130_ef_sc_hd__decap_12
XTAP_TAPCELL_ROW_96_1340 VGND VPWR sky130_fd_sc_hd__tapvpwrvgnd_1
X_7314_ _2806_ _0311_ _3329_ _2804_ VGND VGND VPWR VPWR _2808_ sky130_fd_sc_hd__and4b_1
XFILLER_0_79_3 VPWR VGND VPWR VGND sky130_ef_sc_hd__decap_12
X_5575_ _0897_ _0905_ _0906_ VGND VGND VPWR VPWR _0907_ sky130_fd_sc_hd__nand3_2
XFILLER_0_25_181 VGND VGND VPWR VPWR sky130_fd_sc_hd__decap_8
X_4526_ _3630_ _3631_ _3632_ VGND VGND VPWR VPWR _3633_ sky130_fd_sc_hd__nand3_1
X_4457_ _3339_ _3565_ VGND VGND VPWR VPWR _3566_ sky130_fd_sc_hd__nand2_1
X_7245_ _2518_ _2527_ VGND VGND VPWR VPWR _2732_ sky130_fd_sc_hd__nand2_1
X_7176_ _0072_ _0246_ _1089_ VGND VGND VPWR VPWR _2657_ sky130_fd_sc_hd__mux2_1
X_6127_ _0406_ _1509_ _0390_ VGND VGND VPWR VPWR _1510_ sky130_fd_sc_hd__mux2_1
X_4388_ _3496_ _3497_ VGND VGND VPWR VPWR _3498_ sky130_fd_sc_hd__nor2_1
XFILLER_0_99_107 VGND VGND VPWR VPWR sky130_fd_sc_hd__decap_4
X_6058_ _1432_ _1433_ VGND VGND VPWR VPWR _1434_ sky130_fd_sc_hd__nor2_1
X_5009_ _3370_ _0282_ _0289_ _0104_ VGND VGND VPWR VPWR _0291_ sky130_fd_sc_hd__a22o_1
XFILLER_0_95_335 VGND VGND VPWR VPWR sky130_fd_sc_hd__fill_1
XTAP_TAPCELL_ROW_24_511 VGND VPWR sky130_fd_sc_hd__tapvpwrvgnd_1
XFILLER_0_95_368 VPWR VGND VPWR VGND sky130_ef_sc_hd__decap_12
XFILLER_0_48_251 VGND VGND VPWR VPWR sky130_fd_sc_hd__fill_1
XTAP_TAPCELL_ROW_52_831 VGND VPWR sky130_fd_sc_hd__tapvpwrvgnd_1
XTAP_TAPCELL_ROW_101_1399 VGND VPWR sky130_fd_sc_hd__tapvpwrvgnd_1
XFILLER_0_106_389 VGND VGND VPWR VPWR sky130_fd_sc_hd__decap_8
XFILLER_0_44_490 VPWR VGND VPWR VGND sky130_ef_sc_hd__decap_12
XFILLER_0_51_449 VGND VGND VPWR VPWR sky130_fd_sc_hd__decap_3
XFILLER_0_36_27 VGND VGND VPWR VPWR sky130_fd_sc_hd__fill_1
XPHY_EDGE_ROW_101_Right_101 VGND VGND VPWR VPWR sky130_fd_sc_hd__decap_3
XFILLER_0_99_641 VGND VGND VPWR VPWR sky130_fd_sc_hd__decap_8
XTAP_TAPCELL_ROW_4_280 VGND VPWR sky130_fd_sc_hd__tapvpwrvgnd_1
XFILLER_0_86_324 VGND VGND VPWR VPWR sky130_fd_sc_hd__decap_4
XFILLER_0_52_15 VPWR VGND VPWR VGND sky130_ef_sc_hd__decap_12
XFILLER_0_98_195 VGND VGND VPWR VPWR sky130_fd_sc_hd__fill_1
XTAP_TAPCELL_ROW_80_1152 VGND VPWR sky130_fd_sc_hd__tapvpwrvgnd_1
XFILLER_0_6_329 VGND VGND VPWR VPWR sky130_fd_sc_hd__decap_6
XFILLER_0_54_265 VGND VGND VPWR VPWR sky130_fd_sc_hd__decap_3
XFILLER_0_23_641 VGND VGND VPWR VPWR sky130_fd_sc_hd__decap_8
X_5360_ _0670_ _0672_ VGND VGND VPWR VPWR _0673_ sky130_fd_sc_hd__nor2_1
X_4311_ _3308_ _3406_ _3355_ VGND VGND VPWR VPWR _3422_ sky130_fd_sc_hd__o21a_1
X_5291_ _3255_ _0503_ _0413_ VGND VGND VPWR VPWR _0598_ sky130_fd_sc_hd__and3_1
X_4242_ net65 VGND VGND VPWR VPWR _3354_ sky130_fd_sc_hd__clkbuf_4
X_7030_ _1968_ _1972_ _1973_ _1965_ _2496_ VGND VGND VPWR VPWR _2497_ sky130_fd_sc_hd__a311o_4
XTAP_TAPCELL_ROW_91_1281 VGND VPWR sky130_fd_sc_hd__tapvpwrvgnd_1
X_4173_ _0061_ _0388_ _0409_ _0649_ _3284_ VGND VGND VPWR VPWR _3285_ sky130_fd_sc_hd__a32o_1
XFILLER_0_93_55 VGND VGND VPWR VPWR sky130_fd_sc_hd__fill_1
XTAP_TAPCELL_ROW_38_669 VGND VPWR sky130_fd_sc_hd__tapvpwrvgnd_1
X_6814_ _2257_ _2258_ _2259_ VGND VGND VPWR VPWR _2261_ sky130_fd_sc_hd__o21a_1
XFILLER_0_92_327 VGND VGND VPWR VPWR sky130_fd_sc_hd__fill_1
XFILLER_0_9_167 VGND VGND VPWR VPWR sky130_fd_sc_hd__fill_1
XFILLER_0_9_145 VGND VGND VPWR VPWR sky130_fd_sc_hd__decap_3
X_3957_ net41 VGND VGND VPWR VPWR _1282_ sky130_fd_sc_hd__buf_2
X_6745_ _3518_ _2966_ net16 net15 VGND VGND VPWR VPWR _2185_ sky130_fd_sc_hd__and4_1
X_3888_ _0148_ _0159_ VGND VGND VPWR VPWR _0529_ sky130_fd_sc_hd__or2_1
X_6676_ _1897_ _1898_ VGND VGND VPWR VPWR _2110_ sky130_fd_sc_hd__nand2_1
X_5627_ _0727_ _0963_ _3482_ VGND VGND VPWR VPWR _0964_ sky130_fd_sc_hd__mux2_1
XFILLER_0_33_449 VPWR VGND VPWR VGND sky130_ef_sc_hd__decap_12
XFILLER_0_103_337 VPWR VGND VPWR VGND sky130_ef_sc_hd__decap_12
XFILLER_0_13_140 VGND VGND VPWR VPWR sky130_fd_sc_hd__decap_4
X_5558_ _0886_ _0887_ VGND VGND VPWR VPWR _0888_ sky130_fd_sc_hd__nor2_2
X_4509_ _3304_ _3592_ _3610_ _3613_ _3616_ VGND VGND VPWR VPWR _3617_ sky130_fd_sc_hd__a2111o_1
X_7228_ _2696_ _2697_ _2711_ VGND VGND VPWR VPWR _2713_ sky130_fd_sc_hd__and3_1
X_5489_ _0810_ _0811_ _0750_ _0692_ VGND VGND VPWR VPWR _0814_ sky130_fd_sc_hd__a211o_1
X_7159_ _2635_ _2636_ _2427_ _2429_ VGND VGND VPWR VPWR _2639_ sky130_fd_sc_hd__a211oi_1
XTAP_TAPCELL_ROW_1_250 VGND VPWR sky130_fd_sc_hd__tapvpwrvgnd_1
XTAP_TAPCELL_ROW_103_1417 VGND VPWR sky130_fd_sc_hd__tapvpwrvgnd_1
XFILLER_0_95_110 VGND VGND VPWR VPWR sky130_fd_sc_hd__fill_2
XFILLER_0_68_357 VGND VGND VPWR VPWR sky130_fd_sc_hd__decap_6
XFILLER_0_95_143 VGND VGND VPWR VPWR sky130_fd_sc_hd__decap_6
XFILLER_0_64_541 VGND VGND VPWR VPWR sky130_fd_sc_hd__fill_1
XFILLER_0_36_221 VGND VGND VPWR VPWR sky130_fd_sc_hd__fill_1
XFILLER_0_91_371 VGND VGND VPWR VPWR sky130_fd_sc_hd__decap_8
XFILLER_0_24_427 VGND VGND VPWR VPWR sky130_fd_sc_hd__fill_1
XFILLER_0_36_265 VPWR VGND VPWR VGND sky130_ef_sc_hd__decap_12
XFILLER_0_36_287 VPWR VGND VPWR VGND sky130_ef_sc_hd__decap_12
XFILLER_0_106_153 VPWR VGND VPWR VGND sky130_ef_sc_hd__decap_12
XFILLER_0_106_197 VPWR VGND VPWR VGND sky130_ef_sc_hd__decap_12
XFILLER_0_51_279 VGND VGND VPWR VPWR sky130_fd_sc_hd__fill_1
XTAP_TAPCELL_ROW_69_1025 VGND VPWR sky130_fd_sc_hd__tapvpwrvgnd_1
XFILLER_0_63_25 VGND VGND VPWR VPWR sky130_fd_sc_hd__fill_1
XFILLER_0_59_302 VPWR VGND VPWR VGND sky130_ef_sc_hd__decap_12
XFILLER_0_86_165 VPWR VGND VPWR VGND sky130_ef_sc_hd__decap_12
XTAP_TAPCELL_ROW_63_959 VGND VPWR sky130_fd_sc_hd__tapvpwrvgnd_1
XFILLER_0_59_357 VGND VGND VPWR VPWR sky130_fd_sc_hd__fill_2
XTAP_TAPCELL_ROW_35_639 VGND VPWR sky130_fd_sc_hd__tapvpwrvgnd_1
X_4860_ _0125_ _0127_ VGND VGND VPWR VPWR _0128_ sky130_fd_sc_hd__nor2_1
XFILLER_0_74_349 VGND VGND VPWR VPWR sky130_fd_sc_hd__fill_1
XANTENNA_17 _3379_ VGND VGND VPWR VPWR sky130_fd_sc_hd__diode_2
XFILLER_0_7_649 VGND VGND VPWR VPWR sky130_fd_sc_hd__decap_3
X_6530_ _1884_ _1885_ _1947_ _1948_ VGND VGND VPWR VPWR _1951_ sky130_fd_sc_hd__o22a_1
X_4791_ _3032_ _3268_ VGND VGND VPWR VPWR _0053_ sky130_fd_sc_hd__nand2_1
XFILLER_0_6_137 VGND VGND VPWR VPWR sky130_fd_sc_hd__decap_3
XFILLER_0_70_533 VPWR VGND VPWR VGND sky130_ef_sc_hd__decap_12
X_6461_ _1871_ _1873_ _1864_ VGND VGND VPWR VPWR _1875_ sky130_fd_sc_hd__a21o_1
X_5412_ _3754_ _0729_ _0390_ VGND VGND VPWR VPWR _0730_ sky130_fd_sc_hd__mux2_1
XFILLER_0_88_55 VPWR VGND VPWR VGND sky130_ef_sc_hd__decap_12
XFILLER_0_30_419 VGND VGND VPWR VPWR sky130_fd_sc_hd__fill_1
X_6392_ _1673_ _1636_ _1798_ _1799_ VGND VGND VPWR VPWR _1800_ sky130_fd_sc_hd__o211ai_4
XFILLER_0_100_307 VGND VGND VPWR VPWR sky130_fd_sc_hd__fill_1
XTAP_TAPCELL_ROW_93_1310 VGND VPWR sky130_fd_sc_hd__tapvpwrvgnd_1
X_5343_ _3749_ _0545_ VGND VGND VPWR VPWR _0654_ sky130_fd_sc_hd__nor2_1
XFILLER_0_2_365 VGND VGND VPWR VPWR sky130_fd_sc_hd__fill_1
XFILLER_0_23_493 VGND VGND VPWR VPWR sky130_fd_sc_hd__decap_8
XFILLER_0_2_398 VGND VGND VPWR VPWR sky130_fd_sc_hd__fill_1
XFILLER_0_10_165 VGND VGND VPWR VPWR sky130_fd_sc_hd__decap_8
X_5274_ _0514_ _0577_ _0578_ VGND VGND VPWR VPWR _0579_ sky130_fd_sc_hd__nand3_4
X_7013_ _1816_ _2478_ _1366_ VGND VGND VPWR VPWR _2479_ sky130_fd_sc_hd__mux2_1
X_4225_ _3330_ _3333_ _3335_ _3336_ _3309_ _3314_ VGND VGND VPWR VPWR _3337_ sky130_fd_sc_hd__mux4_1
X_4156_ _3267_ VGND VGND VPWR VPWR _3268_ sky130_fd_sc_hd__buf_6
XFILLER_0_37_70 VGND VGND VPWR VPWR sky130_fd_sc_hd__decap_3
XFILLER_0_37_92 VGND VGND VPWR VPWR sky130_fd_sc_hd__decap_4
XFILLER_0_78_611 VPWR VGND VPWR VGND sky130_ef_sc_hd__decap_12
X_4087_ _2692_ VGND VGND VPWR VPWR _2703_ sky130_fd_sc_hd__buf_4
XFILLER_0_65_305 VGND VGND VPWR VPWR sky130_fd_sc_hd__decap_8
X_4989_ _0265_ _0266_ _0164_ _0166_ VGND VGND VPWR VPWR _0269_ sky130_fd_sc_hd__a211o_1
X_6728_ _3287_ net49 VGND VGND VPWR VPWR _2166_ sky130_fd_sc_hd__nand2_1
XFILLER_0_104_613 VPWR VGND VPWR VGND sky130_ef_sc_hd__decap_12
X_6659_ _2085_ _2090_ VGND VGND VPWR VPWR _2092_ sky130_fd_sc_hd__xnor2_1
XFILLER_0_5_181 VGND VGND VPWR VPWR sky130_fd_sc_hd__decap_8
XFILLER_0_33_257 VPWR VGND VPWR VGND sky130_ef_sc_hd__decap_12
XFILLER_0_103_167 VGND VGND VPWR VPWR sky130_fd_sc_hd__fill_1
XFILLER_0_96_430 VGND VGND VPWR VPWR sky130_fd_sc_hd__fill_2
XFILLER_0_68_121 VPWR VGND VPWR VGND sky130_ef_sc_hd__decap_12
XFILLER_0_68_165 VGND VGND VPWR VPWR sky130_fd_sc_hd__decap_6
XFILLER_0_83_113 VGND VGND VPWR VPWR sky130_fd_sc_hd__decap_4
XFILLER_0_83_102 VGND VGND VPWR VPWR sky130_fd_sc_hd__fill_1
XTAP_TAPCELL_ROW_60_929 VGND VPWR sky130_fd_sc_hd__tapvpwrvgnd_1
XTAP_TAPCELL_ROW_32_609 VGND VPWR sky130_fd_sc_hd__tapvpwrvgnd_1
XFILLER_0_37_530 VGND VGND VPWR VPWR sky130_fd_sc_hd__decap_3
XFILLER_0_37_552 VGND VGND VPWR VPWR sky130_fd_sc_hd__decap_8
XFILLER_0_64_371 VGND VGND VPWR VPWR sky130_fd_sc_hd__fill_1
XFILLER_0_107_462 VGND VGND VPWR VPWR sky130_fd_sc_hd__fill_1
XTAP_TAPCELL_ROW_12_377 VGND VPWR sky130_fd_sc_hd__tapvpwrvgnd_1
Xinput37 B[15] VGND VGND VPWR VPWR net37 sky130_fd_sc_hd__buf_2
Xinput15 A[23] VGND VGND VPWR VPWR net15 sky130_fd_sc_hd__buf_2
Xinput26 A[4] VGND VGND VPWR VPWR net26 sky130_fd_sc_hd__clkbuf_2
XFILLER_0_52_533 VPWR VGND VPWR VGND sky130_ef_sc_hd__decap_12
Xinput48 B[25] VGND VGND VPWR VPWR net48 sky130_fd_sc_hd__buf_2
Xinput59 B[6] VGND VGND VPWR VPWR net59 sky130_fd_sc_hd__buf_2
XFILLER_0_24_257 VGND VGND VPWR VPWR sky130_fd_sc_hd__fill_1
XTAP_TAPCELL_ROW_40_697 VGND VPWR sky130_fd_sc_hd__tapvpwrvgnd_1
XTAP_TAPCELL_ROW_75_1095 VGND VPWR sky130_fd_sc_hd__tapvpwrvgnd_1
X_4010_ _1818_ _1850_ VGND VGND VPWR VPWR _1861_ sky130_fd_sc_hd__or2b_1
X_5961_ _1325_ _1327_ _1188_ _1295_ VGND VGND VPWR VPWR _1329_ sky130_fd_sc_hd__o211a_1
XTAP_TAPCELL_ROW_48_786 VGND VPWR sky130_fd_sc_hd__tapvpwrvgnd_1
XFILLER_0_87_474 VPWR VGND VPWR VGND sky130_ef_sc_hd__decap_12
X_4912_ _3403_ _0184_ VGND VGND VPWR VPWR _0185_ sky130_fd_sc_hd__nand2_1
X_7700_ net72 net73 net74 _3229_ VGND VGND VPWR VPWR _3230_ sky130_fd_sc_hd__or4_1
XFILLER_0_59_165 VGND VGND VPWR VPWR sky130_fd_sc_hd__decap_3
X_7631_ _3113_ _3154_ VGND VGND VPWR VPWR _3155_ sky130_fd_sc_hd__xnor2_1
XFILLER_0_90_56 VPWR VGND VPWR VGND sky130_ef_sc_hd__decap_12
X_5892_ _2649_ _2069_ _0693_ _2550_ VGND VGND VPWR VPWR _1253_ sky130_fd_sc_hd__a22oi_1
XFILLER_0_47_327 VGND VGND VPWR VPWR sky130_fd_sc_hd__decap_8
X_4843_ _3395_ _0010_ VGND VGND VPWR VPWR _0110_ sky130_fd_sc_hd__nor2_2
XFILLER_0_23_50 VGND VGND VPWR VPWR sky130_fd_sc_hd__decap_6
XFILLER_0_28_552 VPWR VGND VPWR VGND sky130_ef_sc_hd__decap_12
XFILLER_0_90_617 VPWR VGND VPWR VGND sky130_ef_sc_hd__decap_12
X_7562_ _1818_ _1632_ _2157_ _3379_ VGND VGND VPWR VPWR _3079_ sky130_fd_sc_hd__nand4_1
XFILLER_0_55_360 VPWR VGND VPWR VGND sky130_ef_sc_hd__decap_12
XFILLER_0_7_435 VPWR VGND VPWR VGND sky130_ef_sc_hd__decap_12
X_4774_ _3329_ _1632_ _0031_ _0032_ VGND VGND VPWR VPWR _0034_ sky130_fd_sc_hd__a211oi_1
X_7493_ _3002_ _3003_ VGND VGND VPWR VPWR _3004_ sky130_fd_sc_hd__xnor2_1
X_6513_ _1773_ _1777_ _1775_ VGND VGND VPWR VPWR _1932_ sky130_fd_sc_hd__o21ba_1
XFILLER_0_70_363 VGND VGND VPWR VPWR sky130_fd_sc_hd__fill_1
X_6444_ _3524_ _0867_ net44 _2933_ VGND VGND VPWR VPWR _1856_ sky130_fd_sc_hd__a22oi_1
XFILLER_0_70_374 VPWR VGND VPWR VGND sky130_ef_sc_hd__decap_12
XFILLER_0_3_641 VGND VGND VPWR VPWR sky130_fd_sc_hd__decap_8
XFILLER_0_61_3 VGND VGND VPWR VPWR sky130_fd_sc_hd__fill_2
X_6375_ _1607_ _1616_ _1615_ VGND VGND VPWR VPWR _1781_ sky130_fd_sc_hd__a21bo_1
XFILLER_0_101_649 VGND VGND VPWR VPWR sky130_fd_sc_hd__decap_3
XFILLER_0_2_184 VPWR VGND VPWR VGND sky130_ef_sc_hd__decap_12
X_5326_ _3119_ _2889_ _0634_ _3253_ VGND VGND VPWR VPWR _0635_ sky130_fd_sc_hd__and4_1
X_5257_ _0557_ _0558_ _0556_ VGND VGND VPWR VPWR _0560_ sky130_fd_sc_hd__o21ai_1
X_4208_ _3319_ VGND VGND VPWR VPWR _3320_ sky130_fd_sc_hd__clkbuf_4
XFILLER_0_48_91 VGND VGND VPWR VPWR sky130_fd_sc_hd__fill_1
X_5188_ _0356_ _0358_ net133 _0484_ VGND VGND VPWR VPWR _0485_ sky130_fd_sc_hd__o211a_1
X_4139_ _2408_ _3250_ VGND VGND VPWR VPWR _3251_ sky130_fd_sc_hd__nor2_1
XFILLER_0_3_93 VPWR VGND VPWR VGND sky130_ef_sc_hd__decap_12
XFILLER_0_78_485 VGND VGND VPWR VPWR sky130_fd_sc_hd__fill_2
XFILLER_0_65_113 VGND VGND VPWR VPWR sky130_fd_sc_hd__decap_8
XFILLER_0_93_455 VGND VGND VPWR VPWR sky130_fd_sc_hd__fill_2
XFILLER_0_93_477 VGND VGND VPWR VPWR sky130_fd_sc_hd__fill_2
XFILLER_0_19_574 VGND VGND VPWR VPWR sky130_fd_sc_hd__fill_2
XFILLER_0_34_500 VPWR VGND VPWR VGND sky130_ef_sc_hd__decap_12
XFILLER_0_34_533 VPWR VGND VPWR VGND sky130_ef_sc_hd__decap_12
XFILLER_0_46_382 VGND VGND VPWR VPWR sky130_fd_sc_hd__fill_1
XFILLER_0_104_421 VGND VGND VPWR VPWR sky130_fd_sc_hd__fill_2
XFILLER_0_34_577 VGND VGND VPWR VPWR sky130_fd_sc_hd__decap_8
XFILLER_0_61_374 VPWR VGND VPWR VGND sky130_ef_sc_hd__decap_12
XFILLER_0_21_249 VGND VGND VPWR VPWR sky130_fd_sc_hd__fill_1
XTAP_TAPCELL_ROW_109_1489 VGND VPWR sky130_fd_sc_hd__tapvpwrvgnd_1
XTAP_TAPCELL_ROW_17_436 VGND VPWR sky130_fd_sc_hd__tapvpwrvgnd_1
XFILLER_0_96_271 VGND VGND VPWR VPWR sky130_fd_sc_hd__fill_1
XTAP_TAPCELL_ROW_45_756 VGND VPWR sky130_fd_sc_hd__tapvpwrvgnd_1
XFILLER_0_84_455 VGND VGND VPWR VPWR sky130_fd_sc_hd__fill_1
XFILLER_0_60_15 VPWR VGND VPWR VGND sky130_ef_sc_hd__decap_12
XFILLER_0_84_477 VPWR VGND VPWR VGND sky130_ef_sc_hd__decap_12
XFILLER_0_71_105 VGND VGND VPWR VPWR sky130_fd_sc_hd__decap_6
XFILLER_0_71_149 VGND VGND VPWR VPWR sky130_fd_sc_hd__decap_8
XFILLER_0_37_393 VGND VGND VPWR VPWR sky130_fd_sc_hd__decap_6
XFILLER_0_107_281 VPWR VGND VPWR VGND sky130_ef_sc_hd__decap_12
XFILLER_0_8_27 VGND VGND VPWR VPWR sky130_fd_sc_hd__fill_1
XFILLER_0_52_341 VGND VGND VPWR VPWR sky130_fd_sc_hd__decap_3
XFILLER_0_52_363 VGND VGND VPWR VPWR sky130_fd_sc_hd__fill_1
X_4490_ _3596_ _3597_ _3394_ VGND VGND VPWR VPWR _3598_ sky130_fd_sc_hd__mux2_4
XTAP_TAPCELL_ROW_77_1124 VGND VPWR sky130_fd_sc_hd__tapvpwrvgnd_1
XFILLER_0_69_57 VPWR VGND VPWR VGND sky130_ef_sc_hd__decap_12
XFILLER_0_25_588 VPWR VGND VPWR VGND sky130_ef_sc_hd__decap_12
XFILLER_0_69_79 VGND VGND VPWR VPWR sky130_fd_sc_hd__fill_2
XFILLER_0_40_569 VGND VGND VPWR VPWR sky130_fd_sc_hd__decap_8
XFILLER_0_100_76 VGND VGND VPWR VPWR sky130_fd_sc_hd__decap_8
X_6160_ _1409_ _1415_ VGND VGND VPWR VPWR _1546_ sky130_fd_sc_hd__or2b_1
XFILLER_0_85_23 VPWR VGND VPWR VGND sky130_ef_sc_hd__decap_12
X_5111_ _3259_ _0400_ VGND VGND VPWR VPWR _0401_ sky130_fd_sc_hd__xnor2_1
XFILLER_0_109_41 VPWR VGND VPWR VGND sky130_ef_sc_hd__decap_12
X_6091_ _1467_ _1469_ _1470_ VGND VGND VPWR VPWR _1471_ sky130_fd_sc_hd__or3_4
X_5042_ _3748_ net28 _2452_ _2649_ VGND VGND VPWR VPWR _0326_ sky130_fd_sc_hd__and4_1
XFILLER_0_109_85 VGND VGND VPWR VPWR sky130_fd_sc_hd__fill_2
XFILLER_0_18_83 VGND VGND VPWR VPWR sky130_fd_sc_hd__fill_1
XTAP_TAPCELL_ROW_88_1253 VGND VPWR sky130_fd_sc_hd__tapvpwrvgnd_1
X_6993_ _2280_ _2282_ _2455_ VGND VGND VPWR VPWR _2457_ sky130_fd_sc_hd__nor3_1
X_5944_ _1308_ _1309_ VGND VGND VPWR VPWR _1310_ sky130_fd_sc_hd__xnor2_1
XFILLER_0_47_113 VGND VGND VPWR VPWR sky130_fd_sc_hd__decap_6
XFILLER_0_48_614 VPWR VGND VPWR VGND sky130_ef_sc_hd__decap_12
XFILLER_0_87_293 VPWR VGND VPWR VGND sky130_ef_sc_hd__decap_12
X_5875_ _1214_ _1216_ _1218_ _1234_ VGND VGND VPWR VPWR _1235_ sky130_fd_sc_hd__a31o_1
X_7614_ _1752_ _2157_ _2907_ _2906_ VGND VGND VPWR VPWR _3136_ sky130_fd_sc_hd__a31o_1
X_4826_ _0007_ _0090_ VGND VGND VPWR VPWR _0091_ sky130_fd_sc_hd__and2_1
XFILLER_0_63_617 VGND VGND VPWR VPWR sky130_fd_sc_hd__decap_3
XFILLER_0_7_210 VPWR VGND VPWR VGND sky130_ef_sc_hd__decap_12
X_7545_ _3059_ _0399_ _2875_ VGND VGND VPWR VPWR _3060_ sky130_fd_sc_hd__or3_1
XFILLER_0_16_533 VPWR VGND VPWR VGND sky130_ef_sc_hd__decap_12
XTAP_TAPCELL_ROW_99_1371 VGND VPWR sky130_fd_sc_hd__tapvpwrvgnd_1
XFILLER_0_71_650 VGND VGND VPWR VPWR sky130_fd_sc_hd__fill_2
X_4757_ net30 VGND VGND VPWR VPWR _0018_ sky130_fd_sc_hd__buf_6
X_7476_ _2968_ _2983_ _2984_ VGND VGND VPWR VPWR _2985_ sky130_fd_sc_hd__nor3_1
X_4688_ _3763_ _3704_ _3791_ _3792_ VGND VGND VPWR VPWR _3793_ sky130_fd_sc_hd__o211ai_4
XFILLER_0_101_402 VGND VGND VPWR VPWR sky130_fd_sc_hd__fill_1
X_6427_ _1835_ _1836_ VGND VGND VPWR VPWR _1837_ sky130_fd_sc_hd__nor2_1
XFILLER_0_101_424 VPWR VGND VPWR VGND sky130_ef_sc_hd__decap_12
X_6358_ _1760_ _1761_ VGND VGND VPWR VPWR _1762_ sky130_fd_sc_hd__and2b_1
X_5309_ _3260_ _0378_ _0614_ _0616_ VGND VGND VPWR VPWR _0618_ sky130_fd_sc_hd__o211a_1
XFILLER_0_11_271 VGND VGND VPWR VPWR sky130_fd_sc_hd__fill_1
X_6289_ _3185_ net45 net44 _3152_ VGND VGND VPWR VPWR _1687_ sky130_fd_sc_hd__a22o_1
XFILLER_0_98_503 VPWR VGND VPWR VGND sky130_ef_sc_hd__decap_12
XFILLER_0_85_219 VGND VGND VPWR VPWR sky130_fd_sc_hd__decap_4
XFILLER_0_66_444 VPWR VGND VPWR VGND sky130_ef_sc_hd__decap_12
XTAP_TAPCELL_ROW_42_715 VGND VPWR sky130_fd_sc_hd__tapvpwrvgnd_1
XFILLER_0_66_477 VPWR VGND VPWR VGND sky130_ef_sc_hd__decap_12
XFILLER_0_81_447 VGND VGND VPWR VPWR sky130_fd_sc_hd__fill_1
XFILLER_0_19_393 VGND VGND VPWR VPWR sky130_fd_sc_hd__decap_4
XTAP_TAPCELL_ROW_22_494 VGND VPWR sky130_fd_sc_hd__tapvpwrvgnd_1
XFILLER_0_34_385 VGND VGND VPWR VPWR sky130_fd_sc_hd__decap_3
XFILLER_0_104_251 VGND VGND VPWR VPWR sky130_fd_sc_hd__fill_1
XFILLER_0_61_193 VPWR VGND VPWR VGND sky130_ef_sc_hd__decap_12
XFILLER_0_39_27 VPWR VGND VPWR VGND sky130_ef_sc_hd__decap_12
XTAP_TAPCELL_ROW_72_1065 VGND VPWR sky130_fd_sc_hd__tapvpwrvgnd_1
XFILLER_0_89_525 VPWR VGND VPWR VGND sky130_ef_sc_hd__decap_12
XFILLER_0_89_558 VGND VGND VPWR VPWR sky130_fd_sc_hd__fill_2
X_3990_ net31 VGND VGND VPWR VPWR _1643_ sky130_fd_sc_hd__buf_4
XFILLER_0_71_69 VPWR VGND VPWR VGND sky130_ef_sc_hd__decap_12
XFILLER_0_29_113 VPWR VGND VPWR VGND sky130_ef_sc_hd__decap_12
XTAP_TAPCELL_ROW_83_1194 VGND VPWR sky130_fd_sc_hd__tapvpwrvgnd_1
X_5660_ _0983_ _0999_ VGND VGND VPWR VPWR _1000_ sky130_fd_sc_hd__xnor2_1
XFILLER_0_45_617 VPWR VGND VPWR VGND sky130_ef_sc_hd__decap_12
X_4611_ _3483_ _3716_ _3340_ VGND VGND VPWR VPWR _3717_ sky130_fd_sc_hd__mux2_2
XFILLER_0_44_138 VGND VGND VPWR VPWR sky130_fd_sc_hd__fill_2
XFILLER_0_72_469 VGND VGND VPWR VPWR sky130_fd_sc_hd__decap_6
X_5591_ net11 net22 net37 net38 VGND VGND VPWR VPWR _0925_ sky130_fd_sc_hd__and4_1
X_4542_ _2758_ _3595_ _2824_ VGND VGND VPWR VPWR _3649_ sky130_fd_sc_hd__a21oi_1
X_7330_ _2817_ _2825_ VGND VGND VPWR VPWR _2826_ sky130_fd_sc_hd__xnor2_1
XFILLER_0_13_503 VGND VGND VPWR VPWR sky130_fd_sc_hd__fill_1
X_7261_ _2731_ _2551_ _2748_ _2749_ VGND VGND VPWR VPWR _2750_ sky130_fd_sc_hd__o211ai_2
XFILLER_0_80_491 VPWR VGND VPWR VGND sky130_ef_sc_hd__decap_12
X_4473_ _3577_ _3578_ _3579_ VGND VGND VPWR VPWR _3581_ sky130_fd_sc_hd__a21o_1
Xmax_cap112 _1136_ VGND VGND VPWR VPWR net112 sky130_fd_sc_hd__buf_2
XFILLER_0_52_193 VGND VGND VPWR VPWR sky130_fd_sc_hd__decap_3
X_6212_ net155 net142 net14 VGND VGND VPWR VPWR _1603_ sky130_fd_sc_hd__and3_1
XFILLER_0_40_388 VPWR VGND VPWR VGND sky130_ef_sc_hd__decap_12
X_7192_ _0072_ _0083_ VGND VGND VPWR VPWR _2674_ sky130_fd_sc_hd__nand2_1
XFILLER_0_0_474 VGND VGND VPWR VPWR sky130_fd_sc_hd__fill_2
X_6143_ _1422_ _1425_ _1526_ VGND VGND VPWR VPWR _1527_ sky130_fd_sc_hd__o21ba_1
X_6074_ _1298_ _1301_ _1299_ VGND VGND VPWR VPWR _1452_ sky130_fd_sc_hd__o21ba_1
X_5025_ _0220_ _0259_ _0260_ VGND VGND VPWR VPWR _0307_ sky130_fd_sc_hd__nand3_1
XFILLER_0_24_3 VPWR VGND VPWR VGND sky130_ef_sc_hd__decap_12
XFILLER_0_45_92 VGND VGND VPWR VPWR sky130_fd_sc_hd__fill_1
XFILLER_0_95_517 VPWR VGND VPWR VGND sky130_ef_sc_hd__decap_12
X_6976_ _2250_ _2252_ _2249_ VGND VGND VPWR VPWR _2438_ sky130_fd_sc_hd__o21ba_1
X_5927_ _1273_ _1274_ _1289_ VGND VGND VPWR VPWR _1291_ sky130_fd_sc_hd__nand3_2
XFILLER_0_75_252 VGND VGND VPWR VPWR sky130_fd_sc_hd__fill_1
XFILLER_0_35_105 VGND VGND VPWR VPWR sky130_fd_sc_hd__decap_6
XFILLER_0_48_477 VPWR VGND VPWR VGND sky130_ef_sc_hd__decap_12
X_5858_ _1348_ _1215_ VGND VGND VPWR VPWR _1216_ sky130_fd_sc_hd__nand2_1
XFILLER_0_63_447 VGND VGND VPWR VPWR sky130_fd_sc_hd__fill_1
XFILLER_0_8_552 VPWR VGND VPWR VGND sky130_ef_sc_hd__decap_12
XFILLER_0_106_538 VPWR VGND VPWR VGND sky130_ef_sc_hd__decap_12
X_5789_ _1026_ _1034_ VGND VGND VPWR VPWR _1141_ sky130_fd_sc_hd__or2b_4
XFILLER_0_8_585 VGND VGND VPWR VPWR sky130_fd_sc_hd__decap_3
XPHY_EDGE_ROW_17_Right_17 VGND VGND VPWR VPWR sky130_fd_sc_hd__decap_3
XFILLER_0_28_190 VGND VGND VPWR VPWR sky130_fd_sc_hd__decap_6
X_4809_ _0069_ _0070_ _0035_ VGND VGND VPWR VPWR _0073_ sky130_fd_sc_hd__a21o_1
X_7528_ _2996_ _3041_ VGND VGND VPWR VPWR _3042_ sky130_fd_sc_hd__xnor2_1
X_7459_ _2957_ _2964_ VGND VGND VPWR VPWR _2967_ sky130_fd_sc_hd__nor2_1
XFILLER_0_31_344 VPWR VGND VPWR VGND sky130_ef_sc_hd__decap_12
XFILLER_0_101_221 VGND VGND VPWR VPWR sky130_fd_sc_hd__decap_3
XPHY_EDGE_ROW_26_Right_26 VGND VGND VPWR VPWR sky130_fd_sc_hd__decap_3
XTAP_TAPCELL_ROW_106_1459 VGND VPWR sky130_fd_sc_hd__tapvpwrvgnd_1
XFILLER_0_98_388 VPWR VGND VPWR VGND sky130_ef_sc_hd__decap_12
XTAP_TAPCELL_ROW_27_542 VGND VPWR sky130_fd_sc_hd__tapvpwrvgnd_1
XTAP_TAPCELL_ROW_55_873 VGND VPWR sky130_fd_sc_hd__tapvpwrvgnd_1
XFILLER_0_27_606 VGND VGND VPWR VPWR sky130_fd_sc_hd__decap_3
XFILLER_0_27_628 VPWR VGND VPWR VGND sky130_ef_sc_hd__decap_12
XFILLER_0_109_365 VPWR VGND VPWR VGND sky130_ef_sc_hd__decap_12
XPHY_EDGE_ROW_35_Right_35 VGND VGND VPWR VPWR sky130_fd_sc_hd__decap_3
XFILLER_0_54_414 VGND VGND VPWR VPWR sky130_fd_sc_hd__decap_6
XFILLER_0_26_149 VPWR VGND VPWR VGND sky130_ef_sc_hd__decap_12
XFILLER_0_35_650 VGND VGND VPWR VPWR sky130_fd_sc_hd__fill_2
XFILLER_0_41_119 VGND VGND VPWR VPWR sky130_fd_sc_hd__fill_1
XFILLER_0_62_491 VGND VGND VPWR VPWR sky130_fd_sc_hd__fill_1
XFILLER_0_34_193 VGND VGND VPWR VPWR sky130_fd_sc_hd__decap_3
XFILLER_0_50_642 VGND VGND VPWR VPWR sky130_fd_sc_hd__fill_2
XFILLER_0_5_39 VPWR VGND VPWR VGND sky130_ef_sc_hd__decap_12
XPHY_EDGE_ROW_44_Right_44 VGND VGND VPWR VPWR sky130_fd_sc_hd__decap_3
XFILLER_0_66_58 VGND VGND VPWR VPWR sky130_fd_sc_hd__decap_6
XTAP_TAPCELL_ROW_85_1212 VGND VPWR sky130_fd_sc_hd__tapvpwrvgnd_1
XFILLER_0_106_53 VPWR VGND VPWR VGND sky130_ef_sc_hd__decap_12
X_6830_ _2275_ _2276_ _2263_ VGND VGND VPWR VPWR _2279_ sky130_fd_sc_hd__o21a_1
XFILLER_0_106_97 VPWR VGND VPWR VGND sky130_ef_sc_hd__decap_12
XFILLER_0_9_305 VGND VGND VPWR VPWR sky130_fd_sc_hd__fill_2
X_6761_ _2199_ _2201_ _2202_ VGND VGND VPWR VPWR _2203_ sky130_fd_sc_hd__nand3_2
XFILLER_0_57_263 VPWR VGND VPWR VGND sky130_ef_sc_hd__decap_12
XFILLER_0_9_349 VGND VGND VPWR VPWR sky130_fd_sc_hd__decap_8
X_5712_ _1054_ net135 _1035_ VGND VGND VPWR VPWR _1057_ sky130_fd_sc_hd__a21oi_4
X_3973_ _1446_ VGND VGND VPWR VPWR _1457_ sky130_fd_sc_hd__buf_4
XPHY_EDGE_ROW_53_Right_53 VGND VGND VPWR VPWR sky130_fd_sc_hd__decap_3
XFILLER_0_18_639 VGND VGND VPWR VPWR sky130_fd_sc_hd__decap_4
X_6692_ _2126_ _2125_ _2022_ VGND VGND VPWR VPWR _2128_ sky130_fd_sc_hd__o21ai_2
XFILLER_0_45_414 VGND VGND VPWR VPWR sky130_fd_sc_hd__fill_1
XFILLER_0_72_233 VGND VGND VPWR VPWR sky130_fd_sc_hd__decap_8
X_5643_ _0929_ _0740_ _0738_ _0737_ VGND VGND VPWR VPWR _0981_ sky130_fd_sc_hd__and4b_1
XFILLER_0_45_447 VGND VGND VPWR VPWR sky130_fd_sc_hd__fill_1
XFILLER_0_60_406 VGND VGND VPWR VPWR sky130_fd_sc_hd__fill_1
X_5574_ _0903_ _0902_ _0904_ VGND VGND VPWR VPWR _0906_ sky130_fd_sc_hd__a21o_1
XTAP_TAPCELL_ROW_96_1341 VGND VPWR sky130_fd_sc_hd__tapvpwrvgnd_1
X_7313_ _3329_ _0311_ _2805_ _2806_ VGND VGND VPWR VPWR _2807_ sky130_fd_sc_hd__o2bb2a_1
X_4525_ _3574_ _3575_ _3576_ VGND VGND VPWR VPWR _3632_ sky130_fd_sc_hd__a21bo_1
X_4456_ _3313_ _3422_ _3564_ VGND VGND VPWR VPWR _3565_ sky130_fd_sc_hd__a21boi_1
X_7244_ _2548_ _2547_ VGND VGND VPWR VPWR _2731_ sky130_fd_sc_hd__and2b_1
XPHY_EDGE_ROW_62_Right_62 VGND VGND VPWR VPWR sky130_fd_sc_hd__decap_3
X_7175_ _0442_ _2655_ VGND VGND VPWR VPWR _2656_ sky130_fd_sc_hd__xor2_1
X_4387_ _3494_ _3495_ _3493_ VGND VGND VPWR VPWR _3497_ sky130_fd_sc_hd__a21oi_1
X_6126_ _0964_ _1508_ _1366_ VGND VGND VPWR VPWR _1509_ sky130_fd_sc_hd__mux2_1
XFILLER_0_56_91 VGND VGND VPWR VPWR sky130_fd_sc_hd__fill_1
X_6057_ _0634_ net34 _1643_ net129 VGND VGND VPWR VPWR _1433_ sky130_fd_sc_hd__and4_1
X_5008_ _3374_ _0283_ _0288_ VGND VGND VPWR VPWR _0289_ sky130_fd_sc_hd__a21oi_1
XFILLER_0_68_506 VGND VGND VPWR VPWR sky130_fd_sc_hd__decap_6
XPHY_EDGE_ROW_71_Right_71 VGND VGND VPWR VPWR sky130_fd_sc_hd__decap_3
X_6959_ _2417_ _2418_ VGND VGND VPWR VPWR _2420_ sky130_fd_sc_hd__xnor2_1
XTAP_TAPCELL_ROW_24_512 VGND VPWR sky130_fd_sc_hd__tapvpwrvgnd_1
XFILLER_0_48_263 VPWR VGND VPWR VGND sky130_ef_sc_hd__decap_12
XTAP_TAPCELL_ROW_52_832 VGND VPWR sky130_fd_sc_hd__tapvpwrvgnd_1
XFILLER_0_91_531 VGND VGND VPWR VPWR sky130_fd_sc_hd__decap_4
XFILLER_0_23_108 VGND VGND VPWR VPWR sky130_fd_sc_hd__decap_4
XFILLER_0_23_119 VGND VGND VPWR VPWR sky130_fd_sc_hd__decap_6
XFILLER_0_32_620 VGND VGND VPWR VPWR sky130_fd_sc_hd__decap_6
XPHY_EDGE_ROW_80_Right_80 VGND VGND VPWR VPWR sky130_fd_sc_hd__decap_3
XTAP_TAPCELL_ROW_4_281 VGND VPWR sky130_fd_sc_hd__tapvpwrvgnd_1
XFILLER_0_98_163 VGND VGND VPWR VPWR sky130_fd_sc_hd__decap_4
XFILLER_0_59_517 VGND VGND VPWR VPWR sky130_fd_sc_hd__fill_1
XFILLER_0_86_358 VGND VGND VPWR VPWR sky130_fd_sc_hd__decap_6
XFILLER_0_52_27 VGND VGND VPWR VPWR sky130_fd_sc_hd__fill_1
XFILLER_0_67_561 VPWR VGND VPWR VGND sky130_ef_sc_hd__decap_12
XTAP_TAPCELL_ROW_80_1153 VGND VPWR sky130_fd_sc_hd__tapvpwrvgnd_1
XFILLER_0_27_447 VGND VGND VPWR VPWR sky130_fd_sc_hd__fill_1
XFILLER_0_22_141 VGND VGND VPWR VPWR sky130_fd_sc_hd__decap_6
X_4310_ _3401_ _3402_ _3403_ _3420_ VGND VGND VPWR VPWR _3421_ sky130_fd_sc_hd__a31o_1
X_5290_ _3260_ _3261_ _0594_ _0596_ VGND VGND VPWR VPWR _0597_ sky130_fd_sc_hd__a31o_1
XFILLER_0_2_558 VGND VGND VPWR VPWR sky130_fd_sc_hd__fill_1
X_4241_ _3350_ _3352_ VGND VGND VPWR VPWR _3353_ sky130_fd_sc_hd__nor2_2
XFILLER_0_77_57 VGND VGND VPWR VPWR sky130_fd_sc_hd__decap_4
XTAP_TAPCELL_ROW_91_1282 VGND VPWR sky130_fd_sc_hd__tapvpwrvgnd_1
X_4172_ _1370_ _2146_ _3282_ _3283_ VGND VGND VPWR VPWR _3284_ sky130_fd_sc_hd__a211o_1
XFILLER_0_92_306 VGND VGND VPWR VPWR sky130_fd_sc_hd__fill_2
X_6813_ _2257_ _2258_ _2259_ VGND VGND VPWR VPWR _2260_ sky130_fd_sc_hd__nor3_1
XFILLER_0_73_520 VPWR VGND VPWR VGND sky130_ef_sc_hd__decap_12
X_3956_ _1260_ VGND VGND VPWR VPWR _1271_ sky130_fd_sc_hd__clkbuf_4
XFILLER_0_58_594 VPWR VGND VPWR VGND sky130_ef_sc_hd__decap_12
X_6744_ _2082_ _2083_ _2093_ VGND VGND VPWR VPWR _2184_ sky130_fd_sc_hd__nand3_1
XFILLER_0_85_391 VGND VGND VPWR VPWR sky130_fd_sc_hd__fill_1
X_6675_ _2107_ _2108_ VGND VGND VPWR VPWR _2109_ sky130_fd_sc_hd__nor2_1
XFILLER_0_42_93 VGND VGND VPWR VPWR sky130_fd_sc_hd__decap_4
XFILLER_0_91_3 VPWR VGND VPWR VGND sky130_ef_sc_hd__decap_12
X_3887_ _0497_ _0508_ VGND VGND VPWR VPWR _0518_ sky130_fd_sc_hd__nor2_2
X_5626_ _0780_ _0682_ _3360_ VGND VGND VPWR VPWR _0963_ sky130_fd_sc_hd__mux2_1
XFILLER_0_103_305 VPWR VGND VPWR VGND sky130_ef_sc_hd__decap_12
XFILLER_0_26_480 VGND VGND VPWR VPWR sky130_fd_sc_hd__decap_3
XFILLER_0_103_349 VGND VGND VPWR VPWR sky130_fd_sc_hd__fill_1
X_5557_ _2495_ _1555_ _0240_ _2342_ VGND VGND VPWR VPWR _0887_ sky130_fd_sc_hd__a22oi_1
X_4508_ _2758_ _3417_ _3615_ VGND VGND VPWR VPWR _3616_ sky130_fd_sc_hd__o21ai_1
X_5488_ _0750_ _0692_ _0810_ _0811_ VGND VGND VPWR VPWR _0812_ sky130_fd_sc_hd__o211ai_4
X_4439_ _3458_ _3454_ _3311_ VGND VGND VPWR VPWR _3548_ sky130_fd_sc_hd__mux2_1
X_7227_ _2696_ _2697_ _2711_ VGND VGND VPWR VPWR _2712_ sky130_fd_sc_hd__a21oi_1
XFILLER_0_1_580 VPWR VGND VPWR VGND sky130_ef_sc_hd__decap_12
XFILLER_0_6_93 VGND VGND VPWR VPWR sky130_fd_sc_hd__fill_1
X_7158_ _2427_ _2429_ _2635_ _2636_ VGND VGND VPWR VPWR _2637_ sky130_fd_sc_hd__o211a_1
X_7089_ _2558_ _2559_ _2560_ VGND VGND VPWR VPWR _2562_ sky130_fd_sc_hd__nor3_1
X_6109_ _1425_ _1426_ _1488_ _1489_ VGND VGND VPWR VPWR _1491_ sky130_fd_sc_hd__and4bb_1
XTAP_TAPCELL_ROW_1_251 VGND VPWR sky130_fd_sc_hd__tapvpwrvgnd_1
XFILLER_0_96_645 VGND VGND VPWR VPWR sky130_fd_sc_hd__decap_6
XTAP_TAPCELL_ROW_103_1418 VGND VPWR sky130_fd_sc_hd__tapvpwrvgnd_1
XFILLER_0_76_380 VGND VGND VPWR VPWR sky130_fd_sc_hd__decap_8
XFILLER_0_22_19 VGND VGND VPWR VPWR sky130_fd_sc_hd__fill_1
XFILLER_0_106_132 VGND VGND VPWR VPWR sky130_fd_sc_hd__decap_8
XFILLER_0_91_361 VGND VGND VPWR VPWR sky130_fd_sc_hd__fill_1
XFILLER_0_36_277 VGND VGND VPWR VPWR sky130_fd_sc_hd__decap_3
XFILLER_0_106_165 VGND VGND VPWR VPWR sky130_fd_sc_hd__decap_3
XFILLER_0_36_299 VGND VGND VPWR VPWR sky130_fd_sc_hd__decap_8
XFILLER_0_51_247 VPWR VGND VPWR VGND sky130_ef_sc_hd__decap_12
XFILLER_0_20_601 VPWR VGND VPWR VGND sky130_ef_sc_hd__decap_12
XFILLER_0_102_360 VGND VGND VPWR VPWR sky130_fd_sc_hd__decap_4
XTAP_TAPCELL_ROW_9_340 VGND VPWR sky130_fd_sc_hd__tapvpwrvgnd_1
XFILLER_0_20_645 VGND VGND VPWR VPWR sky130_fd_sc_hd__decap_6
XTAP_TAPCELL_ROW_69_1026 VGND VPWR sky130_fd_sc_hd__tapvpwrvgnd_1
XFILLER_0_2_29 VPWR VGND VPWR VGND sky130_ef_sc_hd__decap_12
XFILLER_0_87_601 VPWR VGND VPWR VGND sky130_ef_sc_hd__decap_12
XFILLER_0_99_494 VGND VGND VPWR VPWR sky130_fd_sc_hd__decap_3
XFILLER_0_86_122 VGND VGND VPWR VPWR sky130_fd_sc_hd__decap_3
XFILLER_0_59_314 VPWR VGND VPWR VGND sky130_ef_sc_hd__decap_12
XFILLER_0_86_133 VGND VGND VPWR VPWR sky130_fd_sc_hd__fill_1
XFILLER_0_86_177 VPWR VGND VPWR VGND sky130_ef_sc_hd__decap_12
XFILLER_0_74_328 VGND VGND VPWR VPWR sky130_fd_sc_hd__decap_3
X_4790_ _0047_ _0051_ VGND VGND VPWR VPWR _0052_ sky130_fd_sc_hd__xnor2_1
XANTENNA_18 _3542_ VGND VGND VPWR VPWR sky130_fd_sc_hd__diode_2
XFILLER_0_7_617 VPWR VGND VPWR VGND sky130_ef_sc_hd__decap_12
XFILLER_0_55_575 VGND VGND VPWR VPWR sky130_fd_sc_hd__decap_3
XFILLER_0_12_41 VPWR VGND VPWR VGND sky130_ef_sc_hd__decap_12
XFILLER_0_27_277 VGND VGND VPWR VPWR sky130_fd_sc_hd__decap_3
XFILLER_0_70_545 VPWR VGND VPWR VGND sky130_ef_sc_hd__decap_12
XFILLER_0_12_85 VGND VGND VPWR VPWR sky130_fd_sc_hd__decap_4
X_6460_ _1864_ _1871_ _1873_ VGND VGND VPWR VPWR _1874_ sky130_fd_sc_hd__nand3_1
XFILLER_0_42_225 VGND VGND VPWR VPWR sky130_fd_sc_hd__decap_4
X_5411_ _0286_ _0728_ _0402_ VGND VGND VPWR VPWR _0729_ sky130_fd_sc_hd__mux2_1
XFILLER_0_88_45 VGND VGND VPWR VPWR sky130_fd_sc_hd__fill_1
XFILLER_0_70_589 VGND VGND VPWR VPWR sky130_fd_sc_hd__decap_6
X_6391_ _1797_ _1795_ _1682_ VGND VGND VPWR VPWR _1799_ sky130_fd_sc_hd__o21ai_2
XTAP_TAPCELL_ROW_93_1311 VGND VPWR sky130_fd_sc_hd__tapvpwrvgnd_1
X_5342_ _0549_ _0568_ _0569_ VGND VGND VPWR VPWR _0653_ sky130_fd_sc_hd__nand3_2
XFILLER_0_23_461 VPWR VGND VPWR VGND sky130_ef_sc_hd__decap_12
X_7012_ _2149_ _2477_ _0842_ VGND VGND VPWR VPWR _2478_ sky130_fd_sc_hd__mux2_1
XFILLER_0_56_6 VGND VGND VPWR VPWR sky130_fd_sc_hd__decap_8
X_5273_ _0575_ _0576_ _0481_ _0483_ VGND VGND VPWR VPWR _0578_ sky130_fd_sc_hd__o211ai_2
X_4224_ _2933_ VGND VGND VPWR VPWR _3336_ sky130_fd_sc_hd__clkbuf_4
X_4155_ net30 VGND VGND VPWR VPWR _3267_ sky130_fd_sc_hd__clkbuf_4
XFILLER_0_37_60 VGND VGND VPWR VPWR sky130_fd_sc_hd__decap_3
XFILLER_0_97_409 VPWR VGND VPWR VGND sky130_ef_sc_hd__decap_12
X_4086_ net58 VGND VGND VPWR VPWR _2692_ sky130_fd_sc_hd__buf_4
XFILLER_0_78_645 VGND VGND VPWR VPWR sky130_fd_sc_hd__decap_6
XFILLER_0_78_623 VPWR VGND VPWR VGND sky130_ef_sc_hd__decap_12
XFILLER_0_77_111 VGND VGND VPWR VPWR sky130_fd_sc_hd__fill_1
XFILLER_0_108_419 VGND VGND VPWR VPWR sky130_fd_sc_hd__fill_1
XFILLER_0_108_408 VGND VGND VPWR VPWR sky130_fd_sc_hd__decap_4
X_4988_ _0164_ _0166_ _0265_ _0266_ VGND VGND VPWR VPWR _0267_ sky130_fd_sc_hd__o211ai_2
XFILLER_0_80_309 VGND VGND VPWR VPWR sky130_fd_sc_hd__decap_4
XFILLER_0_61_501 VGND VGND VPWR VPWR sky130_fd_sc_hd__decap_3
X_3939_ _1075_ VGND VGND VPWR VPWR _1086_ sky130_fd_sc_hd__buf_2
X_6727_ _3334_ net46 _2027_ _2026_ VGND VGND VPWR VPWR _2165_ sky130_fd_sc_hd__a31o_1
XFILLER_0_73_383 VGND VGND VPWR VPWR sky130_fd_sc_hd__decap_8
X_6658_ _2088_ _2089_ VGND VGND VPWR VPWR _2090_ sky130_fd_sc_hd__xnor2_1
XFILLER_0_104_625 VPWR VGND VPWR VGND sky130_ef_sc_hd__decap_12
XFILLER_0_103_124 VGND VGND VPWR VPWR sky130_fd_sc_hd__decap_4
XFILLER_0_103_113 VGND VGND VPWR VPWR sky130_fd_sc_hd__decap_3
XFILLER_0_5_160 VGND VGND VPWR VPWR sky130_fd_sc_hd__decap_8
XFILLER_0_33_269 VGND VGND VPWR VPWR sky130_fd_sc_hd__decap_8
X_5609_ _0941_ _0942_ _0821_ VGND VGND VPWR VPWR _0945_ sky130_fd_sc_hd__a21o_1
X_6589_ _2012_ _2013_ VGND VGND VPWR VPWR _2015_ sky130_fd_sc_hd__nor2_1
XTAP_TAPCELL_ROW_6_310 VGND VPWR sky130_fd_sc_hd__tapvpwrvgnd_1
XFILLER_0_88_409 VGND VGND VPWR VPWR sky130_fd_sc_hd__decap_8
XFILLER_0_68_133 VGND VGND VPWR VPWR sky130_fd_sc_hd__decap_6
XFILLER_0_52_512 VPWR VGND VPWR VGND sky130_ef_sc_hd__decap_12
XTAP_TAPCELL_ROW_12_378 VGND VPWR sky130_fd_sc_hd__tapvpwrvgnd_1
Xinput27 A[5] VGND VGND VPWR VPWR net27 sky130_fd_sc_hd__clkbuf_2
Xinput16 A[24] VGND VGND VPWR VPWR net16 sky130_fd_sc_hd__buf_2
XFILLER_0_107_496 VGND VGND VPWR VPWR sky130_fd_sc_hd__decap_8
Xinput49 B[26] VGND VGND VPWR VPWR net49 sky130_fd_sc_hd__buf_1
Xinput38 B[16] VGND VGND VPWR VPWR net38 sky130_fd_sc_hd__buf_2
XTAP_TAPCELL_ROW_40_698 VGND VPWR sky130_fd_sc_hd__tapvpwrvgnd_1
XFILLER_0_52_567 VGND VGND VPWR VPWR sky130_fd_sc_hd__decap_4
XFILLER_0_58_37 VPWR VGND VPWR VGND sky130_ef_sc_hd__decap_12
XFILLER_0_58_26 VGND VGND VPWR VPWR sky130_fd_sc_hd__fill_2
XFILLER_0_32_280 VGND VGND VPWR VPWR sky130_fd_sc_hd__decap_3
XTAP_TAPCELL_ROW_75_1096 VGND VPWR sky130_fd_sc_hd__tapvpwrvgnd_1
XFILLER_0_59_111 VGND VGND VPWR VPWR sky130_fd_sc_hd__fill_1
X_5960_ _1188_ _1295_ _1327_ _1325_ VGND VGND VPWR VPWR _1328_ sky130_fd_sc_hd__a211oi_4
XTAP_TAPCELL_ROW_48_787 VGND VPWR sky130_fd_sc_hd__tapvpwrvgnd_1
XFILLER_0_87_442 VGND VGND VPWR VPWR sky130_fd_sc_hd__decap_6
X_4911_ _0182_ _0183_ _3277_ VGND VGND VPWR VPWR _0184_ sky130_fd_sc_hd__a21o_1
X_5891_ _1142_ _1144_ _1143_ VGND VGND VPWR VPWR _1252_ sky130_fd_sc_hd__o21ba_1
X_7630_ _3138_ _3153_ VGND VGND VPWR VPWR _3154_ sky130_fd_sc_hd__xnor2_1
XFILLER_0_90_68 VGND VGND VPWR VPWR sky130_fd_sc_hd__decap_3
XFILLER_0_87_486 VPWR VGND VPWR VGND sky130_ef_sc_hd__decap_12
X_4842_ _3658_ _0108_ _3339_ VGND VGND VPWR VPWR _0109_ sky130_fd_sc_hd__mux2_1
XFILLER_0_28_520 VPWR VGND VPWR VGND sky130_ef_sc_hd__decap_12
XFILLER_0_90_629 VPWR VGND VPWR VGND sky130_ef_sc_hd__decap_12
X_7561_ _1632_ _2157_ _3379_ _1818_ VGND VGND VPWR VPWR _3078_ sky130_fd_sc_hd__a22o_1
XFILLER_0_74_158 VGND VGND VPWR VPWR sky130_fd_sc_hd__decap_3
XFILLER_0_62_309 VPWR VGND VPWR VGND sky130_ef_sc_hd__decap_12
XFILLER_0_7_447 VGND VGND VPWR VPWR sky130_fd_sc_hd__fill_1
XFILLER_0_28_564 VPWR VGND VPWR VGND sky130_ef_sc_hd__decap_12
X_4773_ _0031_ _0032_ _3328_ _1632_ VGND VGND VPWR VPWR _0033_ sky130_fd_sc_hd__o211a_1
XFILLER_0_99_55 VGND VGND VPWR VPWR sky130_fd_sc_hd__fill_1
X_7492_ _3333_ net52 VGND VGND VPWR VPWR _3003_ sky130_fd_sc_hd__nand2_1
XFILLER_0_55_383 VGND VGND VPWR VPWR sky130_fd_sc_hd__decap_8
XFILLER_0_55_372 VGND VGND VPWR VPWR sky130_fd_sc_hd__fill_1
X_6512_ _1755_ _1758_ VGND VGND VPWR VPWR _1931_ sky130_fd_sc_hd__and2b_1
XFILLER_0_15_225 VPWR VGND VPWR VGND sky130_ef_sc_hd__decap_12
XFILLER_0_99_77 VGND VGND VPWR VPWR sky130_fd_sc_hd__fill_1
X_6443_ _2922_ _3524_ _0867_ net44 VGND VGND VPWR VPWR _1855_ sky130_fd_sc_hd__and4_1
XFILLER_0_70_386 VGND VGND VPWR VPWR sky130_fd_sc_hd__fill_1
XFILLER_0_101_617 VPWR VGND VPWR VGND sky130_ef_sc_hd__decap_12
X_6374_ _1771_ _1772_ _1778_ VGND VGND VPWR VPWR _1780_ sky130_fd_sc_hd__a21o_1
X_5325_ net35 VGND VGND VPWR VPWR _0634_ sky130_fd_sc_hd__buf_2
X_5256_ _0556_ _0557_ _0558_ VGND VGND VPWR VPWR _0559_ sky130_fd_sc_hd__or3_1
XFILLER_0_54_3 VGND VGND VPWR VPWR sky130_fd_sc_hd__fill_2
X_4207_ _2977_ VGND VGND VPWR VPWR _3319_ sky130_fd_sc_hd__buf_4
X_5187_ _0444_ _0445_ _0481_ _0482_ VGND VGND VPWR VPWR _0484_ sky130_fd_sc_hd__a2bb2o_1
X_4138_ _3248_ _2517_ _2419_ VGND VGND VPWR VPWR _3250_ sky130_fd_sc_hd__a21oi_1
X_4069_ _2495_ VGND VGND VPWR VPWR _2506_ sky130_fd_sc_hd__buf_4
XFILLER_0_66_615 VGND VGND VPWR VPWR sky130_fd_sc_hd__decap_6
XFILLER_0_53_309 VPWR VGND VPWR VGND sky130_ef_sc_hd__decap_12
XFILLER_0_80_128 VPWR VGND VPWR VGND sky130_ef_sc_hd__decap_12
XFILLER_0_34_512 VPWR VGND VPWR VGND sky130_ef_sc_hd__decap_12
XFILLER_0_73_191 VGND VGND VPWR VPWR sky130_fd_sc_hd__decap_8
XFILLER_0_61_331 VGND VGND VPWR VPWR sky130_fd_sc_hd__decap_4
XFILLER_0_34_545 VGND VGND VPWR VPWR sky130_fd_sc_hd__fill_1
XFILLER_0_61_386 VGND VGND VPWR VPWR sky130_fd_sc_hd__decap_6
XTAP_TAPCELL_ROW_17_437 VGND VPWR sky130_fd_sc_hd__tapvpwrvgnd_1
XTAP_TAPCELL_ROW_45_757 VGND VPWR sky130_fd_sc_hd__tapvpwrvgnd_1
XFILLER_0_60_27 VGND VGND VPWR VPWR sky130_fd_sc_hd__fill_1
XFILLER_0_84_489 VPWR VGND VPWR VGND sky130_ef_sc_hd__decap_12
XFILLER_0_56_169 VGND VGND VPWR VPWR sky130_fd_sc_hd__fill_1
XFILLER_0_25_501 VGND VGND VPWR VPWR sky130_fd_sc_hd__decap_3
XFILLER_0_44_309 VGND VGND VPWR VPWR sky130_fd_sc_hd__fill_1
XFILLER_0_107_271 VGND VGND VPWR VPWR sky130_fd_sc_hd__decap_8
XFILLER_0_80_651 VGND VGND VPWR VPWR sky130_fd_sc_hd__fill_1
XFILLER_0_25_556 VGND VGND VPWR VPWR sky130_fd_sc_hd__decap_4
XFILLER_0_107_293 VGND VGND VPWR VPWR sky130_fd_sc_hd__fill_1
XTAP_TAPCELL_ROW_77_1125 VGND VPWR sky130_fd_sc_hd__tapvpwrvgnd_1
XFILLER_0_69_25 VGND VGND VPWR VPWR sky130_fd_sc_hd__fill_1
XFILLER_0_69_69 VGND VGND VPWR VPWR sky130_fd_sc_hd__decap_4
XFILLER_0_0_601 VPWR VGND VPWR VGND sky130_ef_sc_hd__decap_12
XFILLER_0_0_645 VGND VGND VPWR VPWR sky130_fd_sc_hd__decap_6
XFILLER_0_20_250 VGND VGND VPWR VPWR sky130_fd_sc_hd__fill_2
XFILLER_0_85_35 VPWR VGND VPWR VGND sky130_ef_sc_hd__decap_12
X_5110_ _2003_ _0395_ VGND VGND VPWR VPWR _0400_ sky130_fd_sc_hd__nor2_1
X_6090_ net140 net10 net9 net143 VGND VGND VPWR VPWR _1470_ sky130_fd_sc_hd__a22oi_2
XFILLER_0_85_57 VGND VGND VPWR VPWR sky130_fd_sc_hd__decap_8
X_5041_ _2561_ _1730_ VGND VGND VPWR VPWR _0325_ sky130_fd_sc_hd__nand2_1
XFILLER_0_109_53 VGND VGND VPWR VPWR sky130_fd_sc_hd__decap_3
XTAP_TAPCELL_ROW_88_1254 VGND VPWR sky130_fd_sc_hd__tapvpwrvgnd_1
XTAP_TAPCELL_ROW_88_1243 VGND VPWR sky130_fd_sc_hd__tapvpwrvgnd_1
XFILLER_0_79_239 VGND VGND VPWR VPWR sky130_fd_sc_hd__decap_3
X_6992_ _2280_ _2282_ _2455_ VGND VGND VPWR VPWR _2456_ sky130_fd_sc_hd__o21a_1
XFILLER_0_87_272 VGND VGND VPWR VPWR sky130_fd_sc_hd__decap_8
X_5943_ net58 _2036_ VGND VGND VPWR VPWR _1309_ sky130_fd_sc_hd__nand2_1
XFILLER_0_48_626 VPWR VGND VPWR VGND sky130_ef_sc_hd__decap_12
X_5874_ _0506_ _1220_ _1233_ VGND VGND VPWR VPWR _1234_ sky130_fd_sc_hd__a21o_1
X_7613_ _3131_ _3134_ VGND VGND VPWR VPWR _3135_ sky130_fd_sc_hd__xnor2_1
X_4825_ _1708_ _1752_ VGND VGND VPWR VPWR _0090_ sky130_fd_sc_hd__or2_1
XFILLER_0_7_222 VGND VGND VPWR VPWR sky130_fd_sc_hd__fill_2
X_7544_ _0050_ _0366_ VGND VGND VPWR VPWR _3059_ sky130_fd_sc_hd__nor2_1
XFILLER_0_62_139 VGND VGND VPWR VPWR sky130_fd_sc_hd__fill_1
XFILLER_0_7_244 VGND VGND VPWR VPWR sky130_fd_sc_hd__decap_6
X_4756_ _3342_ _3393_ VGND VGND VPWR VPWR _0017_ sky130_fd_sc_hd__nand2_2
XFILLER_0_7_288 VGND VGND VPWR VPWR sky130_fd_sc_hd__fill_1
XFILLER_0_7_277 VGND VGND VPWR VPWR sky130_fd_sc_hd__decap_3
XFILLER_0_16_545 VGND VGND VPWR VPWR sky130_fd_sc_hd__decap_4
XTAP_TAPCELL_ROW_99_1372 VGND VPWR sky130_fd_sc_hd__tapvpwrvgnd_1
X_7475_ _2969_ _2970_ _2982_ VGND VGND VPWR VPWR _2984_ sky130_fd_sc_hd__and3_1
X_4687_ _3789_ _3790_ _3770_ VGND VGND VPWR VPWR _3792_ sky130_fd_sc_hd__a21o_1
XFILLER_0_16_589 VPWR VGND VPWR VGND sky130_ef_sc_hd__decap_12
XFILLER_0_70_183 VGND VGND VPWR VPWR sky130_fd_sc_hd__fill_1
XFILLER_0_3_461 VGND VGND VPWR VPWR sky130_fd_sc_hd__decap_6
XFILLER_0_31_559 VGND VGND VPWR VPWR sky130_fd_sc_hd__fill_1
X_6426_ _3329_ _0213_ _1834_ VGND VGND VPWR VPWR _1836_ sky130_fd_sc_hd__a21oi_1
XFILLER_0_101_436 VPWR VGND VPWR VGND sky130_ef_sc_hd__decap_12
X_6357_ _1758_ _1759_ _1754_ VGND VGND VPWR VPWR _1761_ sky130_fd_sc_hd__a21o_1
X_5308_ _1479_ _0376_ _3751_ _3262_ _0615_ VGND VGND VPWR VPWR _0616_ sky130_fd_sc_hd__o221a_1
X_6288_ _3185_ _3152_ net45 net44 VGND VGND VPWR VPWR _1685_ sky130_fd_sc_hd__and4_1
X_5239_ _2463_ _3749_ VGND VGND VPWR VPWR _0541_ sky130_fd_sc_hd__nor2_1
XFILLER_0_98_515 VPWR VGND VPWR VGND sky130_ef_sc_hd__decap_12
XFILLER_0_98_548 VGND VGND VPWR VPWR sky130_fd_sc_hd__decap_4
XFILLER_0_109_503 VGND VGND VPWR VPWR sky130_fd_sc_hd__fill_1
XFILLER_0_78_283 VGND VGND VPWR VPWR sky130_fd_sc_hd__fill_1
XTAP_TAPCELL_ROW_42_716 VGND VPWR sky130_fd_sc_hd__tapvpwrvgnd_1
XFILLER_0_109_525 VGND VGND VPWR VPWR sky130_fd_sc_hd__decap_6
XFILLER_0_66_489 VPWR VGND VPWR VGND sky130_ef_sc_hd__decap_12
XFILLER_0_66_456 VGND VGND VPWR VPWR sky130_fd_sc_hd__decap_3
XFILLER_0_19_361 VGND VGND VPWR VPWR sky130_fd_sc_hd__fill_1
XFILLER_0_53_128 VGND VGND VPWR VPWR sky130_fd_sc_hd__fill_1
XFILLER_0_62_651 VGND VGND VPWR VPWR sky130_fd_sc_hd__fill_1
XTAP_TAPCELL_ROW_22_484 VGND VPWR sky130_fd_sc_hd__tapvpwrvgnd_1
XTAP_TAPCELL_ROW_22_495 VGND VPWR sky130_fd_sc_hd__tapvpwrvgnd_1
XFILLER_0_39_39 VPWR VGND VPWR VGND sky130_ef_sc_hd__decap_12
XTAP_TAPCELL_ROW_72_1066 VGND VPWR sky130_fd_sc_hd__tapvpwrvgnd_1
XFILLER_0_89_537 VGND VGND VPWR VPWR sky130_fd_sc_hd__fill_1
XFILLER_0_76_209 VPWR VGND VPWR VGND sky130_ef_sc_hd__decap_12
XFILLER_0_97_592 VPWR VGND VPWR VGND sky130_ef_sc_hd__decap_12
XFILLER_0_29_125 VPWR VGND VPWR VGND sky130_ef_sc_hd__decap_12
XFILLER_0_84_253 VGND VGND VPWR VPWR sky130_fd_sc_hd__decap_6
XTAP_TAPCELL_ROW_83_1195 VGND VPWR sky130_fd_sc_hd__tapvpwrvgnd_1
XFILLER_0_29_169 VGND VGND VPWR VPWR sky130_fd_sc_hd__decap_4
XFILLER_0_45_629 VPWR VGND VPWR VGND sky130_ef_sc_hd__decap_12
X_4610_ _3715_ VGND VGND VPWR VPWR _3716_ sky130_fd_sc_hd__inv_2
XFILLER_0_84_286 VGND VGND VPWR VPWR sky130_fd_sc_hd__fill_2
X_5590_ _3097_ _0791_ VGND VGND VPWR VPWR _0924_ sky130_fd_sc_hd__nand2_1
X_4541_ _3589_ _3645_ _3647_ VGND VGND VPWR VPWR _3648_ sky130_fd_sc_hd__a21o_1
XFILLER_0_25_375 VGND VGND VPWR VPWR sky130_fd_sc_hd__fill_2
X_7260_ _2525_ _2732_ _2746_ VGND VGND VPWR VPWR _2749_ sky130_fd_sc_hd__nand3_1
X_4472_ _3577_ _3578_ _3579_ VGND VGND VPWR VPWR _3580_ sky130_fd_sc_hd__and3_1
Xmax_cap113 _1002_ VGND VGND VPWR VPWR net113 sky130_fd_sc_hd__clkbuf_1
X_7191_ _0977_ _2654_ _2668_ _2673_ VGND VGND VPWR VPWR net89 sky130_fd_sc_hd__a211o_1
X_6211_ _1600_ _1601_ VGND VGND VPWR VPWR _1602_ sky130_fd_sc_hd__nor2_1
XFILLER_0_0_453 VGND VGND VPWR VPWR sky130_fd_sc_hd__decap_4
XFILLER_0_0_464 VGND VGND VPWR VPWR sky130_fd_sc_hd__fill_1
X_6142_ _3329_ _1086_ _1403_ _1525_ VGND VGND VPWR VPWR _1526_ sky130_fd_sc_hd__a31oi_1
X_6073_ _1305_ _1323_ _1324_ VGND VGND VPWR VPWR _1451_ sky130_fd_sc_hd__nand3_1
XFILLER_0_29_94 VPWR VGND VPWR VGND sky130_ef_sc_hd__decap_12
X_5024_ _0168_ _0169_ _0270_ _0076_ VGND VGND VPWR VPWR _0306_ sky130_fd_sc_hd__and4b_1
XFILLER_0_17_3 VPWR VGND VPWR VGND sky130_ef_sc_hd__decap_12
XFILLER_0_95_529 VPWR VGND VPWR VGND sky130_ef_sc_hd__decap_12
XFILLER_0_67_209 VPWR VGND VPWR VGND sky130_ef_sc_hd__decap_12
XFILLER_0_48_401 VPWR VGND VPWR VGND sky130_ef_sc_hd__decap_12
X_6975_ _2169_ _2170_ VGND VGND VPWR VPWR _2437_ sky130_fd_sc_hd__nand2_1
X_5926_ _1273_ _1274_ _1289_ VGND VGND VPWR VPWR _1290_ sky130_fd_sc_hd__a21o_2
X_5857_ _1249_ _1080_ _2222_ VGND VGND VPWR VPWR _1215_ sky130_fd_sc_hd__a21o_1
XFILLER_0_8_564 VGND VGND VPWR VPWR sky130_fd_sc_hd__decap_8
XFILLER_0_48_489 VPWR VGND VPWR VGND sky130_ef_sc_hd__decap_12
XFILLER_0_90_256 VGND VGND VPWR VPWR sky130_fd_sc_hd__decap_4
X_5788_ _1027_ _1033_ VGND VGND VPWR VPWR _1139_ sky130_fd_sc_hd__or2b_1
XFILLER_0_44_651 VGND VGND VPWR VPWR sky130_fd_sc_hd__fill_1
X_4808_ _0035_ _0069_ _0070_ VGND VGND VPWR VPWR _0071_ sky130_fd_sc_hd__nand3_1
X_4739_ _3801_ _3798_ _3797_ VGND VGND VPWR VPWR _0000_ sky130_fd_sc_hd__a21bo_1
X_7527_ _2997_ _3040_ VGND VGND VPWR VPWR _3041_ sky130_fd_sc_hd__xnor2_1
XFILLER_0_16_375 VGND VGND VPWR VPWR sky130_fd_sc_hd__decap_4
X_7458_ _2957_ _2964_ VGND VGND VPWR VPWR _2965_ sky130_fd_sc_hd__and2_1
XFILLER_0_43_172 VPWR VGND VPWR VGND sky130_ef_sc_hd__decap_12
X_6409_ _1088_ _1369_ _3754_ VGND VGND VPWR VPWR _1819_ sky130_fd_sc_hd__and3_1
XFILLER_0_31_356 VPWR VGND VPWR VGND sky130_ef_sc_hd__decap_12
X_7389_ _2887_ _2888_ VGND VGND VPWR VPWR _2890_ sky130_fd_sc_hd__nand2_1
XFILLER_0_101_288 VGND VGND VPWR VPWR sky130_fd_sc_hd__decap_4
XFILLER_0_58_209 VGND VGND VPWR VPWR sky130_fd_sc_hd__fill_2
XTAP_TAPCELL_ROW_27_543 VGND VPWR sky130_fd_sc_hd__tapvpwrvgnd_1
XTAP_TAPCELL_ROW_55_874 VGND VPWR sky130_fd_sc_hd__tapvpwrvgnd_1
XFILLER_0_94_540 VPWR VGND VPWR VGND sky130_ef_sc_hd__decap_12
XFILLER_0_109_377 VGND VGND VPWR VPWR sky130_fd_sc_hd__decap_6
XFILLER_0_81_278 VGND VGND VPWR VPWR sky130_fd_sc_hd__fill_2
XFILLER_0_41_109 VGND VGND VPWR VPWR sky130_fd_sc_hd__decap_3
XFILLER_0_1_206 VGND VGND VPWR VPWR sky130_fd_sc_hd__decap_4
XFILLER_0_66_15 VPWR VGND VPWR VGND sky130_ef_sc_hd__decap_12
XPHY_EDGE_ROW_19_Left_129 VGND VGND VPWR VPWR sky130_fd_sc_hd__decap_3
XTAP_TAPCELL_ROW_85_1213 VGND VPWR sky130_fd_sc_hd__tapvpwrvgnd_1
XFILLER_0_106_65 VPWR VGND VPWR VGND sky130_ef_sc_hd__decap_12
X_6760_ _2072_ _2077_ _2071_ VGND VGND VPWR VPWR _2202_ sky130_fd_sc_hd__a21bo_1
X_5711_ _1055_ _1054_ _1035_ VGND VGND VPWR VPWR _1056_ sky130_fd_sc_hd__and3_1
X_3972_ net5 VGND VGND VPWR VPWR _1446_ sky130_fd_sc_hd__buf_6
XFILLER_0_57_275 VGND VGND VPWR VPWR sky130_fd_sc_hd__decap_4
X_6691_ _2022_ _2125_ _2126_ VGND VGND VPWR VPWR _2127_ sky130_fd_sc_hd__or3_4
X_5642_ _0921_ _0931_ _0979_ VGND VGND VPWR VPWR _0980_ sky130_fd_sc_hd__a21oi_1
XFILLER_0_26_651 VGND VGND VPWR VPWR sky130_fd_sc_hd__fill_1
XPHY_EDGE_ROW_28_Left_138 VGND VGND VPWR VPWR sky130_fd_sc_hd__decap_3
XFILLER_0_72_267 VPWR VGND VPWR VGND sky130_ef_sc_hd__decap_12
X_5573_ _0904_ _0903_ _0902_ VGND VGND VPWR VPWR _0905_ sky130_fd_sc_hd__nand3_2
XFILLER_0_32_109 VGND VGND VPWR VPWR sky130_fd_sc_hd__fill_1
XTAP_TAPCELL_ROW_96_1342 VGND VPWR sky130_fd_sc_hd__tapvpwrvgnd_1
X_7312_ _3332_ _3334_ net51 net50 VGND VGND VPWR VPWR _2806_ sky130_fd_sc_hd__and4_1
X_4524_ _3043_ _2561_ _3628_ _3629_ VGND VGND VPWR VPWR _3631_ sky130_fd_sc_hd__a22o_1
XFILLER_0_53_481 VGND VGND VPWR VPWR sky130_fd_sc_hd__decap_3
XFILLER_0_13_345 VPWR VGND VPWR VGND sky130_ef_sc_hd__decap_12
XFILLER_0_40_153 VGND VGND VPWR VPWR sky130_fd_sc_hd__fill_1
X_4455_ _3345_ _3336_ _3493_ _3312_ VGND VGND VPWR VPWR _3564_ sky130_fd_sc_hd__a211o_1
X_7243_ _2727_ _2728_ _2515_ _2530_ VGND VGND VPWR VPWR _2730_ sky130_fd_sc_hd__a211oi_1
XFILLER_0_40_186 VGND VGND VPWR VPWR sky130_fd_sc_hd__decap_8
X_7174_ _0508_ _2317_ _2303_ _2482_ VGND VGND VPWR VPWR _2655_ sky130_fd_sc_hd__o31a_1
X_4386_ _3493_ _3494_ _3495_ VGND VGND VPWR VPWR _3496_ sky130_fd_sc_hd__and3_1
X_6125_ _1223_ _1507_ _0842_ VGND VGND VPWR VPWR _1508_ sky130_fd_sc_hd__mux2_1
XPHY_EDGE_ROW_0_Left_110 VGND VGND VPWR VPWR sky130_fd_sc_hd__decap_3
XFILLER_0_0_294 VGND VGND VPWR VPWR sky130_fd_sc_hd__decap_3
XPHY_EDGE_ROW_37_Left_147 VGND VGND VPWR VPWR sky130_fd_sc_hd__decap_3
X_6056_ _3253_ _1654_ _3268_ _1402_ VGND VGND VPWR VPWR _1432_ sky130_fd_sc_hd__a22oi_2
X_5007_ _3566_ _0197_ _0287_ _0110_ VGND VGND VPWR VPWR _0288_ sky130_fd_sc_hd__a2bb2o_1
XFILLER_0_68_529 VGND VGND VPWR VPWR sky130_fd_sc_hd__decap_3
X_6958_ _1850_ _0802_ VGND VGND VPWR VPWR _2418_ sky130_fd_sc_hd__nand2_1
XTAP_TAPCELL_ROW_24_513 VGND VPWR sky130_fd_sc_hd__tapvpwrvgnd_1
XFILLER_0_48_253 VGND VGND VPWR VPWR sky130_fd_sc_hd__decap_6
XTAP_TAPCELL_ROW_52_833 VGND VPWR sky130_fd_sc_hd__tapvpwrvgnd_1
X_6889_ _2340_ _2341_ VGND VGND VPWR VPWR _2343_ sky130_fd_sc_hd__xor2_1
X_5909_ _1146_ _1153_ VGND VGND VPWR VPWR _1272_ sky130_fd_sc_hd__and2_1
XFILLER_0_36_404 VGND VGND VPWR VPWR sky130_fd_sc_hd__decap_8
XPHY_EDGE_ROW_46_Left_156 VGND VGND VPWR VPWR sky130_fd_sc_hd__decap_3
XFILLER_0_48_275 VGND VGND VPWR VPWR sky130_fd_sc_hd__decap_8
XFILLER_0_106_303 VGND VGND VPWR VPWR sky130_fd_sc_hd__decap_4
XFILLER_0_91_543 VPWR VGND VPWR VGND sky130_ef_sc_hd__decap_12
XFILLER_0_31_164 VGND VGND VPWR VPWR sky130_fd_sc_hd__decap_4
XFILLER_0_6_3 VPWR VGND VPWR VGND sky130_ef_sc_hd__decap_12
XPHY_EDGE_ROW_55_Left_165 VGND VGND VPWR VPWR sky130_fd_sc_hd__decap_3
XTAP_TAPCELL_ROW_4_282 VGND VPWR sky130_fd_sc_hd__tapvpwrvgnd_1
XFILLER_0_67_540 VGND VGND VPWR VPWR sky130_fd_sc_hd__fill_1
XPHY_EDGE_ROW_64_Left_174 VGND VGND VPWR VPWR sky130_fd_sc_hd__decap_3
XFILLER_0_82_521 VGND VGND VPWR VPWR sky130_fd_sc_hd__decap_8
XFILLER_0_67_573 VGND VGND VPWR VPWR sky130_fd_sc_hd__decap_6
XFILLER_0_109_141 VGND VGND VPWR VPWR sky130_fd_sc_hd__decap_8
XFILLER_0_82_543 VGND VGND VPWR VPWR sky130_fd_sc_hd__decap_6
XTAP_TAPCELL_ROW_80_1154 VGND VPWR sky130_fd_sc_hd__tapvpwrvgnd_1
XFILLER_0_54_245 VGND VGND VPWR VPWR sky130_fd_sc_hd__decap_6
XFILLER_0_42_418 VGND VGND VPWR VPWR sky130_fd_sc_hd__fill_2
XFILLER_0_54_278 VGND VGND VPWR VPWR sky130_fd_sc_hd__decap_6
XFILLER_0_2_504 VGND VGND VPWR VPWR sky130_fd_sc_hd__decap_6
X_4240_ _2944_ _3351_ VGND VGND VPWR VPWR _3352_ sky130_fd_sc_hd__nand2_2
XPHY_EDGE_ROW_73_Left_183 VGND VGND VPWR VPWR sky130_fd_sc_hd__decap_3
XFILLER_0_22_197 VGND VGND VPWR VPWR sky130_fd_sc_hd__decap_6
XTAP_TAPCELL_ROW_91_1283 VGND VPWR sky130_fd_sc_hd__tapvpwrvgnd_1
X_4171_ _0933_ _2310_ VGND VGND VPWR VPWR _3283_ sky130_fd_sc_hd__nor2_1
XFILLER_0_93_57 VGND VGND VPWR VPWR sky130_fd_sc_hd__decap_8
XFILLER_0_89_131 VGND VGND VPWR VPWR sky130_fd_sc_hd__fill_2
XFILLER_0_77_315 VGND VGND VPWR VPWR sky130_fd_sc_hd__decap_3
XPHY_EDGE_ROW_82_Left_192 VGND VGND VPWR VPWR sky130_fd_sc_hd__decap_3
XFILLER_0_77_337 VGND VGND VPWR VPWR sky130_fd_sc_hd__fill_1
XFILLER_0_77_326 VGND VGND VPWR VPWR sky130_fd_sc_hd__fill_1
X_6812_ _2032_ _2033_ _2031_ VGND VGND VPWR VPWR _2259_ sky130_fd_sc_hd__o21ba_1
X_3955_ net10 VGND VGND VPWR VPWR _1260_ sky130_fd_sc_hd__clkbuf_4
X_6743_ _2160_ _2182_ VGND VGND VPWR VPWR _2183_ sky130_fd_sc_hd__xnor2_1
XFILLER_0_73_532 VPWR VGND VPWR VGND sky130_ef_sc_hd__decap_12
XFILLER_0_9_169 VPWR VGND VPWR VGND sky130_ef_sc_hd__decap_12
X_6674_ _1457_ _1533_ _2105_ _2106_ VGND VGND VPWR VPWR _2108_ sky130_fd_sc_hd__o2bb2a_1
X_5625_ _0110_ _3423_ _0011_ VGND VGND VPWR VPWR _0962_ sky130_fd_sc_hd__a21o_1
X_3886_ _0246_ _0257_ VGND VGND VPWR VPWR _0508_ sky130_fd_sc_hd__and2_1
XTAP_TAPCELL_ROW_100_1390 VGND VPWR sky130_fd_sc_hd__tapvpwrvgnd_1
XFILLER_0_26_470 VGND VGND VPWR VPWR sky130_fd_sc_hd__decap_6
XFILLER_0_103_317 VPWR VGND VPWR VGND sky130_ef_sc_hd__decap_12
X_5556_ _3748_ _2452_ _0465_ _1829_ VGND VGND VPWR VPWR _0886_ sky130_fd_sc_hd__and4_1
XFILLER_0_5_386 VGND VGND VPWR VPWR sky130_fd_sc_hd__decap_6
X_4507_ _3324_ _3357_ _3405_ _2780_ _3614_ VGND VGND VPWR VPWR _3615_ sky130_fd_sc_hd__o221a_1
X_5487_ _0808_ _0809_ _0774_ VGND VGND VPWR VPWR _0811_ sky130_fd_sc_hd__o21ai_2
XFILLER_0_41_484 VGND VGND VPWR VPWR sky130_fd_sc_hd__fill_2
X_7226_ _2705_ _2710_ VGND VGND VPWR VPWR _2711_ sky130_fd_sc_hd__xnor2_1
X_4438_ _3373_ _3546_ VGND VGND VPWR VPWR _3547_ sky130_fd_sc_hd__nor2_1
XFILLER_0_13_197 VGND VGND VPWR VPWR sky130_fd_sc_hd__decap_8
XFILLER_0_6_83 VGND VGND VPWR VPWR sky130_fd_sc_hd__fill_1
XFILLER_0_1_592 VPWR VGND VPWR VGND sky130_ef_sc_hd__decap_12
X_4369_ _3395_ _3478_ _3374_ VGND VGND VPWR VPWR _3479_ sky130_fd_sc_hd__o21a_1
X_7157_ _2610_ _2611_ _2633_ _2634_ VGND VGND VPWR VPWR _2636_ sky130_fd_sc_hd__a22o_1
X_6108_ _1486_ _1487_ _1328_ _1427_ VGND VGND VPWR VPWR _1489_ sky130_fd_sc_hd__a211o_1
X_7088_ _2361_ _2387_ VGND VGND VPWR VPWR _2560_ sky130_fd_sc_hd__nor2_1
X_6039_ _3692_ net39 VGND VGND VPWR VPWR _1414_ sky130_fd_sc_hd__nand2_1
XTAP_TAPCELL_ROW_1_252 VGND VPWR sky130_fd_sc_hd__tapvpwrvgnd_1
XTAP_TAPCELL_ROW_37_660 VGND VPWR sky130_fd_sc_hd__tapvpwrvgnd_1
XTAP_TAPCELL_ROW_103_1419 VGND VPWR sky130_fd_sc_hd__tapvpwrvgnd_1
XFILLER_0_95_167 VGND VGND VPWR VPWR sky130_fd_sc_hd__fill_1
XTAP_TAPCELL_ROW_65_980 VGND VPWR sky130_fd_sc_hd__tapvpwrvgnd_1
XFILLER_0_95_189 VGND VGND VPWR VPWR sky130_fd_sc_hd__decap_3
XFILLER_0_64_587 VGND VGND VPWR VPWR sky130_fd_sc_hd__fill_1
XFILLER_0_64_598 VPWR VGND VPWR VGND sky130_ef_sc_hd__decap_12
XFILLER_0_17_481 VGND VGND VPWR VPWR sky130_fd_sc_hd__decap_3
XFILLER_0_51_215 VGND VGND VPWR VPWR sky130_fd_sc_hd__decap_8
XFILLER_0_51_259 VPWR VGND VPWR VGND sky130_ef_sc_hd__decap_12
XFILLER_0_20_613 VPWR VGND VPWR VGND sky130_ef_sc_hd__decap_12
XTAP_TAPCELL_ROW_9_341 VGND VPWR sky130_fd_sc_hd__tapvpwrvgnd_1
XTAP_TAPCELL_ROW_69_1027 VGND VPWR sky130_fd_sc_hd__tapvpwrvgnd_1
XFILLER_0_87_613 VGND VGND VPWR VPWR sky130_fd_sc_hd__decap_3
XFILLER_0_59_337 VPWR VGND VPWR VGND sky130_ef_sc_hd__decap_12
XFILLER_0_59_326 VGND VGND VPWR VPWR sky130_fd_sc_hd__decap_8
XFILLER_0_86_189 VGND VGND VPWR VPWR sky130_fd_sc_hd__decap_6
XFILLER_0_74_307 VGND VGND VPWR VPWR sky130_fd_sc_hd__fill_1
XANTENNA_19 _3379_ VGND VGND VPWR VPWR sky130_fd_sc_hd__diode_2
XFILLER_0_7_629 VPWR VGND VPWR VGND sky130_ef_sc_hd__decap_12
XFILLER_0_27_223 VGND VGND VPWR VPWR sky130_fd_sc_hd__fill_1
XFILLER_0_103_55 VGND VGND VPWR VPWR sky130_fd_sc_hd__fill_1
XFILLER_0_12_53 VGND VGND VPWR VPWR sky130_fd_sc_hd__decap_4
X_5410_ _0404_ _0727_ _3482_ VGND VGND VPWR VPWR _0728_ sky130_fd_sc_hd__mux2_1
XFILLER_0_70_557 VPWR VGND VPWR VGND sky130_ef_sc_hd__decap_12
X_6390_ _1682_ _1795_ _1797_ VGND VGND VPWR VPWR _1798_ sky130_fd_sc_hd__or3_4
XTAP_TAPCELL_ROW_93_1301 VGND VPWR sky130_fd_sc_hd__tapvpwrvgnd_1
X_5341_ _0648_ _0650_ _0629_ _0630_ VGND VGND VPWR VPWR _0652_ sky130_fd_sc_hd__a211o_1
XFILLER_0_23_473 VGND VGND VPWR VPWR sky130_fd_sc_hd__decap_6
XFILLER_0_100_309 VGND VGND VPWR VPWR sky130_fd_sc_hd__decap_6
XFILLER_0_10_134 VGND VGND VPWR VPWR sky130_fd_sc_hd__decap_6
X_7011_ _0246_ _0105_ _1089_ VGND VGND VPWR VPWR _2477_ sky130_fd_sc_hd__mux2_1
X_5272_ _0483_ _0481_ _0575_ _0576_ VGND VGND VPWR VPWR _0577_ sky130_fd_sc_hd__a211o_4
X_4223_ _3334_ VGND VGND VPWR VPWR _3335_ sky130_fd_sc_hd__clkbuf_4
X_4154_ _3258_ _3259_ _3262_ _3265_ VGND VGND VPWR VPWR _3266_ sky130_fd_sc_hd__and4_1
XFILLER_0_37_83 VGND VGND VPWR VPWR sky130_fd_sc_hd__decap_6
X_4085_ _2671_ VGND VGND VPWR VPWR _2681_ sky130_fd_sc_hd__clkbuf_4
XPHY_EDGE_ROW_90_Left_200 VGND VGND VPWR VPWR sky130_fd_sc_hd__decap_3
XFILLER_0_78_635 VGND VGND VPWR VPWR sky130_fd_sc_hd__decap_8
XFILLER_0_65_318 VPWR VGND VPWR VGND sky130_ef_sc_hd__decap_12
XTAP_TAPCELL_ROW_62_950 VGND VPWR sky130_fd_sc_hd__tapvpwrvgnd_1
XTAP_TAPCELL_ROW_34_630 VGND VPWR sky130_fd_sc_hd__tapvpwrvgnd_1
XFILLER_0_93_649 VGND VGND VPWR VPWR sky130_fd_sc_hd__decap_3
X_4987_ _0263_ _0264_ _0125_ VGND VGND VPWR VPWR _0266_ sky130_fd_sc_hd__a21o_1
X_6726_ _2030_ _2039_ _2038_ VGND VGND VPWR VPWR _2164_ sky130_fd_sc_hd__a21oi_1
XFILLER_0_73_351 VGND VGND VPWR VPWR sky130_fd_sc_hd__fill_1
X_3938_ net44 VGND VGND VPWR VPWR _1075_ sky130_fd_sc_hd__buf_2
XFILLER_0_46_587 VGND VGND VPWR VPWR sky130_fd_sc_hd__fill_1
X_3869_ net21 VGND VGND VPWR VPWR _0322_ sky130_fd_sc_hd__clkbuf_4
XFILLER_0_61_535 VGND VGND VPWR VPWR sky130_fd_sc_hd__decap_3
XFILLER_0_6_651 VGND VGND VPWR VPWR sky130_fd_sc_hd__fill_1
X_6657_ _1730_ _0769_ VGND VGND VPWR VPWR _2089_ sky130_fd_sc_hd__nand2_1
XFILLER_0_104_637 VGND VGND VPWR VPWR sky130_fd_sc_hd__decap_6
X_6588_ _2009_ _2011_ _2008_ VGND VGND VPWR VPWR _2013_ sky130_fd_sc_hd__a21oi_1
X_5608_ _0821_ _0941_ _0942_ VGND VGND VPWR VPWR _0943_ sky130_fd_sc_hd__nand3_2
X_5539_ _0864_ _0865_ _0866_ VGND VGND VPWR VPWR _0868_ sky130_fd_sc_hd__and3_1
XFILLER_0_14_462 VGND VGND VPWR VPWR sky130_fd_sc_hd__decap_4
XFILLER_0_103_169 VPWR VGND VPWR VGND sky130_ef_sc_hd__decap_12
XTAP_TAPCELL_ROW_6_300 VGND VPWR sky130_fd_sc_hd__tapvpwrvgnd_1
X_7209_ _3668_ _2148_ VGND VGND VPWR VPWR _2693_ sky130_fd_sc_hd__nand2_1
XTAP_TAPCELL_ROW_6_311 VGND VPWR sky130_fd_sc_hd__tapvpwrvgnd_1
XFILLER_0_68_156 VGND VGND VPWR VPWR sky130_fd_sc_hd__decap_6
XFILLER_0_56_307 VGND VGND VPWR VPWR sky130_fd_sc_hd__fill_1
XFILLER_0_83_126 VGND VGND VPWR VPWR sky130_fd_sc_hd__fill_2
XFILLER_0_107_431 VPWR VGND VPWR VGND sky130_ef_sc_hd__decap_12
Xinput28 A[6] VGND VGND VPWR VPWR net28 sky130_fd_sc_hd__buf_2
Xinput17 A[25] VGND VGND VPWR VPWR net17 sky130_fd_sc_hd__buf_1
XFILLER_0_52_524 VGND VGND VPWR VPWR sky130_fd_sc_hd__decap_8
XTAP_TAPCELL_ROW_12_379 VGND VPWR sky130_fd_sc_hd__tapvpwrvgnd_1
Xinput39 B[17] VGND VGND VPWR VPWR net39 sky130_fd_sc_hd__buf_1
XFILLER_0_24_237 VGND VGND VPWR VPWR sky130_fd_sc_hd__decap_3
XTAP_TAPCELL_ROW_40_699 VGND VPWR sky130_fd_sc_hd__tapvpwrvgnd_1
XFILLER_0_58_49 VPWR VGND VPWR VGND sky130_ef_sc_hd__decap_12
XTAP_TAPCELL_ROW_75_1097 VGND VPWR sky130_fd_sc_hd__tapvpwrvgnd_1
XFILLER_0_99_281 VGND VGND VPWR VPWR sky130_fd_sc_hd__decap_8
XFILLER_0_75_605 VGND VGND VPWR VPWR sky130_fd_sc_hd__decap_8
X_4910_ _0019_ _0095_ _0096_ VGND VGND VPWR VPWR _0183_ sky130_fd_sc_hd__a21o_1
X_5890_ _3524_ _0802_ _1122_ _1121_ VGND VGND VPWR VPWR _1251_ sky130_fd_sc_hd__a31o_1
XTAP_TAPCELL_ROW_48_788 VGND VPWR sky130_fd_sc_hd__tapvpwrvgnd_1
XFILLER_0_87_498 VGND VGND VPWR VPWR sky130_fd_sc_hd__decap_6
X_4841_ _3305_ _3271_ _3326_ _3325_ _3309_ _3314_ VGND VGND VPWR VPWR _0108_ sky130_fd_sc_hd__mux4_1
XFILLER_0_74_115 VPWR VGND VPWR VGND sky130_ef_sc_hd__decap_12
XFILLER_0_75_649 VGND VGND VPWR VPWR sky130_fd_sc_hd__decap_3
X_7560_ _1544_ _1009_ VGND VGND VPWR VPWR _3077_ sky130_fd_sc_hd__nand2_1
XFILLER_0_23_74 VGND VGND VPWR VPWR sky130_fd_sc_hd__fill_2
XFILLER_0_28_576 VGND VGND VPWR VPWR sky130_fd_sc_hd__fill_1
X_4772_ _3764_ _3816_ VGND VGND VPWR VPWR _0032_ sky130_fd_sc_hd__and2_1
X_7491_ _3000_ _3001_ VGND VGND VPWR VPWR _3002_ sky130_fd_sc_hd__nor2_1
X_6511_ _1925_ _1926_ _1928_ VGND VGND VPWR VPWR _1930_ sky130_fd_sc_hd__a21o_1
XFILLER_0_15_237 VGND VGND VPWR VPWR sky130_fd_sc_hd__decap_4
X_6442_ _1849_ _1851_ _1852_ VGND VGND VPWR VPWR _1854_ sky130_fd_sc_hd__a21oi_1
XFILLER_0_70_365 VGND VGND VPWR VPWR sky130_fd_sc_hd__fill_2
XFILLER_0_101_629 VPWR VGND VPWR VGND sky130_ef_sc_hd__decap_12
X_6373_ _1771_ _1772_ _1778_ VGND VGND VPWR VPWR _1779_ sky130_fd_sc_hd__nand3_1
XFILLER_0_23_281 VGND VGND VPWR VPWR sky130_fd_sc_hd__decap_8
XFILLER_0_51_590 VGND VGND VPWR VPWR sky130_fd_sc_hd__decap_8
XFILLER_0_2_197 VGND VGND VPWR VPWR sky130_fd_sc_hd__fill_2
X_5324_ _3152_ _1402_ _1971_ _2846_ VGND VGND VPWR VPWR _0633_ sky130_fd_sc_hd__o2bb2a_1
X_5255_ _3520_ net3 _0465_ _0242_ VGND VGND VPWR VPWR _0558_ sky130_fd_sc_hd__a22oi_2
X_4206_ _1960_ _3316_ _1479_ _2058_ _3317_ _3313_ VGND VGND VPWR VPWR _3318_ sky130_fd_sc_hd__mux4_1
X_5186_ _0444_ _0445_ _0482_ _0481_ VGND VGND VPWR VPWR _0483_ sky130_fd_sc_hd__or4bb_4
XFILLER_0_97_207 VGND VGND VPWR VPWR sky130_fd_sc_hd__decap_3
XFILLER_0_3_51 VGND VGND VPWR VPWR sky130_fd_sc_hd__decap_4
X_4137_ _2441_ VGND VGND VPWR VPWR _3248_ sky130_fd_sc_hd__inv_2
XFILLER_0_97_218 VGND VGND VPWR VPWR sky130_fd_sc_hd__decap_6
XFILLER_0_78_421 VPWR VGND VPWR VGND sky130_ef_sc_hd__decap_12
XFILLER_0_78_410 VGND VGND VPWR VPWR sky130_fd_sc_hd__decap_4
X_4068_ net59 VGND VGND VPWR VPWR _2495_ sky130_fd_sc_hd__buf_6
XFILLER_0_78_465 VGND VGND VPWR VPWR sky130_fd_sc_hd__fill_2
XFILLER_0_65_148 VGND VGND VPWR VPWR sky130_fd_sc_hd__decap_4
XFILLER_0_65_126 VPWR VGND VPWR VGND sky130_ef_sc_hd__decap_12
XFILLER_0_19_532 VGND VGND VPWR VPWR sky130_fd_sc_hd__fill_1
XFILLER_0_80_107 VPWR VGND VPWR VGND sky130_ef_sc_hd__decap_12
XFILLER_0_80_80 VGND VGND VPWR VPWR sky130_fd_sc_hd__decap_4
XFILLER_0_65_159 VGND VGND VPWR VPWR sky130_fd_sc_hd__decap_3
X_7689_ _1366_ _2478_ _3217_ _3353_ VGND VGND VPWR VPWR _3219_ sky130_fd_sc_hd__o211a_1
X_6709_ _0848_ _2145_ VGND VGND VPWR VPWR _2147_ sky130_fd_sc_hd__nor2_1
XFILLER_0_34_524 VGND VGND VPWR VPWR sky130_fd_sc_hd__decap_8
XFILLER_0_46_362 VGND VGND VPWR VPWR sky130_fd_sc_hd__fill_2
XFILLER_0_104_412 VGND VGND VPWR VPWR sky130_fd_sc_hd__fill_1
XFILLER_0_73_181 VGND VGND VPWR VPWR sky130_fd_sc_hd__fill_1
XFILLER_0_104_467 VGND VGND VPWR VPWR sky130_fd_sc_hd__decap_8
XFILLER_0_100_651 VGND VGND VPWR VPWR sky130_fd_sc_hd__fill_1
XFILLER_0_44_29 VPWR VGND VPWR VGND sky130_ef_sc_hd__decap_12
XTAP_TAPCELL_ROW_17_427 VGND VPWR sky130_fd_sc_hd__tapvpwrvgnd_1
XFILLER_0_96_251 VGND VGND VPWR VPWR sky130_fd_sc_hd__fill_1
XTAP_TAPCELL_ROW_45_758 VGND VPWR sky130_fd_sc_hd__tapvpwrvgnd_1
XFILLER_0_8_29 VPWR VGND VPWR VGND sky130_ef_sc_hd__decap_12
XFILLER_0_52_321 VPWR VGND VPWR VGND sky130_ef_sc_hd__decap_12
XTAP_TAPCELL_ROW_77_1126 VGND VPWR sky130_fd_sc_hd__tapvpwrvgnd_1
XFILLER_0_52_365 VGND VGND VPWR VPWR sky130_fd_sc_hd__decap_8
XFILLER_0_0_613 VGND VGND VPWR VPWR sky130_fd_sc_hd__decap_3
XFILLER_0_100_89 VGND VGND VPWR VPWR sky130_fd_sc_hd__decap_3
XFILLER_0_20_273 VGND VGND VPWR VPWR sky130_fd_sc_hd__decap_8
XFILLER_0_85_47 VGND VGND VPWR VPWR sky130_fd_sc_hd__decap_4
X_5040_ _0234_ _0237_ _0236_ VGND VGND VPWR VPWR _0324_ sky130_fd_sc_hd__o21ba_1
XFILLER_0_109_98 VPWR VGND VPWR VGND sky130_ef_sc_hd__decap_12
XFILLER_0_18_85 VGND VGND VPWR VPWR sky130_fd_sc_hd__fill_1
XTAP_TAPCELL_ROW_88_1244 VGND VPWR sky130_fd_sc_hd__tapvpwrvgnd_1
X_6991_ _2453_ _2454_ VGND VGND VPWR VPWR _2455_ sky130_fd_sc_hd__xnor2_1
X_5942_ _1306_ _1307_ VGND VGND VPWR VPWR _1308_ sky130_fd_sc_hd__nor2_1
XFILLER_0_87_262 VGND VGND VPWR VPWR sky130_fd_sc_hd__decap_4
XFILLER_0_34_51 VGND VGND VPWR VPWR sky130_fd_sc_hd__fill_1
X_5873_ _1221_ _1232_ VGND VGND VPWR VPWR _1233_ sky130_fd_sc_hd__or2_1
XFILLER_0_48_638 VGND VGND VPWR VPWR sky130_fd_sc_hd__decap_6
X_7612_ _3132_ _3133_ VGND VGND VPWR VPWR _3134_ sky130_fd_sc_hd__xnor2_1
X_4824_ _0087_ _0088_ VGND VGND VPWR VPWR _0089_ sky130_fd_sc_hd__xnor2_1
XFILLER_0_47_148 VPWR VGND VPWR VGND sky130_ef_sc_hd__decap_12
X_7543_ _2861_ _2872_ _3058_ VGND VGND VPWR VPWR net92 sky130_fd_sc_hd__nand3_1
X_4755_ _3323_ _3383_ _3396_ VGND VGND VPWR VPWR _0016_ sky130_fd_sc_hd__mux2_1
XFILLER_0_90_449 VPWR VGND VPWR VGND sky130_ef_sc_hd__decap_12
XFILLER_0_28_373 VGND VGND VPWR VPWR sky130_fd_sc_hd__decap_6
XFILLER_0_50_83 VGND VGND VPWR VPWR sky130_fd_sc_hd__fill_1
XTAP_TAPCELL_ROW_99_1373 VGND VPWR sky130_fd_sc_hd__tapvpwrvgnd_1
X_7474_ _2969_ _2970_ _2982_ VGND VGND VPWR VPWR _2983_ sky130_fd_sc_hd__a21oi_2
X_4686_ _3770_ _3789_ _3790_ VGND VGND VPWR VPWR _3791_ sky130_fd_sc_hd__nand3_2
XFILLER_0_31_505 VGND VGND VPWR VPWR sky130_fd_sc_hd__decap_6
XFILLER_0_43_387 VGND VGND VPWR VPWR sky130_fd_sc_hd__decap_4
XFILLER_0_70_195 VGND VGND VPWR VPWR sky130_fd_sc_hd__fill_1
X_6425_ _3329_ _0213_ _1834_ VGND VGND VPWR VPWR _1835_ sky130_fd_sc_hd__and3_1
X_6356_ _1754_ _1758_ _1759_ VGND VGND VPWR VPWR _1760_ sky130_fd_sc_hd__and3_1
X_5307_ _3261_ net117 VGND VGND VPWR VPWR _0615_ sky130_fd_sc_hd__nand2_1
X_6287_ _1568_ _1569_ _1585_ _1586_ VGND VGND VPWR VPWR _1684_ sky130_fd_sc_hd__o211ai_1
X_5238_ _0455_ _0477_ _0478_ VGND VGND VPWR VPWR _0539_ sky130_fd_sc_hd__nand3_1
X_5169_ A[11] VGND VGND VPWR VPWR _0465_ sky130_fd_sc_hd__buf_2
XFILLER_0_98_527 VGND VGND VPWR VPWR sky130_fd_sc_hd__decap_4
XTAP_TAPCELL_ROW_108_1480 VGND VPWR sky130_fd_sc_hd__tapvpwrvgnd_1
XFILLER_0_66_402 VGND VGND VPWR VPWR sky130_fd_sc_hd__fill_1
XFILLER_0_39_649 VGND VGND VPWR VPWR sky130_fd_sc_hd__decap_3
XTAP_TAPCELL_ROW_42_717 VGND VPWR sky130_fd_sc_hd__tapvpwrvgnd_1
XFILLER_0_93_254 VPWR VGND VPWR VGND sky130_ef_sc_hd__decap_12
XFILLER_0_81_405 VGND VGND VPWR VPWR sky130_fd_sc_hd__fill_2
XFILLER_0_109_559 VGND VGND VPWR VPWR sky130_fd_sc_hd__fill_1
XFILLER_0_81_427 VPWR VGND VPWR VGND sky130_ef_sc_hd__decap_12
XFILLER_0_19_373 VGND VGND VPWR VPWR sky130_fd_sc_hd__fill_1
XFILLER_0_81_449 VPWR VGND VPWR VGND sky130_ef_sc_hd__decap_12
XTAP_TAPCELL_ROW_22_485 VGND VPWR sky130_fd_sc_hd__tapvpwrvgnd_1
XFILLER_0_30_560 VPWR VGND VPWR VGND sky130_ef_sc_hd__decap_12
XFILLER_0_100_470 VGND VGND VPWR VPWR sky130_fd_sc_hd__decap_6
XTAP_TAPCELL_ROW_72_1067 VGND VPWR sky130_fd_sc_hd__tapvpwrvgnd_1
XFILLER_0_57_435 VGND VGND VPWR VPWR sky130_fd_sc_hd__decap_6
XFILLER_0_29_137 VPWR VGND VPWR VGND sky130_ef_sc_hd__decap_12
XTAP_TAPCELL_ROW_83_1196 VGND VPWR sky130_fd_sc_hd__tapvpwrvgnd_1
XFILLER_0_44_129 VGND VGND VPWR VPWR sky130_fd_sc_hd__fill_2
XFILLER_0_65_490 VGND VGND VPWR VPWR sky130_fd_sc_hd__fill_1
XFILLER_0_105_3 VPWR VGND VPWR VGND sky130_ef_sc_hd__decap_12
X_4540_ _3411_ VGND VGND VPWR VPWR _3647_ sky130_fd_sc_hd__buf_4
XFILLER_0_4_237 VPWR VGND VPWR VGND sky130_ef_sc_hd__decap_12
XFILLER_0_13_505 VGND VGND VPWR VPWR sky130_fd_sc_hd__decap_8
XFILLER_0_25_354 VGND VGND VPWR VPWR sky130_fd_sc_hd__decap_3
X_4471_ _3043_ _3163_ _3522_ _3519_ VGND VGND VPWR VPWR _3579_ sky130_fd_sc_hd__a31o_1
XFILLER_0_13_527 VPWR VGND VPWR VGND sky130_ef_sc_hd__decap_12
Xmax_cap114 _1725_ VGND VGND VPWR VPWR net114 sky130_fd_sc_hd__buf_1
XFILLER_0_25_387 VGND VGND VPWR VPWR sky130_fd_sc_hd__decap_4
Xmax_cap103 _1958_ VGND VGND VPWR VPWR net103 sky130_fd_sc_hd__clkbuf_2
XFILLER_0_52_173 VPWR VGND VPWR VGND sky130_ef_sc_hd__decap_12
X_7190_ _1214_ _2670_ _2672_ VGND VGND VPWR VPWR _2673_ sky130_fd_sc_hd__and3_1
XFILLER_0_0_421 VGND VGND VPWR VPWR sky130_fd_sc_hd__decap_8
X_6210_ _1597_ _1598_ _1591_ VGND VGND VPWR VPWR _1601_ sky130_fd_sc_hd__a21oi_1
X_6141_ _1401_ _1400_ VGND VGND VPWR VPWR _1525_ sky130_fd_sc_hd__and2b_1
X_6072_ _1447_ _1448_ _1428_ _1429_ VGND VGND VPWR VPWR _1450_ sky130_fd_sc_hd__a211oi_2
XFILLER_0_29_73 VPWR VGND VPWR VGND sky130_ef_sc_hd__decap_12
X_5023_ _0273_ _0174_ _0304_ VGND VGND VPWR VPWR _0305_ sky130_fd_sc_hd__a21oi_4
X_6974_ _2253_ _2262_ _2260_ VGND VGND VPWR VPWR _2436_ sky130_fd_sc_hd__a21oi_1
XFILLER_0_0_41 VPWR VGND VPWR VGND sky130_ef_sc_hd__decap_12
X_5925_ _1279_ _1288_ VGND VGND VPWR VPWR _1289_ sky130_fd_sc_hd__xnor2_1
XFILLER_0_48_413 VGND VGND VPWR VPWR sky130_fd_sc_hd__decap_6
X_5856_ _3364_ VGND VGND VPWR VPWR _1214_ sky130_fd_sc_hd__clkbuf_4
XFILLER_0_0_85 VPWR VGND VPWR VGND sky130_ef_sc_hd__decap_12
XPHY_EDGE_ROW_3_Right_3 VGND VGND VPWR VPWR sky130_fd_sc_hd__decap_3
X_4807_ _0068_ _0067_ _3832_ _3834_ VGND VGND VPWR VPWR _0070_ sky130_fd_sc_hd__a211o_1
XFILLER_0_63_449 VPWR VGND VPWR VGND sky130_ef_sc_hd__decap_12
X_5787_ _1011_ _1018_ VGND VGND VPWR VPWR _1138_ sky130_fd_sc_hd__and2_1
X_7526_ _2998_ _3039_ VGND VGND VPWR VPWR _3040_ sky130_fd_sc_hd__xnor2_1
X_4738_ _3840_ _3841_ VGND VGND VPWR VPWR _3842_ sky130_fd_sc_hd__nand2_2
X_7457_ _2962_ _2963_ VGND VGND VPWR VPWR _2964_ sky130_fd_sc_hd__xor2_1
XFILLER_0_43_184 VPWR VGND VPWR VGND sky130_ef_sc_hd__decap_12
X_4669_ net152 _3772_ _2616_ _2911_ VGND VGND VPWR VPWR _3774_ sky130_fd_sc_hd__a22o_1
X_6408_ _1224_ _1816_ _1366_ VGND VGND VPWR VPWR _1817_ sky130_fd_sc_hd__mux2_1
XFILLER_0_3_281 VGND VGND VPWR VPWR sky130_fd_sc_hd__decap_3
XFILLER_0_31_368 VPWR VGND VPWR VGND sky130_ef_sc_hd__decap_12
X_7388_ _3310_ net20 _2700_ _2699_ VGND VGND VPWR VPWR _2888_ sky130_fd_sc_hd__a31o_1
X_6339_ _1738_ _1739_ _1740_ VGND VGND VPWR VPWR _1742_ sky130_fd_sc_hd__nand3_2
XFILLER_0_98_335 VGND VGND VPWR VPWR sky130_fd_sc_hd__fill_1
XTAP_TAPCELL_ROW_27_544 VGND VPWR sky130_fd_sc_hd__tapvpwrvgnd_1
XFILLER_0_66_221 VPWR VGND VPWR VGND sky130_ef_sc_hd__decap_12
XTAP_TAPCELL_ROW_55_864 VGND VPWR sky130_fd_sc_hd__tapvpwrvgnd_1
XFILLER_0_94_552 VGND VGND VPWR VPWR sky130_fd_sc_hd__decap_8
XFILLER_0_39_446 VGND VGND VPWR VPWR sky130_fd_sc_hd__fill_2
XFILLER_0_94_596 VGND VGND VPWR VPWR sky130_fd_sc_hd__decap_6
XFILLER_0_66_287 VGND VGND VPWR VPWR sky130_fd_sc_hd__decap_3
XFILLER_0_54_438 VGND VGND VPWR VPWR sky130_fd_sc_hd__fill_1
XFILLER_0_81_246 VPWR VGND VPWR VGND sky130_ef_sc_hd__decap_12
XFILLER_0_54_449 VGND VGND VPWR VPWR sky130_fd_sc_hd__fill_1
XFILLER_0_34_173 VPWR VGND VPWR VGND sky130_ef_sc_hd__decap_12
XFILLER_0_10_519 VGND VGND VPWR VPWR sky130_fd_sc_hd__fill_1
XFILLER_0_66_27 VGND VGND VPWR VPWR sky130_fd_sc_hd__fill_1
XFILLER_0_66_38 VGND VGND VPWR VPWR sky130_fd_sc_hd__fill_2
XFILLER_0_89_346 VPWR VGND VPWR VGND sky130_ef_sc_hd__decap_12
XTAP_TAPCELL_ROW_85_1214 VGND VPWR sky130_fd_sc_hd__tapvpwrvgnd_1
XFILLER_0_82_26 VGND VGND VPWR VPWR sky130_fd_sc_hd__fill_2
XFILLER_0_15_31 VGND VGND VPWR VPWR sky130_fd_sc_hd__fill_1
XFILLER_0_106_77 VGND VGND VPWR VPWR sky130_fd_sc_hd__decap_6
X_3971_ _1391_ _1424_ VGND VGND VPWR VPWR _1435_ sky130_fd_sc_hd__or2b_1
XFILLER_0_85_552 VGND VGND VPWR VPWR sky130_fd_sc_hd__fill_1
XFILLER_0_9_318 VPWR VGND VPWR VGND sky130_ef_sc_hd__decap_12
X_5710_ _1050_ _1051_ _1052_ VGND VGND VPWR VPWR _1055_ sky130_fd_sc_hd__a21o_1
X_6690_ _2123_ net146 _1947_ _1950_ VGND VGND VPWR VPWR _2126_ sky130_fd_sc_hd__a211oi_2
XFILLER_0_57_298 VGND VGND VPWR VPWR sky130_fd_sc_hd__fill_1
X_5641_ _0743_ _0932_ VGND VGND VPWR VPWR _0979_ sky130_fd_sc_hd__nor2_1
XFILLER_0_45_449 VPWR VGND VPWR VGND sky130_ef_sc_hd__decap_12
XFILLER_0_72_279 VGND VGND VPWR VPWR sky130_fd_sc_hd__decap_6
XFILLER_0_5_535 VGND VGND VPWR VPWR sky130_fd_sc_hd__fill_1
X_5572_ _0792_ _0794_ _0793_ VGND VGND VPWR VPWR _0904_ sky130_fd_sc_hd__o21bai_1
XTAP_TAPCELL_ROW_96_1343 VGND VPWR sky130_fd_sc_hd__tapvpwrvgnd_1
X_7311_ _2804_ VGND VGND VPWR VPWR _2805_ sky130_fd_sc_hd__inv_2
X_4523_ _3043_ _2572_ _3628_ _3629_ VGND VGND VPWR VPWR _3630_ sky130_fd_sc_hd__nand4_1
XFILLER_0_5_568 VPWR VGND VPWR VGND sky130_ef_sc_hd__decap_12
X_7242_ _2515_ _2530_ _2727_ _2728_ VGND VGND VPWR VPWR _2729_ sky130_fd_sc_hd__o211a_1
XFILLER_0_13_357 VPWR VGND VPWR VGND sky130_ef_sc_hd__decap_12
XFILLER_0_40_121 VPWR VGND VPWR VGND sky130_ef_sc_hd__decap_12
X_4454_ _3350_ _3352_ VGND VGND VPWR VPWR _3563_ sky130_fd_sc_hd__or2_1
X_4385_ _3415_ _3338_ _3412_ VGND VGND VPWR VPWR _3495_ sky130_fd_sc_hd__o21ai_1
X_7173_ _2498_ _2653_ VGND VGND VPWR VPWR _2654_ sky130_fd_sc_hd__xor2_1
XFILLER_0_0_273 VGND VGND VPWR VPWR sky130_fd_sc_hd__decap_3
X_6124_ _3379_ _1009_ _1089_ VGND VGND VPWR VPWR _1507_ sky130_fd_sc_hd__mux2_1
X_6055_ _1296_ _1303_ VGND VGND VPWR VPWR _1431_ sky130_fd_sc_hd__or2b_4
X_5006_ _3753_ _0286_ _3340_ VGND VGND VPWR VPWR _0287_ sky130_fd_sc_hd__mux2_1
XFILLER_0_72_70 VGND VGND VPWR VPWR sky130_fd_sc_hd__fill_1
X_6957_ _2415_ _2416_ VGND VGND VPWR VPWR _2417_ sky130_fd_sc_hd__nor2_1
XTAP_TAPCELL_ROW_24_514 VGND VPWR sky130_fd_sc_hd__tapvpwrvgnd_1
XTAP_TAPCELL_ROW_52_834 VGND VPWR sky130_fd_sc_hd__tapvpwrvgnd_1
X_6888_ _2703_ _0856_ VGND VGND VPWR VPWR _2341_ sky130_fd_sc_hd__nand2_1
X_5908_ _1152_ _1150_ VGND VGND VPWR VPWR _1270_ sky130_fd_sc_hd__and2b_1
XPHY_EDGE_ROW_101_Left_211 VGND VGND VPWR VPWR sky130_fd_sc_hd__decap_3
XFILLER_0_91_555 VGND VGND VPWR VPWR sky130_fd_sc_hd__fill_1
XFILLER_0_8_340 VGND VGND VPWR VPWR sky130_fd_sc_hd__decap_3
X_5839_ _1157_ _1158_ _1192_ _1193_ VGND VGND VPWR VPWR _1196_ sky130_fd_sc_hd__o22ai_2
XFILLER_0_17_641 VGND VGND VPWR VPWR sky130_fd_sc_hd__decap_8
XFILLER_0_91_577 VPWR VGND VPWR VGND sky130_ef_sc_hd__decap_12
XFILLER_0_63_279 VGND VGND VPWR VPWR sky130_fd_sc_hd__fill_1
XFILLER_0_51_419 VPWR VGND VPWR VGND sky130_ef_sc_hd__decap_12
X_7509_ _2485_ _2681_ _0159_ _0213_ VGND VGND VPWR VPWR _3022_ sky130_fd_sc_hd__and4_1
XFILLER_0_102_521 VGND VGND VPWR VPWR sky130_fd_sc_hd__decap_8
XFILLER_0_31_121 VGND VGND VPWR VPWR sky130_fd_sc_hd__fill_1
XFILLER_0_31_187 VPWR VGND VPWR VGND sky130_ef_sc_hd__decap_12
XFILLER_0_102_587 VGND VGND VPWR VPWR sky130_fd_sc_hd__fill_1
XFILLER_0_102_598 VPWR VGND VPWR VGND sky130_ef_sc_hd__decap_12
XTAP_TAPCELL_ROW_4_283 VGND VPWR sky130_fd_sc_hd__tapvpwrvgnd_1
XFILLER_0_86_338 VPWR VGND VPWR VGND sky130_ef_sc_hd__decap_12
XFILLER_0_52_29 VPWR VGND VPWR VGND sky130_ef_sc_hd__decap_12
XFILLER_0_79_390 VGND VGND VPWR VPWR sky130_fd_sc_hd__fill_2
XFILLER_0_27_405 VGND VGND VPWR VPWR sky130_fd_sc_hd__decap_6
XFILLER_0_94_393 VGND VGND VPWR VPWR sky130_fd_sc_hd__decap_4
XTAP_TAPCELL_ROW_80_1155 VGND VPWR sky130_fd_sc_hd__tapvpwrvgnd_1
XFILLER_0_27_449 VGND VGND VPWR VPWR sky130_fd_sc_hd__decap_6
XFILLER_0_109_197 VPWR VGND VPWR VGND sky130_ef_sc_hd__decap_12
XFILLER_0_54_257 VGND VGND VPWR VPWR sky130_fd_sc_hd__fill_1
XFILLER_0_23_611 VGND VGND VPWR VPWR sky130_fd_sc_hd__decap_4
XFILLER_0_50_441 VGND VGND VPWR VPWR sky130_fd_sc_hd__fill_1
XFILLER_0_50_474 VGND VGND VPWR VPWR sky130_fd_sc_hd__fill_2
X_4170_ _2299_ _2331_ _3252_ _3281_ VGND VGND VPWR VPWR _3282_ sky130_fd_sc_hd__a2bb2o_1
XTAP_TAPCELL_ROW_91_1284 VGND VPWR sky130_fd_sc_hd__tapvpwrvgnd_1
XFILLER_0_26_52 VPWR VGND VPWR VGND sky130_ef_sc_hd__decap_12
XFILLER_0_26_85 VPWR VGND VPWR VGND sky130_ef_sc_hd__decap_12
X_6811_ _3248_ _2178_ _2254_ _2256_ VGND VGND VPWR VPWR _2258_ sky130_fd_sc_hd__o22a_1
XFILLER_0_85_371 VPWR VGND VPWR VGND sky130_ef_sc_hd__decap_12
X_3954_ _1228_ _1238_ VGND VGND VPWR VPWR _1249_ sky130_fd_sc_hd__nand2_2
X_6742_ _2161_ _2181_ VGND VGND VPWR VPWR _2182_ sky130_fd_sc_hd__xnor2_1
XFILLER_0_42_51 VGND VGND VPWR VPWR sky130_fd_sc_hd__decap_8
X_3885_ _0246_ _0257_ VGND VGND VPWR VPWR _0497_ sky130_fd_sc_hd__nor2_1
XFILLER_0_85_393 VPWR VGND VPWR VGND sky130_ef_sc_hd__decap_12
XFILLER_0_73_544 VPWR VGND VPWR VGND sky130_ef_sc_hd__decap_12
XFILLER_0_9_159 VGND VGND VPWR VPWR sky130_fd_sc_hd__decap_8
X_6673_ _2105_ _2106_ _1457_ _1533_ VGND VGND VPWR VPWR _2107_ sky130_fd_sc_hd__and4bb_1
X_5624_ _0386_ _3373_ VGND VGND VPWR VPWR _0961_ sky130_fd_sc_hd__nor2_1
XTAP_TAPCELL_ROW_100_1391 VGND VPWR sky130_fd_sc_hd__tapvpwrvgnd_1
XFILLER_0_103_329 VGND VGND VPWR VPWR sky130_fd_sc_hd__decap_6
XFILLER_0_60_249 VGND VGND VPWR VPWR sky130_fd_sc_hd__decap_3
XFILLER_0_13_121 VGND VGND VPWR VPWR sky130_fd_sc_hd__decap_3
X_5555_ _1654_ _1719_ VGND VGND VPWR VPWR _0885_ sky130_fd_sc_hd__nand2_1
XFILLER_0_41_441 VGND VGND VPWR VPWR sky130_fd_sc_hd__decap_3
X_4506_ _2769_ net117 VGND VGND VPWR VPWR _3614_ sky130_fd_sc_hd__nand2_1
X_5486_ _0774_ _0808_ _0809_ VGND VGND VPWR VPWR _0810_ sky130_fd_sc_hd__or3_4
X_4437_ _3394_ _3545_ _3541_ VGND VGND VPWR VPWR _3546_ sky130_fd_sc_hd__a21oi_2
X_7225_ _2709_ VGND VGND VPWR VPWR _2710_ sky130_fd_sc_hd__inv_2
XFILLER_0_41_496 VGND VGND VPWR VPWR sky130_fd_sc_hd__decap_8
X_7156_ _2610_ _2611_ _2633_ _2634_ VGND VGND VPWR VPWR _2635_ sky130_fd_sc_hd__nand4_2
X_4368_ _3476_ _3477_ _3339_ VGND VGND VPWR VPWR _3478_ sky130_fd_sc_hd__mux2_1
X_6107_ _1328_ net110 _1486_ _1487_ VGND VGND VPWR VPWR _1488_ sky130_fd_sc_hd__o211ai_4
X_4299_ _3333_ _3357_ _3405_ _3289_ _3409_ VGND VGND VPWR VPWR _3410_ sky130_fd_sc_hd__o221a_1
X_7087_ _2532_ _2533_ _2556_ _2557_ VGND VGND VPWR VPWR _2559_ sky130_fd_sc_hd__a2bb2oi_1
X_6038_ _1410_ _1411_ VGND VGND VPWR VPWR _1412_ sky130_fd_sc_hd__nor2_1
XFILLER_0_68_305 VGND VGND VPWR VPWR sky130_fd_sc_hd__decap_3
XFILLER_0_95_113 VPWR VGND VPWR VGND sky130_ef_sc_hd__decap_12
XFILLER_0_95_102 VGND VGND VPWR VPWR sky130_fd_sc_hd__fill_1
XTAP_TAPCELL_ROW_1_253 VGND VPWR sky130_fd_sc_hd__tapvpwrvgnd_1
XTAP_TAPCELL_ROW_65_981 VGND VPWR sky130_fd_sc_hd__tapvpwrvgnd_1
XTAP_TAPCELL_ROW_37_661 VGND VPWR sky130_fd_sc_hd__tapvpwrvgnd_1
XFILLER_0_64_533 VGND VGND VPWR VPWR sky130_fd_sc_hd__decap_8
XFILLER_0_36_213 VGND VGND VPWR VPWR sky130_fd_sc_hd__decap_8
XFILLER_0_91_352 VGND VGND VPWR VPWR sky130_fd_sc_hd__fill_1
XFILLER_0_20_625 VPWR VGND VPWR VGND sky130_ef_sc_hd__decap_12
XTAP_TAPCELL_ROW_9_342 VGND VPWR sky130_fd_sc_hd__tapvpwrvgnd_1
XFILLER_0_47_18 VPWR VGND VPWR VGND sky130_ef_sc_hd__decap_12
XTAP_TAPCELL_ROW_69_1028 VGND VPWR sky130_fd_sc_hd__tapvpwrvgnd_1
XFILLER_0_63_17 VGND VGND VPWR VPWR sky130_fd_sc_hd__decap_8
XFILLER_0_59_349 VGND VGND VPWR VPWR sky130_fd_sc_hd__decap_8
XFILLER_0_82_363 VGND VGND VPWR VPWR sky130_fd_sc_hd__fill_1
XFILLER_0_70_569 VGND VGND VPWR VPWR sky130_fd_sc_hd__decap_6
XTAP_TAPCELL_ROW_93_1302 VGND VPWR sky130_fd_sc_hd__tapvpwrvgnd_1
X_5340_ _0629_ _0630_ _0648_ _0650_ VGND VGND VPWR VPWR _0651_ sky130_fd_sc_hd__o211ai_4
X_5271_ _0537_ _0538_ _0572_ _0574_ VGND VGND VPWR VPWR _0576_ sky130_fd_sc_hd__a22oi_2
X_7010_ _0518_ _2475_ VGND VGND VPWR VPWR _2476_ sky130_fd_sc_hd__xnor2_1
X_4222_ _3163_ VGND VGND VPWR VPWR _3334_ sky130_fd_sc_hd__buf_4
X_4153_ _3263_ _3264_ VGND VGND VPWR VPWR _3265_ sky130_fd_sc_hd__nand2_2
X_4084_ _2660_ VGND VGND VPWR VPWR _2671_ sky130_fd_sc_hd__buf_4
XFILLER_0_77_113 VPWR VGND VPWR VGND sky130_ef_sc_hd__decap_12
XFILLER_0_53_50 VGND VGND VPWR VPWR sky130_fd_sc_hd__fill_1
XFILLER_0_93_617 VPWR VGND VPWR VGND sky130_ef_sc_hd__decap_12
XTAP_TAPCELL_ROW_62_951 VGND VPWR sky130_fd_sc_hd__tapvpwrvgnd_1
XTAP_TAPCELL_ROW_34_631 VGND VPWR sky130_fd_sc_hd__tapvpwrvgnd_1
X_4986_ _0125_ _0263_ _0264_ VGND VGND VPWR VPWR _0265_ sky130_fd_sc_hd__nand3_2
XFILLER_0_92_127 VGND VGND VPWR VPWR sky130_fd_sc_hd__decap_4
X_3937_ _1042_ _1053_ VGND VGND VPWR VPWR _1064_ sky130_fd_sc_hd__nand2_2
XFILLER_0_18_235 VPWR VGND VPWR VGND sky130_ef_sc_hd__decap_12
X_6725_ _1835_ _2016_ VGND VGND VPWR VPWR _2163_ sky130_fd_sc_hd__nand2_1
XFILLER_0_46_533 VPWR VGND VPWR VGND sky130_ef_sc_hd__decap_12
XFILLER_0_85_190 VGND VGND VPWR VPWR sky130_fd_sc_hd__fill_2
X_3868_ net52 VGND VGND VPWR VPWR _0311_ sky130_fd_sc_hd__buf_2
XFILLER_0_73_396 VPWR VGND VPWR VGND sky130_ef_sc_hd__decap_12
XFILLER_0_33_216 VGND VGND VPWR VPWR sky130_fd_sc_hd__decap_8
X_6656_ _2086_ _2087_ VGND VGND VPWR VPWR _2088_ sky130_fd_sc_hd__nor2_1
X_5607_ _0939_ _0940_ _0817_ _0819_ VGND VGND VPWR VPWR _0942_ sky130_fd_sc_hd__o211ai_4
X_6587_ _2008_ _2009_ _2011_ VGND VGND VPWR VPWR _2012_ sky130_fd_sc_hd__and3_1
X_5538_ _0760_ _0762_ _0761_ VGND VGND VPWR VPWR _0866_ sky130_fd_sc_hd__o21bai_1
XFILLER_0_14_485 VGND VGND VPWR VPWR sky130_fd_sc_hd__fill_2
XFILLER_0_41_271 VGND VGND VPWR VPWR sky130_fd_sc_hd__decap_3
X_7208_ _0322_ _1360_ _2688_ _0097_ _2690_ VGND VGND VPWR VPWR _2691_ sky130_fd_sc_hd__o221a_1
XTAP_TAPCELL_ROW_6_301 VGND VPWR sky130_fd_sc_hd__tapvpwrvgnd_1
X_5469_ net132 _2036_ VGND VGND VPWR VPWR _0792_ sky130_fd_sc_hd__nand2_1
XFILLER_0_1_390 VGND VGND VPWR VPWR sky130_fd_sc_hd__fill_2
X_7139_ _2394_ _2398_ _2395_ VGND VGND VPWR VPWR _2617_ sky130_fd_sc_hd__o21ba_1
XFILLER_0_69_614 VGND VGND VPWR VPWR sky130_fd_sc_hd__fill_2
XFILLER_0_96_455 VGND VGND VPWR VPWR sky130_fd_sc_hd__decap_8
XFILLER_0_49_360 VPWR VGND VPWR VGND sky130_ef_sc_hd__decap_12
XFILLER_0_37_511 VGND VGND VPWR VPWR sky130_fd_sc_hd__fill_1
XFILLER_0_37_522 VGND VGND VPWR VPWR sky130_fd_sc_hd__decap_8
XFILLER_0_107_443 VGND VGND VPWR VPWR sky130_fd_sc_hd__decap_4
XFILLER_0_64_363 VGND VGND VPWR VPWR sky130_fd_sc_hd__fill_1
Xinput18 A[26] VGND VGND VPWR VPWR net18 sky130_fd_sc_hd__clkbuf_2
XTAP_TAPCELL_ROW_12_369 VGND VPWR sky130_fd_sc_hd__tapvpwrvgnd_1
XFILLER_0_24_216 VGND VGND VPWR VPWR sky130_fd_sc_hd__decap_3
Xinput29 A[7] VGND VGND VPWR VPWR net29 sky130_fd_sc_hd__buf_2
XFILLER_0_24_249 VGND VGND VPWR VPWR sky130_fd_sc_hd__decap_3
XFILLER_0_20_400 VGND VGND VPWR VPWR sky130_fd_sc_hd__fill_1
XFILLER_0_102_181 VPWR VGND VPWR VGND sky130_ef_sc_hd__decap_12
XTAP_TAPCELL_ROW_75_1098 VGND VPWR sky130_fd_sc_hd__tapvpwrvgnd_1
XFILLER_0_99_271 VGND VGND VPWR VPWR sky130_fd_sc_hd__decap_4
XFILLER_0_59_113 VPWR VGND VPWR VGND sky130_ef_sc_hd__decap_12
XFILLER_0_90_15 VPWR VGND VPWR VGND sky130_ef_sc_hd__decap_12
XTAP_TAPCELL_ROW_48_789 VGND VPWR sky130_fd_sc_hd__tapvpwrvgnd_1
X_4840_ _3342_ _0010_ VGND VGND VPWR VPWR _0107_ sky130_fd_sc_hd__nor2_1
XFILLER_0_75_617 VPWR VGND VPWR VGND sky130_ef_sc_hd__decap_12
XFILLER_0_7_405 VGND VGND VPWR VPWR sky130_fd_sc_hd__fill_2
XFILLER_0_28_533 VGND VGND VPWR VPWR sky130_fd_sc_hd__fill_1
XFILLER_0_67_190 VPWR VGND VPWR VGND sky130_ef_sc_hd__decap_12
XFILLER_0_7_449 VGND VGND VPWR VPWR sky130_fd_sc_hd__fill_1
X_6510_ _1925_ _1926_ _1928_ VGND VGND VPWR VPWR _1929_ sky130_fd_sc_hd__nand3_2
X_4771_ _3808_ _3815_ VGND VGND VPWR VPWR _0031_ sky130_fd_sc_hd__and2_1
X_7490_ _2933_ _3334_ net51 net50 VGND VGND VPWR VPWR _3001_ sky130_fd_sc_hd__and4_1
XFILLER_0_15_205 VPWR VGND VPWR VGND sky130_ef_sc_hd__decap_12
XFILLER_0_43_503 VGND VGND VPWR VPWR sky130_fd_sc_hd__fill_1
XFILLER_0_43_525 VGND VGND VPWR VPWR sky130_fd_sc_hd__fill_2
XFILLER_0_99_57 VGND VGND VPWR VPWR sky130_fd_sc_hd__decap_8
XFILLER_0_82_193 VGND VGND VPWR VPWR sky130_fd_sc_hd__decap_3
X_6441_ _1849_ _1851_ _1852_ VGND VGND VPWR VPWR _1853_ sky130_fd_sc_hd__and3_1
XFILLER_0_2_121 VPWR VGND VPWR VGND sky130_ef_sc_hd__decap_12
X_6372_ _1776_ _1777_ VGND VGND VPWR VPWR _1778_ sky130_fd_sc_hd__xnor2_1
X_5323_ _0542_ _0548_ VGND VGND VPWR VPWR _0632_ sky130_fd_sc_hd__nand2_1
X_5254_ _0463_ net148 net3 _0465_ VGND VGND VPWR VPWR _0557_ sky130_fd_sc_hd__and4_1
X_4205_ _3308_ VGND VGND VPWR VPWR _3317_ sky130_fd_sc_hd__clkbuf_4
X_5185_ _0479_ _0480_ _0351_ _0446_ VGND VGND VPWR VPWR _0482_ sky130_fd_sc_hd__o211ai_2
XFILLER_0_48_83 VGND VGND VPWR VPWR sky130_fd_sc_hd__fill_1
X_4136_ _2736_ _2747_ _2835_ _3228_ VGND VGND VPWR VPWR _3238_ sky130_fd_sc_hd__a2bb2o_1
XFILLER_0_64_82 VGND VGND VPWR VPWR sky130_fd_sc_hd__fill_2
X_4067_ _2474_ VGND VGND VPWR VPWR _2485_ sky130_fd_sc_hd__clkbuf_4
XFILLER_0_78_433 VPWR VGND VPWR VGND sky130_ef_sc_hd__decap_12
XFILLER_0_64_93 VGND VGND VPWR VPWR sky130_fd_sc_hd__decap_8
XFILLER_0_78_477 VGND VGND VPWR VPWR sky130_fd_sc_hd__decap_8
XFILLER_0_65_105 VGND VGND VPWR VPWR sky130_fd_sc_hd__decap_6
XFILLER_0_19_500 VGND VGND VPWR VPWR sky130_fd_sc_hd__decap_4
XFILLER_0_93_447 VGND VGND VPWR VPWR sky130_fd_sc_hd__fill_1
XFILLER_0_66_639 VGND VGND VPWR VPWR sky130_fd_sc_hd__decap_4
XFILLER_0_65_138 VGND VGND VPWR VPWR sky130_fd_sc_hd__decap_4
XFILLER_0_81_609 VGND VGND VPWR VPWR sky130_fd_sc_hd__decap_6
X_4969_ _0243_ _0244_ _0241_ VGND VGND VPWR VPWR _0247_ sky130_fd_sc_hd__o21ai_1
XFILLER_0_46_352 VGND VGND VPWR VPWR sky130_fd_sc_hd__decap_3
X_7688_ _3348_ _3431_ _3443_ _2683_ _3553_ VGND VGND VPWR VPWR _3217_ sky130_fd_sc_hd__o32a_1
X_6708_ _0529_ _1096_ _3558_ _0562_ _2144_ VGND VGND VPWR VPWR _2145_ sky130_fd_sc_hd__a221o_1
XFILLER_0_61_311 VGND VGND VPWR VPWR sky130_fd_sc_hd__decap_8
X_6639_ _1912_ _1913_ _1911_ VGND VGND VPWR VPWR _2070_ sky130_fd_sc_hd__o21bai_2
XTAP_TAPCELL_ROW_17_428 VGND VPWR sky130_fd_sc_hd__tapvpwrvgnd_1
XFILLER_0_57_617 VGND VGND VPWR VPWR sky130_fd_sc_hd__decap_4
XTAP_TAPCELL_ROW_45_759 VGND VPWR sky130_fd_sc_hd__tapvpwrvgnd_1
XFILLER_0_84_436 VGND VGND VPWR VPWR sky130_fd_sc_hd__decap_6
XFILLER_0_57_639 VPWR VGND VPWR VGND sky130_ef_sc_hd__decap_12
XFILLER_0_60_29 VPWR VGND VPWR VGND sky130_ef_sc_hd__decap_12
XFILLER_0_4_408 VPWR VGND VPWR VGND sky130_ef_sc_hd__decap_12
XFILLER_0_52_333 VGND VGND VPWR VPWR sky130_fd_sc_hd__decap_8
XTAP_TAPCELL_ROW_77_1127 VGND VPWR sky130_fd_sc_hd__tapvpwrvgnd_1
XFILLER_0_25_569 VGND VGND VPWR VPWR sky130_fd_sc_hd__fill_1
XFILLER_0_20_263 VGND VGND VPWR VPWR sky130_fd_sc_hd__decap_4
XFILLER_0_109_77 VGND VGND VPWR VPWR sky130_fd_sc_hd__decap_3
XTAP_TAPCELL_ROW_88_1245 VGND VPWR sky130_fd_sc_hd__tapvpwrvgnd_1
XFILLER_0_79_208 VPWR VGND VPWR VGND sky130_ef_sc_hd__decap_12
X_6990_ _3330_ _0257_ VGND VGND VPWR VPWR _2454_ sky130_fd_sc_hd__nand2_1
X_5941_ net32 _2605_ _0987_ net7 VGND VGND VPWR VPWR _1307_ sky130_fd_sc_hd__and4_1
X_5872_ _3303_ _3546_ _1231_ VGND VGND VPWR VPWR _1232_ sky130_fd_sc_hd__o21ai_1
XFILLER_0_75_447 VGND VGND VPWR VPWR sky130_fd_sc_hd__fill_1
XFILLER_0_34_85 VGND VGND VPWR VPWR sky130_fd_sc_hd__fill_2
XFILLER_0_47_127 VPWR VGND VPWR VGND sky130_ef_sc_hd__decap_12
X_7611_ _2714_ _0105_ VGND VGND VPWR VPWR _3133_ sky130_fd_sc_hd__nand2_1
X_4823_ _3270_ _0026_ VGND VGND VPWR VPWR _0088_ sky130_fd_sc_hd__or2_1
XFILLER_0_28_341 VGND VGND VPWR VPWR sky130_fd_sc_hd__fill_2
X_7542_ _0596_ _2874_ _2875_ _3057_ VGND VGND VPWR VPWR _3058_ sky130_fd_sc_hd__o31a_1
X_4754_ _3349_ _0014_ _3343_ VGND VGND VPWR VPWR _0015_ sky130_fd_sc_hd__mux2_1
XFILLER_0_90_428 VGND VGND VPWR VPWR sky130_fd_sc_hd__decap_4
XFILLER_0_55_160 VGND VGND VPWR VPWR sky130_fd_sc_hd__decap_8
XFILLER_0_71_642 VGND VGND VPWR VPWR sky130_fd_sc_hd__decap_8
X_7473_ _2980_ _2981_ VGND VGND VPWR VPWR _2982_ sky130_fd_sc_hd__or2_1
XTAP_TAPCELL_ROW_99_1374 VGND VPWR sky130_fd_sc_hd__tapvpwrvgnd_1
XFILLER_0_70_163 VPWR VGND VPWR VGND sky130_ef_sc_hd__decap_12
X_4685_ _3786_ _3787_ _3788_ VGND VGND VPWR VPWR _3790_ sky130_fd_sc_hd__a21o_1
XFILLER_0_43_377 VGND VGND VPWR VPWR sky130_fd_sc_hd__decap_6
X_6424_ _3328_ _0944_ _1687_ _1685_ VGND VGND VPWR VPWR _1834_ sky130_fd_sc_hd__a31o_1
X_6355_ _1755_ _1756_ _1757_ VGND VGND VPWR VPWR _1759_ sky130_fd_sc_hd__o21ai_1
X_5306_ _0104_ _0604_ _0609_ _0613_ VGND VGND VPWR VPWR _0614_ sky130_fd_sc_hd__a31o_1
XFILLER_0_11_263 VGND VGND VPWR VPWR sky130_fd_sc_hd__fill_1
X_6286_ _1560_ VGND VGND VPWR VPWR _1683_ sky130_fd_sc_hd__inv_2
XFILLER_0_11_296 VPWR VGND VPWR VGND sky130_ef_sc_hd__decap_12
X_5237_ _0535_ _0536_ _0517_ VGND VGND VPWR VPWR _0538_ sky130_fd_sc_hd__a21o_1
X_5168_ net56 VGND VGND VPWR VPWR _0463_ sky130_fd_sc_hd__buf_6
X_5099_ _3374_ _0381_ _0387_ VGND VGND VPWR VPWR _0389_ sky130_fd_sc_hd__a21oi_1
X_4119_ _3010_ _3043_ VGND VGND VPWR VPWR _3054_ sky130_fd_sc_hd__or2b_1
XTAP_TAPCELL_ROW_108_1481 VGND VPWR sky130_fd_sc_hd__tapvpwrvgnd_1
XFILLER_0_39_617 VPWR VGND VPWR VGND sky130_ef_sc_hd__decap_12
XTAP_TAPCELL_ROW_42_718 VGND VPWR sky130_fd_sc_hd__tapvpwrvgnd_1
XFILLER_0_93_288 VGND VGND VPWR VPWR sky130_fd_sc_hd__decap_3
XFILLER_0_93_266 VPWR VGND VPWR VGND sky130_ef_sc_hd__decap_12
XFILLER_0_81_439 VGND VGND VPWR VPWR sky130_fd_sc_hd__decap_8
XTAP_TAPCELL_ROW_22_486 VGND VPWR sky130_fd_sc_hd__tapvpwrvgnd_1
XFILLER_0_46_193 VGND VGND VPWR VPWR sky130_fd_sc_hd__decap_3
XFILLER_0_104_210 VPWR VGND VPWR VGND sky130_ef_sc_hd__decap_12
XFILLER_0_22_506 VGND VGND VPWR VPWR sky130_fd_sc_hd__decap_4
XFILLER_0_6_290 VGND VGND VPWR VPWR sky130_fd_sc_hd__fill_1
XFILLER_0_15_591 VGND VGND VPWR VPWR sky130_fd_sc_hd__decap_6
XFILLER_0_104_287 VGND VGND VPWR VPWR sky130_fd_sc_hd__fill_1
XFILLER_0_30_572 VGND VGND VPWR VPWR sky130_fd_sc_hd__decap_4
XTAP_TAPCELL_ROW_72_1068 VGND VPWR sky130_fd_sc_hd__tapvpwrvgnd_1
XFILLER_0_97_561 VGND VGND VPWR VPWR sky130_fd_sc_hd__decap_4
XTAP_TAPCELL_ROW_83_1186 VGND VPWR sky130_fd_sc_hd__tapvpwrvgnd_1
XFILLER_0_57_447 VGND VGND VPWR VPWR sky130_fd_sc_hd__fill_1
XFILLER_0_29_149 VGND VGND VPWR VPWR sky130_fd_sc_hd__decap_8
XFILLER_0_4_205 VGND VGND VPWR VPWR sky130_fd_sc_hd__fill_2
XFILLER_0_25_322 VPWR VGND VPWR VGND sky130_ef_sc_hd__decap_12
XFILLER_0_4_249 VGND VGND VPWR VPWR sky130_fd_sc_hd__decap_3
XFILLER_0_52_141 VGND VGND VPWR VPWR sky130_fd_sc_hd__decap_8
X_4470_ _3575_ _3576_ _3574_ VGND VGND VPWR VPWR _3578_ sky130_fd_sc_hd__a21o_1
XFILLER_0_13_539 VGND VGND VPWR VPWR sky130_fd_sc_hd__fill_2
XFILLER_0_20_76 VGND VGND VPWR VPWR sky130_fd_sc_hd__fill_2
Xmax_cap104 _2159_ VGND VGND VPWR VPWR net104 sky130_fd_sc_hd__buf_1
XFILLER_0_52_185 VGND VGND VPWR VPWR sky130_fd_sc_hd__decap_8
XFILLER_0_96_58 VPWR VGND VPWR VGND sky130_ef_sc_hd__decap_12
XFILLER_0_21_561 VPWR VGND VPWR VGND sky130_ef_sc_hd__decap_12
X_6140_ _1497_ _1387_ _1498_ VGND VGND VPWR VPWR _1524_ sky130_fd_sc_hd__and3b_1
XFILLER_0_0_477 VGND VGND VPWR VPWR sky130_fd_sc_hd__fill_2
X_6071_ _1428_ _1429_ _1447_ _1448_ VGND VGND VPWR VPWR _1449_ sky130_fd_sc_hd__o211a_1
XFILLER_0_29_85 VGND VGND VPWR VPWR sky130_fd_sc_hd__decap_3
X_5022_ _0272_ _0206_ VGND VGND VPWR VPWR _0304_ sky130_fd_sc_hd__and2b_1
XFILLER_0_45_62 VGND VGND VPWR VPWR sky130_fd_sc_hd__decap_6
X_6973_ _2432_ _2433_ _2245_ _2284_ VGND VGND VPWR VPWR _2435_ sky130_fd_sc_hd__a211o_1
XFILLER_0_75_211 VPWR VGND VPWR VGND sky130_ef_sc_hd__decap_12
X_5924_ _1285_ _1287_ VGND VGND VPWR VPWR _1288_ sky130_fd_sc_hd__xor2_1
X_5855_ _1102_ _1078_ _1211_ VGND VGND VPWR VPWR _1213_ sky130_fd_sc_hd__nand3_1
XFILLER_0_0_53 VGND VGND VPWR VPWR sky130_fd_sc_hd__decap_3
XFILLER_0_0_97 VPWR VGND VPWR VGND sky130_ef_sc_hd__decap_12
X_4806_ _3832_ _3834_ _0067_ _0068_ VGND VGND VPWR VPWR _0069_ sky130_fd_sc_hd__o211ai_2
XFILLER_0_8_577 VGND VGND VPWR VPWR sky130_fd_sc_hd__decap_8
X_5786_ _1016_ _1017_ VGND VGND VPWR VPWR _1137_ sky130_fd_sc_hd__and2_1
XFILLER_0_16_322 VGND VGND VPWR VPWR sky130_fd_sc_hd__decap_3
XFILLER_0_44_620 VGND VGND VPWR VPWR sky130_fd_sc_hd__fill_1
X_7525_ _3014_ _3038_ VGND VGND VPWR VPWR _3039_ sky130_fd_sc_hd__xnor2_1
X_4737_ _3838_ _3839_ _3793_ _3795_ VGND VGND VPWR VPWR _3841_ sky130_fd_sc_hd__o211ai_1
XFILLER_0_9_51 VGND VGND VPWR VPWR sky130_fd_sc_hd__decap_4
X_7456_ _1675_ _1031_ _2766_ _2765_ VGND VGND VPWR VPWR _2963_ sky130_fd_sc_hd__a31o_1
X_4668_ net152 _3119_ _3772_ _2616_ VGND VGND VPWR VPWR _3773_ sky130_fd_sc_hd__and4_1
X_6407_ _1507_ _1815_ _0842_ VGND VGND VPWR VPWR _1816_ sky130_fd_sc_hd__mux2_1
X_7387_ _2885_ _2886_ VGND VGND VPWR VPWR _2887_ sky130_fd_sc_hd__xor2_1
XFILLER_0_101_246 VPWR VGND VPWR VGND sky130_ef_sc_hd__decap_12
X_4599_ _3702_ _3703_ _3684_ VGND VGND VPWR VPWR _3705_ sky130_fd_sc_hd__a21oi_1
XFILLER_0_101_279 VGND VGND VPWR VPWR sky130_fd_sc_hd__fill_1
X_6338_ _0278_ _1578_ _1579_ VGND VGND VPWR VPWR _1740_ sky130_fd_sc_hd__o21bai_1
X_6269_ _1009_ _2178_ _1129_ _1118_ VGND VGND VPWR VPWR _1666_ sky130_fd_sc_hd__a31o_1
XTAP_TAPCELL_ROW_27_545 VGND VPWR sky130_fd_sc_hd__tapvpwrvgnd_1
XTAP_TAPCELL_ROW_55_865 VGND VPWR sky130_fd_sc_hd__tapvpwrvgnd_1
XFILLER_0_94_531 VGND VGND VPWR VPWR sky130_fd_sc_hd__fill_1
XFILLER_0_66_233 VPWR VGND VPWR VGND sky130_ef_sc_hd__decap_12
XFILLER_0_109_324 VPWR VGND VPWR VGND sky130_ef_sc_hd__decap_12
XFILLER_0_81_236 VGND VGND VPWR VPWR sky130_fd_sc_hd__fill_1
XFILLER_0_66_299 VGND VGND VPWR VPWR sky130_fd_sc_hd__decap_8
XFILLER_0_81_258 VPWR VGND VPWR VGND sky130_ef_sc_hd__decap_12
XFILLER_0_34_141 VGND VGND VPWR VPWR sky130_fd_sc_hd__decap_8
XFILLER_0_50_601 VGND VGND VPWR VPWR sky130_fd_sc_hd__decap_8
XFILLER_0_34_185 VGND VGND VPWR VPWR sky130_fd_sc_hd__decap_8
XFILLER_0_50_645 VGND VGND VPWR VPWR sky130_fd_sc_hd__decap_4
XFILLER_0_89_303 VGND VGND VPWR VPWR sky130_fd_sc_hd__decap_4
XPHY_EDGE_ROW_13_Right_13 VGND VGND VPWR VPWR sky130_fd_sc_hd__decap_3
XFILLER_0_89_358 VGND VGND VPWR VPWR sky130_fd_sc_hd__decap_3
XTAP_TAPCELL_ROW_85_1215 VGND VPWR sky130_fd_sc_hd__tapvpwrvgnd_1
XFILLER_0_77_509 VGND VGND VPWR VPWR sky130_fd_sc_hd__fill_1
XFILLER_0_85_520 VPWR VGND VPWR VGND sky130_ef_sc_hd__decap_12
X_3970_ _1413_ VGND VGND VPWR VPWR _1424_ sky130_fd_sc_hd__buf_2
XFILLER_0_15_65 VGND VGND VPWR VPWR sky130_fd_sc_hd__fill_2
XFILLER_0_97_391 VGND VGND VPWR VPWR sky130_fd_sc_hd__fill_1
XFILLER_0_15_87 VGND VGND VPWR VPWR sky130_fd_sc_hd__fill_1
X_5640_ _0746_ _0938_ _0937_ VGND VGND VPWR VPWR _0978_ sky130_fd_sc_hd__a21bo_1
XFILLER_0_26_620 VPWR VGND VPWR VGND sky130_ef_sc_hd__decap_12
XFILLER_0_31_20 VPWR VGND VPWR VGND sky130_ef_sc_hd__decap_12
X_5571_ _0899_ _0901_ _0898_ VGND VGND VPWR VPWR _0903_ sky130_fd_sc_hd__o21ai_1
XPHY_EDGE_ROW_22_Right_22 VGND VGND VPWR VPWR sky130_fd_sc_hd__decap_3
XFILLER_0_41_601 VPWR VGND VPWR VGND sky130_ef_sc_hd__decap_12
XTAP_TAPCELL_ROW_96_1344 VGND VPWR sky130_fd_sc_hd__tapvpwrvgnd_1
X_7310_ _3332_ net51 net50 _3335_ VGND VGND VPWR VPWR _2804_ sky130_fd_sc_hd__a22o_1
XFILLER_0_5_558 VGND VGND VPWR VPWR sky130_fd_sc_hd__fill_2
X_4522_ _3518_ _2889_ _3521_ _3119_ VGND VGND VPWR VPWR _3629_ sky130_fd_sc_hd__a22o_1
X_7241_ _2712_ _2713_ _2726_ VGND VGND VPWR VPWR _2728_ sky130_fd_sc_hd__o21ai_1
X_4453_ _3512_ _3559_ _3560_ _3561_ VGND VGND VPWR VPWR _3562_ sky130_fd_sc_hd__a211o_1
XFILLER_0_40_133 VGND VGND VPWR VPWR sky130_fd_sc_hd__decap_6
XFILLER_0_13_369 VGND VGND VPWR VPWR sky130_fd_sc_hd__decap_6
XFILLER_0_40_177 VGND VGND VPWR VPWR sky130_fd_sc_hd__fill_1
X_4384_ _3415_ _3338_ _3412_ VGND VGND VPWR VPWR _3494_ sky130_fd_sc_hd__or3_4
X_7172_ _2467_ _2652_ VGND VGND VPWR VPWR _2653_ sky130_fd_sc_hd__xor2_2
XFILLER_0_21_391 VGND VGND VPWR VPWR sky130_fd_sc_hd__fill_1
X_6123_ _3352_ _3660_ VGND VGND VPWR VPWR _1506_ sky130_fd_sc_hd__nor2_1
X_6054_ _1297_ _1302_ VGND VGND VPWR VPWR _1430_ sky130_fd_sc_hd__or2b_1
XPHY_EDGE_ROW_31_Right_31 VGND VGND VPWR VPWR sky130_fd_sc_hd__decap_3
X_5005_ _0284_ _0285_ _3407_ VGND VGND VPWR VPWR _0286_ sky130_fd_sc_hd__mux2_1
XFILLER_0_22_3 VPWR VGND VPWR VGND sky130_ef_sc_hd__decap_12
XTAP_TAPCELL_ROW_105_1440 VGND VPWR sky130_fd_sc_hd__tapvpwrvgnd_1
X_6956_ _2080_ _1949_ _1566_ _0704_ VGND VGND VPWR VPWR _2416_ sky130_fd_sc_hd__a22oi_1
X_5907_ _1157_ _1158_ _1192_ _1193_ VGND VGND VPWR VPWR _1269_ sky130_fd_sc_hd__nor4_1
XTAP_TAPCELL_ROW_24_515 VGND VPWR sky130_fd_sc_hd__tapvpwrvgnd_1
XFILLER_0_48_222 VGND VGND VPWR VPWR sky130_fd_sc_hd__decap_3
XTAP_TAPCELL_ROW_52_835 VGND VPWR sky130_fd_sc_hd__tapvpwrvgnd_1
X_6887_ _2338_ _2339_ VGND VGND VPWR VPWR _2340_ sky130_fd_sc_hd__or2_1
XFILLER_0_91_523 VGND VGND VPWR VPWR sky130_fd_sc_hd__fill_1
XFILLER_0_63_225 VPWR VGND VPWR VGND sky130_ef_sc_hd__decap_12
XFILLER_0_8_352 VPWR VGND VPWR VGND sky130_ef_sc_hd__decap_12
X_5838_ _1157_ _1158_ _1193_ _1192_ VGND VGND VPWR VPWR _1194_ sky130_fd_sc_hd__or4_4
XPHY_EDGE_ROW_40_Right_40 VGND VGND VPWR VPWR sky130_fd_sc_hd__decap_3
XFILLER_0_91_589 VPWR VGND VPWR VGND sky130_ef_sc_hd__decap_12
X_5769_ _1006_ _1008_ _1007_ VGND VGND VPWR VPWR _1119_ sky130_fd_sc_hd__o21ba_1
X_7508_ _2802_ _0159_ _0213_ _2485_ VGND VGND VPWR VPWR _3020_ sky130_fd_sc_hd__a22oi_1
XFILLER_0_31_111 VGND VGND VPWR VPWR sky130_fd_sc_hd__fill_1
XFILLER_0_32_645 VGND VGND VPWR VPWR sky130_fd_sc_hd__decap_6
XFILLER_0_102_533 VPWR VGND VPWR VGND sky130_ef_sc_hd__decap_12
X_7439_ _2923_ _2943_ VGND VGND VPWR VPWR _2945_ sky130_fd_sc_hd__and2b_1
XFILLER_0_31_155 VGND VGND VPWR VPWR sky130_fd_sc_hd__decap_3
XFILLER_0_12_391 VPWR VGND VPWR VGND sky130_ef_sc_hd__decap_12
XFILLER_0_31_199 VGND VGND VPWR VPWR sky130_fd_sc_hd__decap_4
XTAP_TAPCELL_ROW_4_284 VGND VPWR sky130_fd_sc_hd__tapvpwrvgnd_1
XFILLER_0_98_177 VPWR VGND VPWR VGND sky130_ef_sc_hd__decap_12
XFILLER_0_86_328 VGND VGND VPWR VPWR sky130_fd_sc_hd__fill_1
XFILLER_0_79_380 VGND VGND VPWR VPWR sky130_fd_sc_hd__decap_4
XFILLER_0_109_110 VGND VGND VPWR VPWR sky130_fd_sc_hd__fill_2
XFILLER_0_27_417 VPWR VGND VPWR VGND sky130_ef_sc_hd__decap_12
XTAP_TAPCELL_ROW_80_1156 VGND VPWR sky130_fd_sc_hd__tapvpwrvgnd_1
XFILLER_0_27_439 VGND VGND VPWR VPWR sky130_fd_sc_hd__decap_8
XFILLER_0_54_214 VGND VGND VPWR VPWR sky130_fd_sc_hd__decap_4
XFILLER_0_2_517 VGND VGND VPWR VPWR sky130_fd_sc_hd__decap_4
XFILLER_0_22_133 VGND VGND VPWR VPWR sky130_fd_sc_hd__fill_1
XFILLER_0_105_393 VGND VGND VPWR VPWR sky130_fd_sc_hd__decap_8
XFILLER_0_77_16 VGND VGND VPWR VPWR sky130_fd_sc_hd__decap_4
XFILLER_0_77_38 VGND VGND VPWR VPWR sky130_fd_sc_hd__decap_3
XFILLER_0_50_497 VGND VGND VPWR VPWR sky130_fd_sc_hd__fill_1
XTAP_TAPCELL_ROW_91_1285 VGND VPWR sky130_fd_sc_hd__tapvpwrvgnd_1
XFILLER_0_93_15 VPWR VGND VPWR VGND sky130_ef_sc_hd__decap_12
XFILLER_0_89_111 VGND VGND VPWR VPWR sky130_fd_sc_hd__fill_1
XFILLER_0_26_42 VGND VGND VPWR VPWR sky130_fd_sc_hd__fill_1
XFILLER_0_26_64 VPWR VGND VPWR VGND sky130_ef_sc_hd__decap_12
XFILLER_0_89_177 VGND VGND VPWR VPWR sky130_fd_sc_hd__decap_6
XFILLER_0_26_97 VPWR VGND VPWR VGND sky130_ef_sc_hd__decap_12
X_6810_ _2254_ _2256_ _2485_ _1020_ VGND VGND VPWR VPWR _2257_ sky130_fd_sc_hd__and4bb_1
XFILLER_0_58_531 VGND VGND VPWR VPWR sky130_fd_sc_hd__fill_1
XFILLER_0_92_309 VPWR VGND VPWR VGND sky130_ef_sc_hd__decap_12
X_3953_ _1173_ _1217_ VGND VGND VPWR VPWR _1238_ sky130_fd_sc_hd__or2_1
XFILLER_0_58_586 VGND VGND VPWR VPWR sky130_fd_sc_hd__fill_2
X_6741_ _2179_ _2180_ VGND VGND VPWR VPWR _2181_ sky130_fd_sc_hd__nand2_1
X_3884_ _0442_ _0453_ _0464_ _0475_ VGND VGND VPWR VPWR _0486_ sky130_fd_sc_hd__or4_1
XFILLER_0_85_383 VGND VGND VPWR VPWR sky130_fd_sc_hd__decap_8
X_6672_ _2036_ _1796_ _1610_ _0671_ VGND VGND VPWR VPWR _2106_ sky130_fd_sc_hd__a22oi_1
XFILLER_0_45_225 VGND VGND VPWR VPWR sky130_fd_sc_hd__fill_2
X_5623_ _3300_ VGND VGND VPWR VPWR _0960_ sky130_fd_sc_hd__inv_2
XFILLER_0_73_556 VGND VGND VPWR VPWR sky130_fd_sc_hd__decap_4
XTAP_TAPCELL_ROW_100_1392 VGND VPWR sky130_fd_sc_hd__tapvpwrvgnd_1
XTAP_TAPCELL_ROW_100_1381 VGND VPWR sky130_fd_sc_hd__tapvpwrvgnd_1
XFILLER_0_13_111 VGND VGND VPWR VPWR sky130_fd_sc_hd__fill_1
X_5554_ _0786_ _0788_ _0787_ VGND VGND VPWR VPWR _0884_ sky130_fd_sc_hd__o21ba_1
XFILLER_0_14_645 VGND VGND VPWR VPWR sky130_fd_sc_hd__decap_6
X_4505_ _3611_ _3612_ VGND VGND VPWR VPWR _3613_ sky130_fd_sc_hd__nor2_1
XFILLER_0_13_144 VGND VGND VPWR VPWR sky130_fd_sc_hd__fill_1
XFILLER_0_5_399 VGND VGND VPWR VPWR sky130_fd_sc_hd__decap_3
X_5485_ _0807_ _0806_ _0686_ _0775_ VGND VGND VPWR VPWR _0809_ sky130_fd_sc_hd__o211a_1
XFILLER_0_41_464 VPWR VGND VPWR VGND sky130_ef_sc_hd__decap_12
X_4436_ _3407_ _3320_ _3443_ _3535_ VGND VGND VPWR VPWR _3545_ sky130_fd_sc_hd__a31o_1
X_7224_ _2707_ _2708_ VGND VGND VPWR VPWR _2709_ sky130_fd_sc_hd__xor2_1
XFILLER_0_6_41 VPWR VGND VPWR VGND sky130_ef_sc_hd__decap_12
X_4367_ _3335_ _3324_ _3336_ _2802_ _3313_ _3317_ VGND VGND VPWR VPWR _3477_ sky130_fd_sc_hd__mux4_1
X_7155_ _2628_ _2629_ _2632_ VGND VGND VPWR VPWR _2634_ sky130_fd_sc_hd__o21ai_1
XFILLER_0_67_82 VGND VGND VPWR VPWR sky130_fd_sc_hd__decap_3
XFILLER_0_6_85 VGND VGND VPWR VPWR sky130_fd_sc_hd__decap_8
X_6106_ _1449_ _1450_ _1484_ _1485_ VGND VGND VPWR VPWR _1487_ sky130_fd_sc_hd__o22ai_2
X_4298_ _3406_ _3407_ _3408_ VGND VGND VPWR VPWR _3409_ sky130_fd_sc_hd__a21o_1
X_7086_ _2532_ _2533_ _2556_ _2557_ VGND VGND VPWR VPWR _2558_ sky130_fd_sc_hd__and4bb_1
X_6037_ net28 net27 net37 net38 VGND VGND VPWR VPWR _1411_ sky130_fd_sc_hd__and4_1
XFILLER_0_83_70 VPWR VGND VPWR VGND sky130_ef_sc_hd__decap_12
XTAP_TAPCELL_ROW_1_243 VGND VPWR sky130_fd_sc_hd__tapvpwrvgnd_1
XFILLER_0_96_626 VPWR VGND VPWR VGND sky130_ef_sc_hd__decap_12
XFILLER_0_95_125 VGND VGND VPWR VPWR sky130_fd_sc_hd__decap_4
XTAP_TAPCELL_ROW_65_982 VGND VPWR sky130_fd_sc_hd__tapvpwrvgnd_1
XTAP_TAPCELL_ROW_37_662 VGND VPWR sky130_fd_sc_hd__tapvpwrvgnd_1
XFILLER_0_95_169 VPWR VGND VPWR VGND sky130_ef_sc_hd__decap_12
X_6939_ _2583_ net46 VGND VGND VPWR VPWR _2398_ sky130_fd_sc_hd__nand2_1
XFILLER_0_64_545 VPWR VGND VPWR VGND sky130_ef_sc_hd__decap_12
XFILLER_0_36_225 VPWR VGND VPWR VGND sky130_ef_sc_hd__decap_12
XFILLER_0_64_589 VGND VGND VPWR VPWR sky130_fd_sc_hd__decap_4
XFILLER_0_17_461 VPWR VGND VPWR VGND sky130_ef_sc_hd__decap_12
XFILLER_0_44_291 VGND VGND VPWR VPWR sky130_fd_sc_hd__fill_1
XFILLER_0_32_475 VGND VGND VPWR VPWR sky130_fd_sc_hd__fill_1
XTAP_TAPCELL_ROW_9_343 VGND VPWR sky130_fd_sc_hd__tapvpwrvgnd_1
XFILLER_0_20_637 VGND VGND VPWR VPWR sky130_fd_sc_hd__decap_6
XTAP_TAPCELL_ROW_69_1029 VGND VPWR sky130_fd_sc_hd__tapvpwrvgnd_1
XFILLER_0_99_486 VGND VGND VPWR VPWR sky130_fd_sc_hd__decap_8
XFILLER_0_74_309 VGND VGND VPWR VPWR sky130_fd_sc_hd__decap_4
XFILLER_0_67_361 VPWR VGND VPWR VGND sky130_ef_sc_hd__decap_12
XFILLER_0_55_512 VGND VGND VPWR VPWR sky130_fd_sc_hd__decap_8
XFILLER_0_27_225 VPWR VGND VPWR VGND sky130_ef_sc_hd__decap_12
XFILLER_0_103_57 VPWR VGND VPWR VGND sky130_ef_sc_hd__decap_12
XFILLER_0_15_409 VPWR VGND VPWR VGND sky130_ef_sc_hd__decap_12
XFILLER_0_70_515 VPWR VGND VPWR VGND sky130_ef_sc_hd__decap_12
XFILLER_0_55_589 VGND VGND VPWR VPWR sky130_fd_sc_hd__fill_2
XFILLER_0_88_15 VPWR VGND VPWR VGND sky130_ef_sc_hd__decap_12
XFILLER_0_2_314 VGND VGND VPWR VPWR sky130_fd_sc_hd__decap_6
XTAP_TAPCELL_ROW_93_1303 VGND VPWR sky130_fd_sc_hd__tapvpwrvgnd_1
XFILLER_0_105_190 VGND VGND VPWR VPWR sky130_fd_sc_hd__decap_8
X_5270_ _0537_ _0538_ _0572_ _0574_ VGND VGND VPWR VPWR _0575_ sky130_fd_sc_hd__and4_1
X_4221_ _3332_ VGND VGND VPWR VPWR _3333_ sky130_fd_sc_hd__buf_4
X_4152_ _2058_ _2091_ VGND VGND VPWR VPWR _3264_ sky130_fd_sc_hd__or2_1
X_4083_ _2649_ VGND VGND VPWR VPWR _2660_ sky130_fd_sc_hd__clkbuf_4
XFILLER_0_77_125 VGND VGND VPWR VPWR sky130_fd_sc_hd__decap_8
XTAP_TAPCELL_ROW_102_1410 VGND VPWR sky130_fd_sc_hd__tapvpwrvgnd_1
XFILLER_0_93_629 VPWR VGND VPWR VGND sky130_ef_sc_hd__decap_12
XTAP_TAPCELL_ROW_62_952 VGND VPWR sky130_fd_sc_hd__tapvpwrvgnd_1
XTAP_TAPCELL_ROW_34_632 VGND VPWR sky130_fd_sc_hd__tapvpwrvgnd_1
X_4985_ _0261_ _0262_ _0160_ _0162_ VGND VGND VPWR VPWR _0264_ sky130_fd_sc_hd__o211ai_2
X_3936_ _0998_ _1031_ VGND VGND VPWR VPWR _1053_ sky130_fd_sc_hd__or2_1
X_6724_ _2007_ _2012_ _2013_ VGND VGND VPWR VPWR _2162_ sky130_fd_sc_hd__or3_1
XFILLER_0_73_342 VGND VGND VPWR VPWR sky130_fd_sc_hd__fill_2
XFILLER_0_18_247 VGND VGND VPWR VPWR sky130_fd_sc_hd__decap_4
XFILLER_0_46_545 VPWR VGND VPWR VGND sky130_ef_sc_hd__decap_12
X_3867_ _0072_ _0083_ _0279_ _0290_ VGND VGND VPWR VPWR _0300_ sky130_fd_sc_hd__o22ai_1
X_6655_ _3810_ _1260_ _1162_ _3809_ VGND VGND VPWR VPWR _2087_ sky130_fd_sc_hd__a22oi_2
XFILLER_0_46_589 VPWR VGND VPWR VGND sky130_ef_sc_hd__decap_12
XFILLER_0_61_559 VGND VGND VPWR VPWR sky130_fd_sc_hd__fill_1
X_5606_ _0817_ _0819_ _0940_ _0939_ VGND VGND VPWR VPWR _0941_ sky130_fd_sc_hd__a211o_4
XFILLER_0_26_280 VGND VGND VPWR VPWR sky130_fd_sc_hd__decap_3
XFILLER_0_33_239 VGND VGND VPWR VPWR sky130_fd_sc_hd__fill_1
X_6586_ _2010_ VGND VGND VPWR VPWR _2011_ sky130_fd_sc_hd__inv_2
XFILLER_0_14_475 VGND VGND VPWR VPWR sky130_fd_sc_hd__fill_1
X_5537_ _0862_ _0863_ _0861_ VGND VGND VPWR VPWR _0865_ sky130_fd_sc_hd__a21bo_1
X_7207_ _2678_ _1094_ _0378_ _2689_ VGND VGND VPWR VPWR _2690_ sky130_fd_sc_hd__o22a_1
XFILLER_0_78_92 VPWR VGND VPWR VGND sky130_ef_sc_hd__decap_12
X_5468_ _0786_ _0789_ VGND VGND VPWR VPWR _0790_ sky130_fd_sc_hd__xnor2_1
XFILLER_0_1_380 VGND VGND VPWR VPWR sky130_fd_sc_hd__decap_4
X_5399_ _3538_ _3533_ _3549_ _3539_ _3742_ _0402_ VGND VGND VPWR VPWR _0716_ sky130_fd_sc_hd__mux4_1
X_4419_ _3517_ _3527_ VGND VGND VPWR VPWR _3528_ sky130_fd_sc_hd__xor2_1
XTAP_TAPCELL_ROW_6_302 VGND VPWR sky130_fd_sc_hd__tapvpwrvgnd_1
X_7138_ _2439_ _2443_ _2440_ VGND VGND VPWR VPWR _2615_ sky130_fd_sc_hd__o21ba_1
X_7069_ _2047_ _1424_ _3256_ _0671_ VGND VGND VPWR VPWR _2540_ sky130_fd_sc_hd__and4_1
XFILLER_0_69_626 VGND VGND VPWR VPWR sky130_fd_sc_hd__decap_6
XFILLER_0_69_648 VGND VGND VPWR VPWR sky130_fd_sc_hd__decap_4
XFILLER_0_96_489 VGND VGND VPWR VPWR sky130_fd_sc_hd__decap_6
XFILLER_0_56_309 VPWR VGND VPWR VGND sky130_ef_sc_hd__decap_12
XFILLER_0_49_350 VGND VGND VPWR VPWR sky130_fd_sc_hd__decap_6
XFILLER_0_83_117 VGND VGND VPWR VPWR sky130_fd_sc_hd__fill_1
XFILLER_0_49_372 VPWR VGND VPWR VGND sky130_ef_sc_hd__decap_12
XFILLER_0_92_651 VGND VGND VPWR VPWR sky130_fd_sc_hd__fill_1
Xinput19 A[27] VGND VGND VPWR VPWR net19 sky130_fd_sc_hd__buf_2
XFILLER_0_52_504 VGND VGND VPWR VPWR sky130_fd_sc_hd__fill_2
XFILLER_0_91_194 VGND VGND VPWR VPWR sky130_fd_sc_hd__fill_2
XFILLER_0_32_272 VGND VGND VPWR VPWR sky130_fd_sc_hd__decap_8
XFILLER_0_102_193 VGND VGND VPWR VPWR sky130_fd_sc_hd__decap_3
XTAP_TAPCELL_ROW_75_1099 VGND VPWR sky130_fd_sc_hd__tapvpwrvgnd_1
XFILLER_0_87_401 VGND VGND VPWR VPWR sky130_fd_sc_hd__decap_6
XFILLER_0_59_103 VGND VGND VPWR VPWR sky130_fd_sc_hd__decap_8
XFILLER_0_90_27 VGND VGND VPWR VPWR sky130_fd_sc_hd__fill_1
XFILLER_0_59_125 VGND VGND VPWR VPWR sky130_fd_sc_hd__decap_4
XFILLER_0_75_629 VPWR VGND VPWR VGND sky130_ef_sc_hd__decap_12
XFILLER_0_74_139 VGND VGND VPWR VPWR sky130_fd_sc_hd__fill_1
XFILLER_0_83_640 VPWR VGND VPWR VGND sky130_ef_sc_hd__decap_12
X_4770_ _3802_ _3842_ VGND VGND VPWR VPWR _0030_ sky130_fd_sc_hd__nor2_1
XFILLER_0_15_217 VGND VGND VPWR VPWR sky130_fd_sc_hd__decap_6
XFILLER_0_23_98 VGND VGND VPWR VPWR sky130_fd_sc_hd__decap_3
XFILLER_0_28_589 VPWR VGND VPWR VGND sky130_ef_sc_hd__decap_12
X_6440_ _2933_ _1020_ _1692_ _1691_ VGND VGND VPWR VPWR _1852_ sky130_fd_sc_hd__a31o_1
X_6371_ _2692_ _1162_ VGND VGND VPWR VPWR _1777_ sky130_fd_sc_hd__nand2_1
X_5322_ _0543_ _0547_ VGND VGND VPWR VPWR _0631_ sky130_fd_sc_hd__or2b_1
XFILLER_0_2_133 VGND VGND VPWR VPWR sky130_fd_sc_hd__decap_6
XFILLER_0_11_434 VGND VGND VPWR VPWR sky130_fd_sc_hd__fill_1
X_5253_ _3021_ _0457_ VGND VGND VPWR VPWR _0556_ sky130_fd_sc_hd__nand2_1
X_4204_ _1391_ VGND VGND VPWR VPWR _3316_ sky130_fd_sc_hd__clkbuf_4
X_5184_ _0351_ _0446_ _0479_ _0480_ VGND VGND VPWR VPWR _0481_ sky130_fd_sc_hd__a211o_1
X_4135_ _2846_ _2878_ _2900_ _2999_ _3218_ VGND VGND VPWR VPWR _3228_ sky130_fd_sc_hd__a221o_1
XFILLER_0_64_50 VPWR VGND VPWR VGND sky130_ef_sc_hd__decap_12
X_4066_ _2441_ VGND VGND VPWR VPWR _2474_ sky130_fd_sc_hd__clkbuf_4
XFILLER_0_78_445 VPWR VGND VPWR VGND sky130_ef_sc_hd__decap_12
XFILLER_0_38_309 VGND VGND VPWR VPWR sky130_fd_sc_hd__decap_6
XFILLER_0_19_512 VGND VGND VPWR VPWR sky130_fd_sc_hd__decap_8
XFILLER_0_74_651 VGND VGND VPWR VPWR sky130_fd_sc_hd__fill_1
X_4968_ _0241_ _0243_ _0244_ VGND VGND VPWR VPWR _0245_ sky130_fd_sc_hd__or3_1
XFILLER_0_19_556 VGND VGND VPWR VPWR sky130_fd_sc_hd__decap_4
X_7687_ _3721_ _3443_ _2148_ _3215_ VGND VGND VPWR VPWR _3216_ sky130_fd_sc_hd__a31o_1
X_6707_ _0148_ _1360_ _3512_ _0551_ VGND VGND VPWR VPWR _2144_ sky130_fd_sc_hd__a2bb2o_1
X_4899_ _0168_ _0169_ VGND VGND VPWR VPWR _0171_ sky130_fd_sc_hd__or2b_1
XFILLER_0_61_301 VGND VGND VPWR VPWR sky130_fd_sc_hd__decap_4
X_3919_ net45 VGND VGND VPWR VPWR _0867_ sky130_fd_sc_hd__buf_2
X_6638_ _2064_ _2065_ _2066_ VGND VGND VPWR VPWR _2068_ sky130_fd_sc_hd__a21o_1
X_6569_ _0192_ _0376_ _3747_ _0573_ VGND VGND VPWR VPWR _1994_ sky130_fd_sc_hd__o22a_1
XFILLER_0_100_642 VGND VGND VPWR VPWR sky130_fd_sc_hd__fill_2
XFILLER_0_88_209 VPWR VGND VPWR VGND sky130_ef_sc_hd__decap_12
XFILLER_0_96_253 VPWR VGND VPWR VGND sky130_ef_sc_hd__decap_12
XTAP_TAPCELL_ROW_17_429 VGND VPWR sky130_fd_sc_hd__tapvpwrvgnd_1
XTAP_TAPCELL_ROW_45_749 VGND VPWR sky130_fd_sc_hd__tapvpwrvgnd_1
XPHY_EDGE_ROW_69_Right_69 VGND VGND VPWR VPWR sky130_fd_sc_hd__decap_3
XFILLER_0_56_128 VGND VGND VPWR VPWR sky130_fd_sc_hd__fill_1
XFILLER_0_52_301 VGND VGND VPWR VPWR sky130_fd_sc_hd__decap_6
XFILLER_0_80_643 VGND VGND VPWR VPWR sky130_fd_sc_hd__fill_1
XTAP_TAPCELL_ROW_77_1117 VGND VPWR sky130_fd_sc_hd__tapvpwrvgnd_1
XFILLER_0_12_209 VPWR VGND VPWR VGND sky130_ef_sc_hd__decap_12
XPHY_EDGE_ROW_78_Right_78 VGND VGND VPWR VPWR sky130_fd_sc_hd__decap_3
XFILLER_0_20_253 VGND VGND VPWR VPWR sky130_fd_sc_hd__decap_4
XFILLER_0_20_286 VGND VGND VPWR VPWR sky130_fd_sc_hd__fill_1
XFILLER_0_20_297 VGND VGND VPWR VPWR sky130_fd_sc_hd__decap_8
XTAP_TAPCELL_ROW_88_1246 VGND VPWR sky130_fd_sc_hd__tapvpwrvgnd_1
X_5940_ net155 _0987_ _0660_ net142 VGND VGND VPWR VPWR _1306_ sky130_fd_sc_hd__a22oi_1
XPHY_EDGE_ROW_87_Right_87 VGND VGND VPWR VPWR sky130_fd_sc_hd__decap_3
X_7610_ _3312_ _0322_ _2884_ _2883_ _0072_ VGND VGND VPWR VPWR _3132_ sky130_fd_sc_hd__a32o_1
X_5871_ _3566_ _1222_ _1227_ _1230_ _0717_ VGND VGND VPWR VPWR _1231_ sky130_fd_sc_hd__o2111a_1
X_4822_ _0086_ VGND VGND VPWR VPWR _0087_ sky130_fd_sc_hd__buf_1
XFILLER_0_7_203 VGND VGND VPWR VPWR sky130_fd_sc_hd__fill_1
XFILLER_0_47_139 VGND VGND VPWR VPWR sky130_fd_sc_hd__decap_4
X_4753_ _3600_ _0013_ _3340_ VGND VGND VPWR VPWR _0014_ sky130_fd_sc_hd__mux2_1
X_7541_ _3055_ _3056_ VGND VGND VPWR VPWR _3057_ sky130_fd_sc_hd__nand2_1
XFILLER_0_62_109 VPWR VGND VPWR VGND sky130_ef_sc_hd__decap_12
XFILLER_0_43_301 VGND VGND VPWR VPWR sky130_fd_sc_hd__fill_1
XFILLER_0_50_41 VGND VGND VPWR VPWR sky130_fd_sc_hd__decap_8
XFILLER_0_70_120 VGND VGND VPWR VPWR sky130_fd_sc_hd__decap_6
X_7472_ _2971_ _2784_ _2979_ VGND VGND VPWR VPWR _2981_ sky130_fd_sc_hd__nor3_1
XFILLER_0_7_269 VGND VGND VPWR VPWR sky130_fd_sc_hd__decap_8
XFILLER_0_7_258 VGND VGND VPWR VPWR sky130_fd_sc_hd__decap_4
XFILLER_0_50_85 VPWR VGND VPWR VGND sky130_ef_sc_hd__decap_12
XTAP_TAPCELL_ROW_99_1375 VGND VPWR sky130_fd_sc_hd__tapvpwrvgnd_1
XFILLER_0_31_518 VGND VGND VPWR VPWR sky130_fd_sc_hd__fill_2
X_6423_ _1695_ _1696_ VGND VGND VPWR VPWR _1833_ sky130_fd_sc_hd__and2_1
XFILLER_0_43_367 VGND VGND VPWR VPWR sky130_fd_sc_hd__decap_3
X_4684_ _3786_ _3787_ _3788_ VGND VGND VPWR VPWR _3789_ sky130_fd_sc_hd__nand3_2
XPHY_EDGE_ROW_96_Right_96 VGND VGND VPWR VPWR sky130_fd_sc_hd__decap_3
XFILLER_0_70_197 VGND VGND VPWR VPWR sky130_fd_sc_hd__decap_8
XFILLER_0_70_175 VGND VGND VPWR VPWR sky130_fd_sc_hd__decap_8
XFILLER_0_24_581 VGND VGND VPWR VPWR sky130_fd_sc_hd__decap_6
X_6354_ _1755_ _1756_ _1757_ VGND VGND VPWR VPWR _1758_ sky130_fd_sc_hd__or3_1
XFILLER_0_3_475 VPWR VGND VPWR VGND sky130_ef_sc_hd__decap_12
X_5305_ _3742_ _3373_ _0610_ _0612_ _0386_ VGND VGND VPWR VPWR _0613_ sky130_fd_sc_hd__o311a_1
XFILLER_0_59_83 VPWR VGND VPWR VGND sky130_ef_sc_hd__decap_12
X_6285_ _1680_ _1681_ VGND VGND VPWR VPWR _1682_ sky130_fd_sc_hd__nand2_1
X_5236_ _0517_ _0535_ _0536_ VGND VGND VPWR VPWR _0537_ sky130_fd_sc_hd__nand3_2
XFILLER_0_52_3 VPWR VGND VPWR VGND sky130_ef_sc_hd__decap_12
X_5167_ net132 _1927_ VGND VGND VPWR VPWR _0462_ sky130_fd_sc_hd__nand2_1
X_5098_ _3602_ _0382_ _0385_ _0110_ _0386_ VGND VGND VPWR VPWR _0387_ sky130_fd_sc_hd__a221o_1
X_4118_ _3032_ VGND VGND VPWR VPWR _3043_ sky130_fd_sc_hd__buf_6
X_4049_ _1009_ _2178_ _2277_ VGND VGND VPWR VPWR _2288_ sky130_fd_sc_hd__o21a_1
XTAP_TAPCELL_ROW_108_1482 VGND VPWR sky130_fd_sc_hd__tapvpwrvgnd_1
XFILLER_0_78_253 VPWR VGND VPWR VGND sky130_ef_sc_hd__decap_12
XFILLER_0_78_297 VGND VGND VPWR VPWR sky130_fd_sc_hd__decap_3
XFILLER_0_38_117 VGND VGND VPWR VPWR sky130_fd_sc_hd__fill_2
XFILLER_0_39_629 VPWR VGND VPWR VGND sky130_ef_sc_hd__decap_12
XTAP_TAPCELL_ROW_42_719 VGND VPWR sky130_fd_sc_hd__tapvpwrvgnd_1
XFILLER_0_93_278 VGND VGND VPWR VPWR sky130_fd_sc_hd__fill_2
XFILLER_0_19_397 VGND VGND VPWR VPWR sky130_fd_sc_hd__fill_1
XFILLER_0_104_222 VGND VGND VPWR VPWR sky130_fd_sc_hd__decap_6
XTAP_TAPCELL_ROW_22_487 VGND VPWR sky130_fd_sc_hd__tapvpwrvgnd_1
XFILLER_0_104_233 VPWR VGND VPWR VGND sky130_ef_sc_hd__decap_12
XFILLER_0_100_494 VPWR VGND VPWR VGND sky130_ef_sc_hd__decap_12
XTAP_TAPCELL_ROW_72_1069 VGND VPWR sky130_fd_sc_hd__tapvpwrvgnd_1
XFILLER_0_55_19 VPWR VGND VPWR VGND sky130_ef_sc_hd__decap_12
XFILLER_0_89_518 VGND VGND VPWR VPWR sky130_fd_sc_hd__fill_1
XFILLER_0_29_106 VGND VGND VPWR VPWR sky130_fd_sc_hd__decap_6
XTAP_TAPCELL_ROW_83_1187 VGND VPWR sky130_fd_sc_hd__tapvpwrvgnd_1
XFILLER_0_84_278 VGND VGND VPWR VPWR sky130_fd_sc_hd__decap_8
XFILLER_0_38_651 VGND VGND VPWR VPWR sky130_fd_sc_hd__fill_1
XFILLER_0_25_334 VGND VGND VPWR VPWR sky130_fd_sc_hd__fill_2
XFILLER_0_53_643 VGND VGND VPWR VPWR sky130_fd_sc_hd__decap_4
XFILLER_0_25_367 VGND VGND VPWR VPWR sky130_fd_sc_hd__decap_8
XFILLER_0_80_484 VGND VGND VPWR VPWR sky130_fd_sc_hd__decap_4
XFILLER_0_20_44 VGND VGND VPWR VPWR sky130_fd_sc_hd__fill_2
Xmax_cap105 _2005_ VGND VGND VPWR VPWR net105 sky130_fd_sc_hd__buf_1
XFILLER_0_40_348 VPWR VGND VPWR VGND sky130_ef_sc_hd__decap_12
XFILLER_0_21_573 VPWR VGND VPWR VGND sky130_ef_sc_hd__decap_12
XFILLER_0_0_489 VPWR VGND VPWR VGND sky130_ef_sc_hd__decap_12
X_6070_ _1430_ _1431_ _1445_ VGND VGND VPWR VPWR _1448_ sky130_fd_sc_hd__nand3_2
X_5021_ _3258_ _0302_ VGND VGND VPWR VPWR _0303_ sky130_fd_sc_hd__xnor2_1
X_6972_ _2245_ _2284_ _2432_ _2433_ VGND VGND VPWR VPWR _2434_ sky130_fd_sc_hd__o211ai_2
X_5923_ _1533_ _3268_ _1148_ _1286_ VGND VGND VPWR VPWR _1287_ sky130_fd_sc_hd__a31o_1
XFILLER_0_75_223 VGND VGND VPWR VPWR sky130_fd_sc_hd__fill_1
X_5854_ _1102_ _1078_ _1211_ VGND VGND VPWR VPWR _1212_ sky130_fd_sc_hd__a21o_1
XFILLER_0_75_256 VPWR VGND VPWR VGND sky130_ef_sc_hd__decap_12
XFILLER_0_61_73 VGND VGND VPWR VPWR sky130_fd_sc_hd__fill_1
X_4805_ _0065_ _0066_ _0046_ VGND VGND VPWR VPWR _0068_ sky130_fd_sc_hd__a21o_1
XFILLER_0_90_215 VPWR VGND VPWR VGND sky130_ef_sc_hd__decap_12
X_7524_ _3036_ _3037_ VGND VGND VPWR VPWR _3038_ sky130_fd_sc_hd__nor2_1
X_5785_ _1023_ _1024_ _1059_ _1058_ VGND VGND VPWR VPWR _1136_ sky130_fd_sc_hd__nor4_2
XFILLER_0_8_589 VPWR VGND VPWR VGND sky130_ef_sc_hd__decap_12
XFILLER_0_71_440 VGND VGND VPWR VPWR sky130_fd_sc_hd__decap_4
X_4736_ _3793_ _3795_ _3838_ _3839_ VGND VGND VPWR VPWR _3840_ sky130_fd_sc_hd__a211o_1
XFILLER_0_43_153 VPWR VGND VPWR VGND sky130_ef_sc_hd__decap_12
X_7455_ _2960_ _2961_ VGND VGND VPWR VPWR _2962_ sky130_fd_sc_hd__xnor2_1
XFILLER_0_9_96 VPWR VGND VPWR VGND sky130_ef_sc_hd__decap_12
X_4667_ net29 VGND VGND VPWR VPWR _3772_ sky130_fd_sc_hd__clkbuf_4
X_7386_ _3310_ net21 VGND VGND VPWR VPWR _2886_ sky130_fd_sc_hd__nand2_1
X_6406_ _0933_ _2157_ _1089_ VGND VGND VPWR VPWR _1815_ sky130_fd_sc_hd__mux2_1
XFILLER_0_3_261 VPWR VGND VPWR VGND sky130_ef_sc_hd__decap_12
XFILLER_0_31_337 VGND VGND VPWR VPWR sky130_fd_sc_hd__decap_3
X_4598_ _3684_ _3702_ _3703_ VGND VGND VPWR VPWR _3704_ sky130_fd_sc_hd__and3_1
XFILLER_0_3_294 VGND VGND VPWR VPWR sky130_fd_sc_hd__decap_3
X_6337_ _1735_ _1736_ _1737_ VGND VGND VPWR VPWR _1739_ sky130_fd_sc_hd__o21ai_1
XFILLER_0_101_269 VGND VGND VPWR VPWR sky130_fd_sc_hd__fill_2
XFILLER_0_86_70 VGND VGND VPWR VPWR sky130_fd_sc_hd__fill_1
X_6268_ _3489_ _1659_ _1663_ VGND VGND VPWR VPWR _1664_ sky130_fd_sc_hd__a21o_1
X_5219_ _0448_ _0452_ VGND VGND VPWR VPWR _0519_ sky130_fd_sc_hd__or2b_1
X_6199_ _1585_ _1586_ _1568_ _1569_ VGND VGND VPWR VPWR _1589_ sky130_fd_sc_hd__a211oi_2
XTAP_TAPCELL_ROW_55_866 VGND VPWR sky130_fd_sc_hd__tapvpwrvgnd_1
XTAP_TAPCELL_ROW_27_546 VGND VPWR sky130_fd_sc_hd__tapvpwrvgnd_1
XFILLER_0_39_426 VPWR VGND VPWR VGND sky130_ef_sc_hd__decap_12
XFILLER_0_66_245 VGND VGND VPWR VPWR sky130_fd_sc_hd__fill_2
XFILLER_0_66_256 VPWR VGND VPWR VGND sky130_ef_sc_hd__decap_12
XFILLER_0_26_109 VPWR VGND VPWR VGND sky130_ef_sc_hd__decap_12
XFILLER_0_19_183 VPWR VGND VPWR VGND sky130_ef_sc_hd__decap_12
XFILLER_0_47_481 VGND VGND VPWR VPWR sky130_fd_sc_hd__decap_6
XFILLER_0_62_484 VGND VGND VPWR VPWR sky130_fd_sc_hd__fill_2
XFILLER_0_105_564 VPWR VGND VPWR VGND sky130_ef_sc_hd__decap_12
XFILLER_0_34_197 VPWR VGND VPWR VGND sky130_ef_sc_hd__decap_12
XFILLER_0_66_29 VGND VGND VPWR VPWR sky130_fd_sc_hd__decap_6
XFILLER_0_100_291 VGND VGND VPWR VPWR sky130_fd_sc_hd__fill_1
XTAP_TAPCELL_ROW_85_1216 VGND VPWR sky130_fd_sc_hd__tapvpwrvgnd_1
XFILLER_0_85_532 VPWR VGND VPWR VGND sky130_ef_sc_hd__decap_12
XFILLER_0_9_309 VGND VGND VPWR VPWR sky130_fd_sc_hd__fill_2
XFILLER_0_85_587 VGND VGND VPWR VPWR sky130_fd_sc_hd__decap_3
XFILLER_0_17_109 VGND VGND VPWR VPWR sky130_fd_sc_hd__decap_3
XFILLER_0_26_632 VPWR VGND VPWR VGND sky130_ef_sc_hd__decap_12
XFILLER_0_31_32 VGND VGND VPWR VPWR sky130_fd_sc_hd__fill_2
X_5570_ _0898_ _0899_ _0901_ VGND VGND VPWR VPWR _0902_ sky130_fd_sc_hd__or3_4
X_4521_ _2911_ _2867_ _3152_ _2977_ VGND VGND VPWR VPWR _3628_ sky130_fd_sc_hd__nand4_1
XFILLER_0_41_613 VGND VGND VPWR VPWR sky130_fd_sc_hd__decap_3
XTAP_TAPCELL_ROW_96_1345 VGND VPWR sky130_fd_sc_hd__tapvpwrvgnd_1
X_7240_ _2712_ _2713_ _2726_ VGND VGND VPWR VPWR _2727_ sky130_fd_sc_hd__or3_1
X_4452_ _3336_ _3357_ VGND VGND VPWR VPWR _3561_ sky130_fd_sc_hd__nor2_1
XFILLER_0_80_292 VGND VGND VPWR VPWR sky130_fd_sc_hd__fill_1
XFILLER_0_0_220 VGND VGND VPWR VPWR sky130_fd_sc_hd__fill_1
X_4383_ _3288_ _2900_ VGND VGND VPWR VPWR _3493_ sky130_fd_sc_hd__nor2_1
X_7171_ _2650_ _2651_ VGND VGND VPWR VPWR _2652_ sky130_fd_sc_hd__xnor2_1
XFILLER_0_0_253 VGND VGND VPWR VPWR sky130_fd_sc_hd__fill_2
X_6122_ _1042_ _1140_ _1380_ _0953_ VGND VGND VPWR VPWR _1505_ sky130_fd_sc_hd__a31o_1
X_6053_ _1279_ _1288_ VGND VGND VPWR VPWR _1429_ sky130_fd_sc_hd__and2_1
X_5004_ _1894_ _1872_ _3317_ VGND VGND VPWR VPWR _0285_ sky130_fd_sc_hd__mux2_1
XFILLER_0_15_3 VPWR VGND VPWR VGND sky130_ef_sc_hd__decap_12
X_6955_ _2080_ _1949_ _1566_ _0704_ VGND VGND VPWR VPWR _2415_ sky130_fd_sc_hd__and4_1
XTAP_TAPCELL_ROW_105_1441 VGND VPWR sky130_fd_sc_hd__tapvpwrvgnd_1
XFILLER_0_72_83 VGND VGND VPWR VPWR sky130_fd_sc_hd__fill_1
XTAP_TAPCELL_ROW_24_516 VGND VPWR sky130_fd_sc_hd__tapvpwrvgnd_1
X_5906_ _1265_ _1266_ _1127_ _1130_ VGND VGND VPWR VPWR _1268_ sky130_fd_sc_hd__o211a_1
XTAP_TAPCELL_ROW_52_836 VGND VPWR sky130_fd_sc_hd__tapvpwrvgnd_1
X_6886_ net149 _2627_ net19 _0922_ VGND VGND VPWR VPWR _2339_ sky130_fd_sc_hd__and4_1
XFILLER_0_76_587 VGND VGND VPWR VPWR sky130_fd_sc_hd__fill_1
XFILLER_0_63_204 VPWR VGND VPWR VGND sky130_ef_sc_hd__decap_12
XFILLER_0_36_418 VGND VGND VPWR VPWR sky130_fd_sc_hd__fill_2
XFILLER_0_91_535 VGND VGND VPWR VPWR sky130_fd_sc_hd__fill_1
XFILLER_0_63_237 VPWR VGND VPWR VGND sky130_ef_sc_hd__decap_12
X_5837_ _1191_ _1190_ _1054_ _1159_ VGND VGND VPWR VPWR _1193_ sky130_fd_sc_hd__o211a_4
XFILLER_0_29_481 VGND VGND VPWR VPWR sky130_fd_sc_hd__fill_1
XFILLER_0_48_289 VPWR VGND VPWR VGND sky130_ef_sc_hd__decap_12
XFILLER_0_106_317 VPWR VGND VPWR VGND sky130_ef_sc_hd__decap_12
X_5768_ _3331_ _0802_ _0991_ _0989_ VGND VGND VPWR VPWR _1117_ sky130_fd_sc_hd__a31o_1
XFILLER_0_44_451 VGND VGND VPWR VPWR sky130_fd_sc_hd__decap_3
X_7507_ _3325_ _0944_ _2761_ _2760_ VGND VGND VPWR VPWR _3019_ sky130_fd_sc_hd__a31o_1
XFILLER_0_16_164 VGND VGND VPWR VPWR sky130_fd_sc_hd__fill_2
X_4719_ _3521_ _3777_ _3621_ _3518_ VGND VGND VPWR VPWR _3823_ sky130_fd_sc_hd__a22oi_2
XFILLER_0_102_501 VGND VGND VPWR VPWR sky130_fd_sc_hd__decap_4
X_7438_ _2941_ _2942_ VGND VGND VPWR VPWR _2943_ sky130_fd_sc_hd__nor2_1
XFILLER_0_71_281 VPWR VGND VPWR VGND sky130_ef_sc_hd__decap_12
X_5699_ net7 net53 net6 net56 VGND VGND VPWR VPWR _1043_ sky130_fd_sc_hd__and4_1
XPHY_EDGE_ROW_15_Left_125 VGND VGND VPWR VPWR sky130_fd_sc_hd__decap_3
XFILLER_0_16_197 VGND VGND VPWR VPWR sky130_fd_sc_hd__decap_8
XFILLER_0_102_545 VPWR VGND VPWR VGND sky130_ef_sc_hd__decap_12
XFILLER_0_4_581 VGND VGND VPWR VPWR sky130_fd_sc_hd__decap_6
XFILLER_0_102_567 VPWR VGND VPWR VGND sky130_ef_sc_hd__decap_12
X_7369_ _1366_ _2312_ _2866_ _1369_ VGND VGND VPWR VPWR _2868_ sky130_fd_sc_hd__o211a_1
XFILLER_0_102_589 VGND VGND VPWR VPWR sky130_fd_sc_hd__fill_2
XFILLER_0_98_101 VGND VGND VPWR VPWR sky130_fd_sc_hd__decap_8
XTAP_TAPCELL_ROW_4_285 VGND VPWR sky130_fd_sc_hd__tapvpwrvgnd_1
XPHY_EDGE_ROW_24_Left_134 VGND VGND VPWR VPWR sky130_fd_sc_hd__decap_3
XFILLER_0_98_189 VGND VGND VPWR VPWR sky130_fd_sc_hd__decap_6
XFILLER_0_98_167 VGND VGND VPWR VPWR sky130_fd_sc_hd__fill_1
XFILLER_0_86_307 VGND VGND VPWR VPWR sky130_fd_sc_hd__fill_1
XPHY_EDGE_ROW_105_Right_105 VGND VGND VPWR VPWR sky130_fd_sc_hd__decap_3
XFILLER_0_39_223 VGND VGND VPWR VPWR sky130_fd_sc_hd__fill_1
XFILLER_0_39_245 VGND VGND VPWR VPWR sky130_fd_sc_hd__fill_1
XFILLER_0_39_256 VPWR VGND VPWR VGND sky130_ef_sc_hd__decap_12
XFILLER_0_94_384 VGND VGND VPWR VPWR sky130_fd_sc_hd__decap_3
XTAP_TAPCELL_ROW_80_1157 VGND VPWR sky130_fd_sc_hd__tapvpwrvgnd_1
XFILLER_0_27_429 VGND VGND VPWR VPWR sky130_fd_sc_hd__decap_3
XFILLER_0_109_166 VGND VGND VPWR VPWR sky130_fd_sc_hd__fill_2
XPHY_EDGE_ROW_33_Left_143 VGND VGND VPWR VPWR sky130_fd_sc_hd__decap_3
XFILLER_0_35_473 VGND VGND VPWR VPWR sky130_fd_sc_hd__decap_3
XFILLER_0_105_361 VGND VGND VPWR VPWR sky130_fd_sc_hd__fill_2
XFILLER_0_50_421 VGND VGND VPWR VPWR sky130_fd_sc_hd__decap_8
XTAP_TAPCELL_ROW_91_1286 VGND VPWR sky130_fd_sc_hd__tapvpwrvgnd_1
XFILLER_0_93_27 VGND VGND VPWR VPWR sky130_fd_sc_hd__decap_8
XPHY_EDGE_ROW_42_Left_152 VGND VGND VPWR VPWR sky130_fd_sc_hd__decap_3
XFILLER_0_93_49 VGND VGND VPWR VPWR sky130_fd_sc_hd__decap_6
XFILLER_0_89_123 VGND VGND VPWR VPWR sky130_fd_sc_hd__decap_8
XFILLER_0_77_307 VGND VGND VPWR VPWR sky130_fd_sc_hd__decap_8
XFILLER_0_26_76 VGND VGND VPWR VPWR sky130_fd_sc_hd__decap_8
X_6740_ _2162_ _2163_ _2177_ VGND VGND VPWR VPWR _2180_ sky130_fd_sc_hd__nand3_1
X_3952_ _1184_ _1217_ VGND VGND VPWR VPWR _1228_ sky130_fd_sc_hd__nand2_1
XFILLER_0_73_502 VGND VGND VPWR VPWR sky130_fd_sc_hd__fill_2
X_3883_ _0377_ _0399_ VGND VGND VPWR VPWR _0475_ sky130_fd_sc_hd__or2_1
X_6671_ _2036_ _1796_ _1610_ _0660_ VGND VGND VPWR VPWR _2105_ sky130_fd_sc_hd__and4_1
XFILLER_0_42_75 VGND VGND VPWR VPWR sky130_fd_sc_hd__fill_2
XPHY_EDGE_ROW_51_Left_161 VGND VGND VPWR VPWR sky130_fd_sc_hd__decap_3
X_5622_ _0846_ _0957_ _0596_ VGND VGND VPWR VPWR _0959_ sky130_fd_sc_hd__a21o_1
XFILLER_0_26_440 VGND VGND VPWR VPWR sky130_fd_sc_hd__decap_3
XFILLER_0_45_259 VGND VGND VPWR VPWR sky130_fd_sc_hd__fill_1
XTAP_TAPCELL_ROW_100_1382 VGND VPWR sky130_fd_sc_hd__tapvpwrvgnd_1
XFILLER_0_60_218 VGND VGND VPWR VPWR sky130_fd_sc_hd__decap_4
X_5553_ _0778_ _0779_ VGND VGND VPWR VPWR _0883_ sky130_fd_sc_hd__and2b_1
XFILLER_0_5_345 VGND VGND VPWR VPWR sky130_fd_sc_hd__fill_1
XFILLER_0_14_602 VPWR VGND VPWR VGND sky130_ef_sc_hd__decap_12
X_4504_ _3537_ _3598_ VGND VGND VPWR VPWR _3612_ sky130_fd_sc_hd__nor2_1
XFILLER_0_53_281 VGND VGND VPWR VPWR sky130_fd_sc_hd__fill_2
XFILLER_0_13_167 VGND VGND VPWR VPWR sky130_fd_sc_hd__fill_1
X_5484_ _0686_ _0775_ _0806_ _0807_ VGND VGND VPWR VPWR _0808_ sky130_fd_sc_hd__a211oi_4
XFILLER_0_41_476 VGND VGND VPWR VPWR sky130_fd_sc_hd__decap_8
X_7223_ _2714_ _0181_ VGND VGND VPWR VPWR _2708_ sky130_fd_sc_hd__nand2_1
X_4435_ _3141_ _3543_ VGND VGND VPWR VPWR _3544_ sky130_fd_sc_hd__xnor2_1
X_4366_ _3325_ _3271_ _3326_ _3305_ _3313_ _3317_ VGND VGND VPWR VPWR _3476_ sky130_fd_sc_hd__mux4_1
X_7154_ _2628_ _2629_ _2632_ VGND VGND VPWR VPWR _2633_ sky130_fd_sc_hd__or3_2
XFILLER_0_6_53 VPWR VGND VPWR VGND sky130_ef_sc_hd__decap_12
XPHY_EDGE_ROW_60_Left_170 VGND VGND VPWR VPWR sky130_fd_sc_hd__decap_3
X_6105_ _1449_ _1450_ _1484_ _1485_ VGND VGND VPWR VPWR _1486_ sky130_fd_sc_hd__or4_4
X_4297_ net65 net66 _3361_ VGND VGND VPWR VPWR _3408_ sky130_fd_sc_hd__or3_2
X_7085_ _2554_ _2555_ _2534_ _2535_ VGND VGND VPWR VPWR _2557_ sky130_fd_sc_hd__a211o_1
X_6036_ _2441_ net37 net38 _2649_ VGND VGND VPWR VPWR _1410_ sky130_fd_sc_hd__a22oi_1
Xrebuffer20 _1056_ VGND VGND VPWR VPWR net138 sky130_fd_sc_hd__clkbuf_2
XFILLER_0_96_638 VGND VGND VPWR VPWR sky130_fd_sc_hd__decap_6
XFILLER_0_96_616 VGND VGND VPWR VPWR sky130_fd_sc_hd__decap_3
XFILLER_0_83_82 VPWR VGND VPWR VGND sky130_ef_sc_hd__decap_12
XTAP_TAPCELL_ROW_1_244 VGND VPWR sky130_fd_sc_hd__tapvpwrvgnd_1
XTAP_TAPCELL_ROW_65_983 VGND VPWR sky130_fd_sc_hd__tapvpwrvgnd_1
XTAP_TAPCELL_ROW_37_663 VGND VPWR sky130_fd_sc_hd__tapvpwrvgnd_1
XFILLER_0_49_543 VGND VGND VPWR VPWR sky130_fd_sc_hd__fill_2
X_6938_ _2394_ _2395_ VGND VGND VPWR VPWR _2396_ sky130_fd_sc_hd__nor2_1
X_6869_ _2303_ _2305_ _2309_ _2320_ VGND VGND VPWR VPWR _2322_ sky130_fd_sc_hd__o211ai_2
XFILLER_0_76_395 VPWR VGND VPWR VGND sky130_ef_sc_hd__decap_12
XFILLER_0_107_615 VGND VGND VPWR VPWR sky130_fd_sc_hd__fill_1
XFILLER_0_64_557 VPWR VGND VPWR VGND sky130_ef_sc_hd__decap_12
XFILLER_0_36_237 VGND VGND VPWR VPWR sky130_fd_sc_hd__decap_4
XFILLER_0_17_473 VGND VGND VPWR VPWR sky130_fd_sc_hd__decap_8
XTAP_TAPCELL_ROW_9_344 VGND VPWR sky130_fd_sc_hd__tapvpwrvgnd_1
XFILLER_0_4_3 VPWR VGND VPWR VGND sky130_ef_sc_hd__decap_12
XFILLER_0_99_421 VGND VGND VPWR VPWR sky130_fd_sc_hd__fill_2
XFILLER_0_87_649 VGND VGND VPWR VPWR sky130_fd_sc_hd__decap_3
XFILLER_0_94_181 VGND VGND VPWR VPWR sky130_fd_sc_hd__fill_1
XFILLER_0_82_321 VPWR VGND VPWR VGND sky130_ef_sc_hd__decap_12
XFILLER_0_67_373 VGND VGND VPWR VPWR sky130_fd_sc_hd__fill_1
XFILLER_0_55_557 VGND VGND VPWR VPWR sky130_fd_sc_hd__decap_3
XFILLER_0_55_546 VGND VGND VPWR VPWR sky130_fd_sc_hd__decap_4
XFILLER_0_27_237 VPWR VGND VPWR VGND sky130_ef_sc_hd__decap_12
XFILLER_0_103_69 VPWR VGND VPWR VGND sky130_ef_sc_hd__decap_12
XFILLER_0_82_365 VPWR VGND VPWR VGND sky130_ef_sc_hd__decap_12
XFILLER_0_70_527 VGND VGND VPWR VPWR sky130_fd_sc_hd__decap_4
XFILLER_0_12_67 VGND VGND VPWR VPWR sky130_fd_sc_hd__decap_8
XFILLER_0_88_27 VGND VGND VPWR VPWR sky130_fd_sc_hd__fill_1
XFILLER_0_23_432 VPWR VGND VPWR VGND sky130_ef_sc_hd__decap_12
XFILLER_0_42_229 VGND VGND VPWR VPWR sky130_fd_sc_hd__fill_1
XTAP_TAPCELL_ROW_93_1304 VGND VPWR sky130_fd_sc_hd__tapvpwrvgnd_1
XFILLER_0_2_348 VGND VGND VPWR VPWR sky130_fd_sc_hd__decap_6
XFILLER_0_11_649 VGND VGND VPWR VPWR sky130_fd_sc_hd__decap_3
XFILLER_0_10_104 VPWR VGND VPWR VGND sky130_ef_sc_hd__decap_12
X_4220_ _3331_ VGND VGND VPWR VPWR _3332_ sky130_fd_sc_hd__buf_4
X_4151_ _2047_ _2091_ VGND VGND VPWR VPWR _3263_ sky130_fd_sc_hd__nand2_2
X_4082_ net27 VGND VGND VPWR VPWR _2649_ sky130_fd_sc_hd__buf_6
XTAP_TAPCELL_ROW_102_1411 VGND VPWR sky130_fd_sc_hd__tapvpwrvgnd_1
XFILLER_0_93_608 VGND VGND VPWR VPWR sky130_fd_sc_hd__decap_8
XTAP_TAPCELL_ROW_34_622 VGND VPWR sky130_fd_sc_hd__tapvpwrvgnd_1
XTAP_TAPCELL_ROW_34_633 VGND VPWR sky130_fd_sc_hd__tapvpwrvgnd_1
X_4984_ _0160_ _0162_ _0261_ _0262_ VGND VGND VPWR VPWR _0263_ sky130_fd_sc_hd__a211o_1
XFILLER_0_53_74 VPWR VGND VPWR VGND sky130_ef_sc_hd__decap_12
XFILLER_0_53_96 VGND VGND VPWR VPWR sky130_fd_sc_hd__decap_3
X_3935_ _1009_ _1031_ VGND VGND VPWR VPWR _1042_ sky130_fd_sc_hd__nand2_2
XFILLER_0_73_310 VGND VGND VPWR VPWR sky130_fd_sc_hd__decap_4
XTAP_TAPCELL_ROW_62_953 VGND VPWR sky130_fd_sc_hd__tapvpwrvgnd_1
XFILLER_0_58_395 VPWR VGND VPWR VGND sky130_ef_sc_hd__decap_12
XFILLER_0_58_362 VGND VGND VPWR VPWR sky130_fd_sc_hd__fill_2
X_6723_ _2059_ _2061_ VGND VGND VPWR VPWR _2161_ sky130_fd_sc_hd__or2_1
XFILLER_0_73_321 VPWR VGND VPWR VGND sky130_ef_sc_hd__decap_12
X_6654_ _3809_ _2495_ _1260_ _1162_ VGND VGND VPWR VPWR _2086_ sky130_fd_sc_hd__and4_1
XFILLER_0_46_557 VPWR VGND VPWR VGND sky130_ef_sc_hd__decap_12
X_3866_ _0257_ _0246_ VGND VGND VPWR VPWR _0290_ sky130_fd_sc_hd__and2b_1
XFILLER_0_61_527 VGND VGND VPWR VPWR sky130_fd_sc_hd__decap_8
XFILLER_0_61_505 VGND VGND VPWR VPWR sky130_fd_sc_hd__decap_4
XFILLER_0_6_643 VGND VGND VPWR VPWR sky130_fd_sc_hd__fill_1
X_5605_ _0937_ _0938_ _0746_ VGND VGND VPWR VPWR _0940_ sky130_fd_sc_hd__a21oi_2
X_6585_ _3287_ _3331_ net48 net47 VGND VGND VPWR VPWR _2010_ sky130_fd_sc_hd__and4_1
XFILLER_0_103_128 VGND VGND VPWR VPWR sky130_fd_sc_hd__fill_1
X_5536_ _0861_ _0862_ _0863_ VGND VGND VPWR VPWR _0864_ sky130_fd_sc_hd__nand3b_1
XFILLER_0_78_60 VGND VGND VPWR VPWR sky130_fd_sc_hd__fill_2
X_5467_ _0787_ _0788_ VGND VGND VPWR VPWR _0789_ sky130_fd_sc_hd__nor2_1
X_7206_ _0322_ _0311_ VGND VGND VPWR VPWR _2689_ sky130_fd_sc_hd__nand2_1
X_4418_ _3494_ _3526_ VGND VGND VPWR VPWR _3527_ sky130_fd_sc_hd__xor2_2
X_5398_ _3265_ _0713_ VGND VGND VPWR VPWR _0714_ sky130_fd_sc_hd__xnor2_1
XTAP_TAPCELL_ROW_6_303 VGND VPWR sky130_fd_sc_hd__tapvpwrvgnd_1
X_4349_ _3452_ _3453_ _3456_ _3459_ _3338_ _3394_ VGND VGND VPWR VPWR _3460_ sky130_fd_sc_hd__mux4_1
X_7137_ _2405_ _2404_ VGND VGND VPWR VPWR _2614_ sky130_fd_sc_hd__and2b_1
X_7068_ _2047_ _1424_ _1971_ _2189_ VGND VGND VPWR VPWR _2538_ sky130_fd_sc_hd__o2bb2a_1
X_6019_ _1267_ _1268_ _1333_ _1332_ VGND VGND VPWR VPWR _1392_ sky130_fd_sc_hd__or4bb_4
XFILLER_0_96_402 VGND VGND VPWR VPWR sky130_fd_sc_hd__decap_3
XFILLER_0_49_384 VGND VGND VPWR VPWR sky130_fd_sc_hd__decap_8
XFILLER_0_9_481 VPWR VGND VPWR VGND sky130_ef_sc_hd__decap_12
XFILLER_0_107_478 VGND VGND VPWR VPWR sky130_fd_sc_hd__fill_1
XFILLER_0_91_173 VGND VGND VPWR VPWR sky130_fd_sc_hd__fill_1
XFILLER_0_17_281 VPWR VGND VPWR VGND sky130_ef_sc_hd__decap_12
XFILLER_0_24_229 VGND VGND VPWR VPWR sky130_fd_sc_hd__decap_8
XFILLER_0_32_240 VPWR VGND VPWR VGND sky130_ef_sc_hd__decap_12
XFILLER_0_60_571 VPWR VGND VPWR VGND sky130_ef_sc_hd__decap_12
XFILLER_0_99_262 VGND VGND VPWR VPWR sky130_fd_sc_hd__decap_6
XFILLER_0_90_39 VGND VGND VPWR VPWR sky130_fd_sc_hd__fill_2
XFILLER_0_67_181 VGND VGND VPWR VPWR sky130_fd_sc_hd__fill_2
XFILLER_0_99_15 VPWR VGND VPWR VGND sky130_ef_sc_hd__decap_12
XFILLER_0_43_505 VPWR VGND VPWR VGND sky130_ef_sc_hd__decap_12
XFILLER_0_82_173 VPWR VGND VPWR VGND sky130_ef_sc_hd__decap_12
XFILLER_0_3_602 VPWR VGND VPWR VGND sky130_ef_sc_hd__decap_12
XTAP_TAPCELL_ROW_11_360 VGND VPWR sky130_fd_sc_hd__tapvpwrvgnd_1
X_6370_ _1773_ _1775_ VGND VGND VPWR VPWR _1776_ sky130_fd_sc_hd__nor2_1
X_5321_ _0525_ _0533_ VGND VGND VPWR VPWR _0630_ sky130_fd_sc_hd__and2_1
XFILLER_0_11_446 VGND VGND VPWR VPWR sky130_fd_sc_hd__fill_2
X_5252_ _0550_ _0554_ VGND VGND VPWR VPWR _0555_ sky130_fd_sc_hd__xor2_1
X_4203_ _3271_ _3305_ _1872_ _1894_ _3309_ _3314_ VGND VGND VPWR VPWR _3315_ sky130_fd_sc_hd__mux4_1
X_5183_ _0477_ _0478_ _0455_ VGND VGND VPWR VPWR _0480_ sky130_fd_sc_hd__a21oi_1
XFILLER_0_48_63 VPWR VGND VPWR VGND sky130_ef_sc_hd__decap_12
XFILLER_0_48_85 VGND VGND VPWR VPWR sky130_fd_sc_hd__decap_6
X_4134_ _3054_ _3108_ _3141_ _3174_ _3207_ VGND VGND VPWR VPWR _3218_ sky130_fd_sc_hd__a2111oi_1
XFILLER_0_64_62 VPWR VGND VPWR VGND sky130_ef_sc_hd__decap_12
X_4065_ _2441_ _2452_ VGND VGND VPWR VPWR _2463_ sky130_fd_sc_hd__nand2_4
XFILLER_0_78_457 VGND VGND VPWR VPWR sky130_fd_sc_hd__decap_8
XTAP_TAPCELL_ROW_19_460 VGND VPWR sky130_fd_sc_hd__tapvpwrvgnd_1
XTAP_TAPCELL_ROW_47_780 VGND VPWR sky130_fd_sc_hd__tapvpwrvgnd_1
XFILLER_0_80_50 VGND VGND VPWR VPWR sky130_fd_sc_hd__decap_4
XFILLER_0_80_61 VGND VGND VPWR VPWR sky130_fd_sc_hd__decap_3
X_4967_ _2966_ _1643_ _0018_ _2857_ VGND VGND VPWR VPWR _0244_ sky130_fd_sc_hd__a22oi_2
XFILLER_0_46_321 VGND VGND VPWR VPWR sky130_fd_sc_hd__decap_6
XFILLER_0_46_332 VPWR VGND VPWR VGND sky130_ef_sc_hd__decap_12
X_7686_ _1096_ _3211_ _3214_ VGND VGND VPWR VPWR _3215_ sky130_fd_sc_hd__a21bo_1
X_6706_ _0562_ _2142_ VGND VGND VPWR VPWR _2143_ sky130_fd_sc_hd__xor2_1
X_3918_ net14 VGND VGND VPWR VPWR _0856_ sky130_fd_sc_hd__clkbuf_4
X_4898_ _0166_ _0167_ _0074_ VGND VGND VPWR VPWR _0169_ sky130_fd_sc_hd__o21ai_1
XFILLER_0_46_365 VGND VGND VPWR VPWR sky130_fd_sc_hd__decap_4
XFILLER_0_46_376 VGND VGND VPWR VPWR sky130_fd_sc_hd__decap_6
X_3849_ _0094_ VGND VGND VPWR VPWR _0105_ sky130_fd_sc_hd__buf_2
XFILLER_0_61_335 VGND VGND VPWR VPWR sky130_fd_sc_hd__fill_1
X_6637_ _2064_ _2065_ _2066_ VGND VGND VPWR VPWR _2067_ sky130_fd_sc_hd__nand3_1
X_6568_ _0595_ _1990_ _1991_ VGND VGND VPWR VPWR _1992_ sky130_fd_sc_hd__o21a_1
X_5519_ _0747_ _3751_ net117 _0736_ VGND VGND VPWR VPWR _0847_ sky130_fd_sc_hd__a2bb2o_1
XFILLER_0_14_251 VGND VGND VPWR VPWR sky130_fd_sc_hd__fill_1
XFILLER_0_100_610 VPWR VGND VPWR VGND sky130_ef_sc_hd__decap_12
X_6499_ _1766_ _1767_ _1765_ VGND VGND VPWR VPWR _1917_ sky130_fd_sc_hd__o21bai_1
XFILLER_0_96_265 VGND VGND VPWR VPWR sky130_fd_sc_hd__decap_6
XFILLER_0_65_641 VGND VGND VPWR VPWR sky130_fd_sc_hd__decap_3
XPHY_EDGE_ROW_7_Left_117 VGND VGND VPWR VPWR sky130_fd_sc_hd__decap_3
XFILLER_0_25_505 VGND VGND VPWR VPWR sky130_fd_sc_hd__decap_6
XFILLER_0_25_538 VPWR VGND VPWR VGND sky130_ef_sc_hd__decap_12
XTAP_TAPCELL_ROW_77_1118 VGND VPWR sky130_fd_sc_hd__tapvpwrvgnd_1
XFILLER_0_100_15 VPWR VGND VPWR VGND sky130_ef_sc_hd__decap_12
XFILLER_0_52_379 VPWR VGND VPWR VGND sky130_ef_sc_hd__decap_12
XFILLER_0_103_470 VGND VGND VPWR VPWR sky130_fd_sc_hd__decap_3
XFILLER_0_33_593 VGND VGND VPWR VPWR sky130_fd_sc_hd__fill_1
XFILLER_0_109_57 VPWR VGND VPWR VGND sky130_ef_sc_hd__decap_12
XFILLER_0_18_33 VGND VGND VPWR VPWR sky130_fd_sc_hd__fill_1
XTAP_TAPCELL_ROW_88_1247 VGND VPWR sky130_fd_sc_hd__tapvpwrvgnd_1
X_5870_ _3376_ _0376_ _1094_ _1348_ _1229_ VGND VGND VPWR VPWR _1230_ sky130_fd_sc_hd__o221a_1
XFILLER_0_75_405 VPWR VGND VPWR VGND sky130_ef_sc_hd__decap_12
X_4821_ _1763_ _1686_ VGND VGND VPWR VPWR _0086_ sky130_fd_sc_hd__or2_1
XFILLER_0_34_65 VGND VGND VPWR VPWR sky130_fd_sc_hd__decap_4
XFILLER_0_75_449 VPWR VGND VPWR VGND sky130_ef_sc_hd__decap_12
X_4752_ _3714_ _0012_ _3482_ VGND VGND VPWR VPWR _0013_ sky130_fd_sc_hd__mux2_1
XFILLER_0_71_600 VPWR VGND VPWR VGND sky130_ef_sc_hd__decap_12
X_7540_ _2876_ _2854_ _2855_ _3053_ _0977_ VGND VGND VPWR VPWR _3056_ sky130_fd_sc_hd__o41a_1
XFILLER_0_28_365 VGND VGND VPWR VPWR sky130_fd_sc_hd__fill_2
XFILLER_0_70_110 VGND VGND VPWR VPWR sky130_fd_sc_hd__fill_2
X_7471_ _2971_ _2784_ _2979_ VGND VGND VPWR VPWR _2980_ sky130_fd_sc_hd__o21a_1
X_4683_ _3689_ _3698_ _3697_ VGND VGND VPWR VPWR _3788_ sky130_fd_sc_hd__a21bo_1
XFILLER_0_16_549 VGND VGND VPWR VPWR sky130_fd_sc_hd__fill_1
XFILLER_0_43_335 VGND VGND VPWR VPWR sky130_fd_sc_hd__fill_1
XFILLER_0_50_75 VGND VGND VPWR VPWR sky130_fd_sc_hd__decap_8
XTAP_TAPCELL_ROW_99_1376 VGND VPWR sky130_fd_sc_hd__tapvpwrvgnd_1
X_6422_ _1721_ _1723_ VGND VGND VPWR VPWR _1832_ sky130_fd_sc_hd__or2_1
XFILLER_0_50_97 VGND VGND VPWR VPWR sky130_fd_sc_hd__fill_1
X_6353_ _2025_ net61 VGND VGND VPWR VPWR _1757_ sky130_fd_sc_hd__nand2_1
XFILLER_0_3_487 VPWR VGND VPWR VGND sky130_ef_sc_hd__decap_12
X_5304_ net118 _0611_ VGND VGND VPWR VPWR _0612_ sky130_fd_sc_hd__nand2_1
XFILLER_0_59_95 VGND VGND VPWR VPWR sky130_fd_sc_hd__decap_3
X_6284_ _1562_ _1564_ _1679_ VGND VGND VPWR VPWR _1681_ sky130_fd_sc_hd__or3_1
XFILLER_0_11_287 VGND VGND VPWR VPWR sky130_fd_sc_hd__decap_4
X_5235_ _0519_ _0520_ _0534_ VGND VGND VPWR VPWR _0536_ sky130_fd_sc_hd__nand3_1
X_5166_ _0456_ _0460_ VGND VGND VPWR VPWR _0461_ sky130_fd_sc_hd__xnor2_1
X_5097_ _3370_ VGND VGND VPWR VPWR _0386_ sky130_fd_sc_hd__clkbuf_4
X_4117_ _3021_ VGND VGND VPWR VPWR _3032_ sky130_fd_sc_hd__buf_4
X_4048_ _1337_ _2255_ _2266_ VGND VGND VPWR VPWR _2277_ sky130_fd_sc_hd__or3b_1
XTAP_TAPCELL_ROW_108_1483 VGND VPWR sky130_fd_sc_hd__tapvpwrvgnd_1
XFILLER_0_91_60 VPWR VGND VPWR VGND sky130_ef_sc_hd__decap_12
XFILLER_0_93_213 VGND VGND VPWR VPWR sky130_fd_sc_hd__decap_4
XFILLER_0_91_93 VGND VGND VPWR VPWR sky130_fd_sc_hd__decap_6
XFILLER_0_78_265 VPWR VGND VPWR VGND sky130_ef_sc_hd__decap_12
X_5999_ _1369_ _3602_ _0011_ VGND VGND VPWR VPWR _1371_ sky130_fd_sc_hd__a21o_1
XFILLER_0_46_151 VGND VGND VPWR VPWR sky130_fd_sc_hd__decap_3
XFILLER_0_46_184 VGND VGND VPWR VPWR sky130_fd_sc_hd__decap_6
X_7669_ _3194_ _3195_ VGND VGND VPWR VPWR _3197_ sky130_fd_sc_hd__xnor2_1
XTAP_TAPCELL_ROW_22_488 VGND VPWR sky130_fd_sc_hd__tapvpwrvgnd_1
XFILLER_0_34_346 VPWR VGND VPWR VGND sky130_ef_sc_hd__decap_12
XFILLER_0_104_245 VGND VGND VPWR VPWR sky130_fd_sc_hd__decap_6
XPHY_EDGE_ROW_89_Left_199 VGND VGND VPWR VPWR sky130_fd_sc_hd__decap_3
XFILLER_0_100_440 VGND VGND VPWR VPWR sky130_fd_sc_hd__decap_8
XTAP_TAPCELL_ROW_72_1059 VGND VPWR sky130_fd_sc_hd__tapvpwrvgnd_1
XFILLER_0_97_530 VPWR VGND VPWR VGND sky130_ef_sc_hd__decap_12
XTAP_TAPCELL_ROW_83_1188 VGND VPWR sky130_fd_sc_hd__tapvpwrvgnd_1
XFILLER_0_57_449 VPWR VGND VPWR VGND sky130_ef_sc_hd__decap_12
XFILLER_0_72_419 VGND VGND VPWR VPWR sky130_fd_sc_hd__fill_1
XFILLER_0_108_540 VPWR VGND VPWR VGND sky130_ef_sc_hd__decap_12
XFILLER_0_65_471 VGND VGND VPWR VPWR sky130_fd_sc_hd__decap_4
Xmax_cap117 _3362_ VGND VGND VPWR VPWR net117 sky130_fd_sc_hd__buf_2
XFILLER_0_20_56 VGND VGND VPWR VPWR sky130_fd_sc_hd__decap_6
Xmax_cap106 _2284_ VGND VGND VPWR VPWR net106 sky130_fd_sc_hd__clkbuf_2
XFILLER_0_40_305 VGND VGND VPWR VPWR sky130_fd_sc_hd__decap_3
XFILLER_0_40_316 VGND VGND VPWR VPWR sky130_fd_sc_hd__decap_4
XFILLER_0_40_327 VPWR VGND VPWR VGND sky130_ef_sc_hd__decap_12
XFILLER_0_20_89 VPWR VGND VPWR VGND sky130_ef_sc_hd__decap_12
XFILLER_0_96_27 VGND VGND VPWR VPWR sky130_fd_sc_hd__fill_1
XFILLER_0_0_457 VGND VGND VPWR VPWR sky130_fd_sc_hd__fill_1
XFILLER_0_21_585 VPWR VGND VPWR VGND sky130_ef_sc_hd__decap_12
XFILLER_0_29_43 VPWR VGND VPWR VGND sky130_ef_sc_hd__decap_12
X_5020_ _0278_ _0299_ _0301_ VGND VGND VPWR VPWR _0302_ sky130_fd_sc_hd__and3_1
X_6971_ _2389_ _2390_ _2429_ _2431_ VGND VGND VPWR VPWR _2433_ sky130_fd_sc_hd__o22ai_2
X_5922_ _3275_ _0095_ VGND VGND VPWR VPWR _1286_ sky130_fd_sc_hd__nor2_1
XFILLER_0_29_641 VGND VGND VPWR VPWR sky130_fd_sc_hd__decap_8
X_5853_ _1210_ _1103_ VGND VGND VPWR VPWR _1211_ sky130_fd_sc_hd__xor2_2
XFILLER_0_90_205 VGND VGND VPWR VPWR sky130_fd_sc_hd__fill_1
XFILLER_0_75_268 VPWR VGND VPWR VGND sky130_ef_sc_hd__decap_12
X_5784_ _1132_ _1133_ _1111_ VGND VGND VPWR VPWR _1135_ sky130_fd_sc_hd__o21a_1
X_4804_ _0046_ _0065_ _0066_ VGND VGND VPWR VPWR _0067_ sky130_fd_sc_hd__nand3_2
XFILLER_0_90_227 VGND VGND VPWR VPWR sky130_fd_sc_hd__decap_4
X_7523_ _2827_ _2829_ _3035_ VGND VGND VPWR VPWR _3037_ sky130_fd_sc_hd__nor3_1
X_4735_ _3836_ _3837_ _3768_ VGND VGND VPWR VPWR _3839_ sky130_fd_sc_hd__o21ba_1
XFILLER_0_44_633 VGND VGND VPWR VPWR sky130_fd_sc_hd__fill_1
XFILLER_0_71_474 VGND VGND VPWR VPWR sky130_fd_sc_hd__decap_4
X_7454_ _1850_ _1031_ VGND VGND VPWR VPWR _2961_ sky130_fd_sc_hd__nand2_1
XFILLER_0_16_379 VGND VGND VPWR VPWR sky130_fd_sc_hd__fill_1
XFILLER_0_43_165 VGND VGND VPWR VPWR sky130_fd_sc_hd__decap_3
X_4666_ _3163_ _2692_ VGND VGND VPWR VPWR _3771_ sky130_fd_sc_hd__nand2_1
X_7385_ net20 _2883_ _2884_ VGND VGND VPWR VPWR _2885_ sky130_fd_sc_hd__a21bo_1
X_6405_ _0976_ _2321_ _1668_ _1214_ VGND VGND VPWR VPWR _1814_ sky130_fd_sc_hd__o31a_1
X_4597_ _3699_ _3700_ _3701_ VGND VGND VPWR VPWR _3703_ sky130_fd_sc_hd__a21o_1
XFILLER_0_24_390 VPWR VGND VPWR VGND sky130_ef_sc_hd__decap_12
XFILLER_0_101_237 VGND VGND VPWR VPWR sky130_fd_sc_hd__fill_1
XFILLER_0_12_574 VPWR VGND VPWR VGND sky130_ef_sc_hd__decap_12
XFILLER_0_3_273 VGND VGND VPWR VPWR sky130_fd_sc_hd__decap_6
X_6336_ _1735_ _1736_ _1737_ VGND VGND VPWR VPWR _1738_ sky130_fd_sc_hd__or3_1
X_6267_ _1661_ _1662_ VGND VGND VPWR VPWR _1663_ sky130_fd_sc_hd__nand2_1
X_6198_ _1568_ _1569_ _1585_ _1586_ VGND VGND VPWR VPWR _1587_ sky130_fd_sc_hd__o211a_1
X_5218_ _0515_ _0516_ VGND VGND VPWR VPWR _0517_ sky130_fd_sc_hd__nand2_1
X_5149_ _0426_ _0427_ _0440_ VGND VGND VPWR VPWR _0443_ sky130_fd_sc_hd__nor3_1
XFILLER_0_79_541 VGND VGND VPWR VPWR sky130_fd_sc_hd__fill_1
XFILLER_0_79_574 VGND VGND VPWR VPWR sky130_fd_sc_hd__decap_3
XTAP_TAPCELL_ROW_55_867 VGND VPWR sky130_fd_sc_hd__tapvpwrvgnd_1
XTAP_TAPCELL_ROW_27_547 VGND VPWR sky130_fd_sc_hd__tapvpwrvgnd_1
XFILLER_0_39_438 VGND VGND VPWR VPWR sky130_fd_sc_hd__decap_8
XFILLER_0_39_449 VPWR VGND VPWR VGND sky130_ef_sc_hd__decap_12
XFILLER_0_109_337 VPWR VGND VPWR VGND sky130_ef_sc_hd__decap_12
XFILLER_0_66_268 VGND VGND VPWR VPWR sky130_fd_sc_hd__decap_8
XFILLER_0_81_216 VGND VGND VPWR VPWR sky130_fd_sc_hd__decap_8
XFILLER_0_19_151 VGND VGND VPWR VPWR sky130_fd_sc_hd__fill_1
XFILLER_0_62_441 VPWR VGND VPWR VGND sky130_ef_sc_hd__decap_12
XFILLER_0_19_195 VGND VGND VPWR VPWR sky130_fd_sc_hd__fill_1
XFILLER_0_62_474 VGND VGND VPWR VPWR sky130_fd_sc_hd__fill_2
XFILLER_0_22_305 VGND VGND VPWR VPWR sky130_fd_sc_hd__decap_3
XFILLER_0_105_576 VPWR VGND VPWR VGND sky130_ef_sc_hd__decap_12
XPHY_EDGE_ROW_97_Left_207 VGND VGND VPWR VPWR sky130_fd_sc_hd__decap_3
XFILLER_0_15_390 VGND VGND VPWR VPWR sky130_fd_sc_hd__fill_2
XFILLER_0_89_316 VGND VGND VPWR VPWR sky130_fd_sc_hd__decap_3
XFILLER_0_82_29 VPWR VGND VPWR VGND sky130_ef_sc_hd__decap_12
XFILLER_0_82_18 VGND VGND VPWR VPWR sky130_fd_sc_hd__decap_8
XTAP_TAPCELL_ROW_85_1217 VGND VPWR sky130_fd_sc_hd__tapvpwrvgnd_1
XFILLER_0_85_500 VGND VGND VPWR VPWR sky130_fd_sc_hd__decap_4
XFILLER_0_97_393 VGND VGND VPWR VPWR sky130_fd_sc_hd__decap_4
XFILLER_0_85_544 VGND VGND VPWR VPWR sky130_fd_sc_hd__decap_8
XFILLER_0_57_279 VGND VGND VPWR VPWR sky130_fd_sc_hd__fill_1
XFILLER_0_5_505 VPWR VGND VPWR VGND sky130_ef_sc_hd__decap_12
XFILLER_0_31_11 VGND VGND VPWR VPWR sky130_fd_sc_hd__fill_2
XFILLER_0_31_55 VGND VGND VPWR VPWR sky130_fd_sc_hd__fill_1
XFILLER_0_53_430 VPWR VGND VPWR VGND sky130_ef_sc_hd__decap_12
XTAP_TAPCELL_ROW_96_1335 VGND VPWR sky130_fd_sc_hd__tapvpwrvgnd_1
X_4520_ _3625_ _3626_ VGND VGND VPWR VPWR _3627_ sky130_fd_sc_hd__xor2_2
XFILLER_0_103_3 VPWR VGND VPWR VGND sky130_ef_sc_hd__decap_12
XTAP_TAPCELL_ROW_96_1346 VGND VPWR sky130_fd_sc_hd__tapvpwrvgnd_1
X_4451_ _2846_ _2944_ _3408_ VGND VGND VPWR VPWR _3560_ sky130_fd_sc_hd__a21oi_1
XFILLER_0_0_210 VGND VGND VPWR VPWR sky130_fd_sc_hd__decap_6
X_7170_ _2462_ _2465_ VGND VGND VPWR VPWR _2651_ sky130_fd_sc_hd__nor2_1
X_4382_ _3491_ VGND VGND VPWR VPWR _3492_ sky130_fd_sc_hd__clkbuf_4
X_6121_ _1042_ _1380_ _1140_ VGND VGND VPWR VPWR _1504_ sky130_fd_sc_hd__a21oi_1
XFILLER_0_21_393 VPWR VGND VPWR VGND sky130_ef_sc_hd__decap_12
XPHY_EDGE_ROW_7_Right_7 VGND VGND VPWR VPWR sky130_fd_sc_hd__decap_3
X_6052_ _1285_ _1287_ VGND VGND VPWR VPWR _1428_ sky130_fd_sc_hd__and2_1
X_5003_ _3345_ _3305_ _3450_ VGND VGND VPWR VPWR _0284_ sky130_fd_sc_hd__a21bo_1
XFILLER_0_56_85 VGND VGND VPWR VPWR sky130_fd_sc_hd__decap_6
XFILLER_0_95_319 VPWR VGND VPWR VGND sky130_ef_sc_hd__decap_12
X_6954_ _2225_ _2227_ _2224_ VGND VGND VPWR VPWR _2414_ sky130_fd_sc_hd__o21ba_1
XTAP_TAPCELL_ROW_105_1442 VGND VPWR sky130_fd_sc_hd__tapvpwrvgnd_1
XFILLER_0_76_533 VPWR VGND VPWR VGND sky130_ef_sc_hd__decap_12
XTAP_TAPCELL_ROW_24_517 VGND VPWR sky130_fd_sc_hd__tapvpwrvgnd_1
X_5905_ _1127_ _1130_ _1265_ _1266_ VGND VGND VPWR VPWR _1267_ sky130_fd_sc_hd__a211oi_2
XFILLER_0_91_503 VGND VGND VPWR VPWR sky130_fd_sc_hd__fill_1
X_6885_ net149 net19 _0922_ _2627_ VGND VGND VPWR VPWR _2338_ sky130_fd_sc_hd__a22oi_1
XTAP_TAPCELL_ROW_52_837 VGND VPWR sky130_fd_sc_hd__tapvpwrvgnd_1
XFILLER_0_63_216 VGND VGND VPWR VPWR sky130_fd_sc_hd__decap_8
XFILLER_0_8_332 VGND VGND VPWR VPWR sky130_fd_sc_hd__decap_3
X_5836_ _1054_ _1159_ net125 _1191_ VGND VGND VPWR VPWR _1192_ sky130_fd_sc_hd__a211oi_4
XFILLER_0_106_329 VPWR VGND VPWR VGND sky130_ef_sc_hd__decap_12
XFILLER_0_106_307 VGND VGND VPWR VPWR sky130_fd_sc_hd__fill_1
XFILLER_0_63_249 VPWR VGND VPWR VGND sky130_ef_sc_hd__decap_12
XFILLER_0_8_365 VGND VGND VPWR VPWR sky130_fd_sc_hd__fill_1
X_5767_ _0985_ _0993_ VGND VGND VPWR VPWR _1116_ sky130_fd_sc_hd__or2b_1
XFILLER_0_44_441 VGND VGND VPWR VPWR sky130_fd_sc_hd__decap_6
X_7506_ _3336_ _0116_ _2821_ _2820_ VGND VGND VPWR VPWR _3018_ sky130_fd_sc_hd__a31o_1
X_5698_ net42 net8 VGND VGND VPWR VPWR _1041_ sky130_fd_sc_hd__nand2_1
XFILLER_0_16_176 VPWR VGND VPWR VGND sky130_ef_sc_hd__decap_12
X_4718_ _2660_ _2966_ _2441_ _2857_ VGND VGND VPWR VPWR _3822_ sky130_fd_sc_hd__and4_1
X_4649_ _3565_ _3753_ _3340_ VGND VGND VPWR VPWR _3754_ sky130_fd_sc_hd__mux2_1
X_7437_ _2722_ _2924_ _2940_ VGND VGND VPWR VPWR _2942_ sky130_fd_sc_hd__and3_1
XFILLER_0_71_293 VPWR VGND VPWR VGND sky130_ef_sc_hd__decap_12
XFILLER_0_31_113 VGND VGND VPWR VPWR sky130_fd_sc_hd__decap_8
X_7368_ _3348_ _3387_ _3389_ _2657_ _3553_ VGND VGND VPWR VPWR _2866_ sky130_fd_sc_hd__o32a_1
XFILLER_0_102_579 VGND VGND VPWR VPWR sky130_fd_sc_hd__decap_8
XFILLER_0_102_557 VGND VGND VPWR VPWR sky130_fd_sc_hd__decap_4
XFILLER_0_12_360 VGND VGND VPWR VPWR sky130_fd_sc_hd__fill_1
X_7299_ _2788_ _2789_ _2774_ VGND VGND VPWR VPWR _2792_ sky130_fd_sc_hd__o21ai_1
X_6319_ _1716_ _1717_ _1701_ VGND VGND VPWR VPWR _1720_ sky130_fd_sc_hd__o21a_1
XTAP_TAPCELL_ROW_4_286 VGND VPWR sky130_fd_sc_hd__tapvpwrvgnd_1
XFILLER_0_79_393 VPWR VGND VPWR VGND sky130_ef_sc_hd__decap_12
XFILLER_0_94_363 VGND VGND VPWR VPWR sky130_fd_sc_hd__fill_1
XFILLER_0_39_268 VPWR VGND VPWR VGND sky130_ef_sc_hd__decap_12
XFILLER_0_94_374 VGND VGND VPWR VPWR sky130_fd_sc_hd__fill_1
XTAP_TAPCELL_ROW_80_1158 VGND VPWR sky130_fd_sc_hd__tapvpwrvgnd_1
XFILLER_0_54_205 VGND VGND VPWR VPWR sky130_fd_sc_hd__fill_2
XFILLER_0_50_477 VPWR VGND VPWR VGND sky130_ef_sc_hd__decap_12
XFILLER_0_101_590 VPWR VGND VPWR VGND sky130_ef_sc_hd__decap_12
XTAP_TAPCELL_ROW_91_1287 VGND VPWR sky130_fd_sc_hd__tapvpwrvgnd_1
XFILLER_0_89_113 VGND VGND VPWR VPWR sky130_fd_sc_hd__decap_6
XFILLER_0_58_533 VPWR VGND VPWR VGND sky130_ef_sc_hd__decap_12
X_3951_ _1206_ VGND VGND VPWR VPWR _1217_ sky130_fd_sc_hd__buf_2
XFILLER_0_58_566 VPWR VGND VPWR VGND sky130_ef_sc_hd__decap_12
XFILLER_0_18_408 VPWR VGND VPWR VGND sky130_ef_sc_hd__decap_12
X_3882_ _0050_ _0366_ VGND VGND VPWR VPWR _0464_ sky130_fd_sc_hd__or2_1
X_6670_ _2101_ _2103_ VGND VGND VPWR VPWR _2104_ sky130_fd_sc_hd__xnor2_4
X_5621_ _0846_ _0957_ VGND VGND VPWR VPWR _0958_ sky130_fd_sc_hd__nor2_1
XTAP_TAPCELL_ROW_100_1383 VGND VPWR sky130_fd_sc_hd__tapvpwrvgnd_1
XFILLER_0_5_335 VGND VGND VPWR VPWR sky130_fd_sc_hd__fill_1
X_5552_ _0785_ _0804_ _0805_ VGND VGND VPWR VPWR _0882_ sky130_fd_sc_hd__nand3_2
XFILLER_0_14_614 VPWR VGND VPWR VGND sky130_ef_sc_hd__decap_12
X_4503_ _3350_ _3299_ VGND VGND VPWR VPWR _3611_ sky130_fd_sc_hd__nand2_1
XFILLER_0_84_7 VPWR VGND VPWR VGND sky130_ef_sc_hd__decap_12
X_5483_ _0804_ _0805_ _0785_ VGND VGND VPWR VPWR _0807_ sky130_fd_sc_hd__a21oi_2
X_7222_ _3389_ _2706_ VGND VGND VPWR VPWR _2707_ sky130_fd_sc_hd__xnor2_1
X_4434_ _2900_ _3321_ _3504_ VGND VGND VPWR VPWR _3543_ sky130_fd_sc_hd__o21ai_1
X_4365_ _3371_ _3472_ _3474_ VGND VGND VPWR VPWR _3475_ sky130_fd_sc_hd__o21ai_2
XFILLER_0_6_65 VPWR VGND VPWR VGND sky130_ef_sc_hd__decap_12
X_7153_ _2630_ _2631_ VGND VGND VPWR VPWR _2632_ sky130_fd_sc_hd__nor2_1
X_7084_ _2534_ _2535_ _2554_ _2555_ VGND VGND VPWR VPWR _2556_ sky130_fd_sc_hd__o211ai_2
X_6104_ _1483_ _1482_ _1323_ _1451_ VGND VGND VPWR VPWR _1485_ sky130_fd_sc_hd__o211a_1
X_4296_ _3391_ VGND VGND VPWR VPWR _3407_ sky130_fd_sc_hd__clkbuf_4
X_6035_ _1275_ _1278_ _1276_ VGND VGND VPWR VPWR _1409_ sky130_fd_sc_hd__o21ba_1
Xrebuffer21 net141 VGND VGND VPWR VPWR net139 sky130_fd_sc_hd__clkbuf_1
Xrebuffer10 _0701_ VGND VGND VPWR VPWR net128 sky130_fd_sc_hd__dlygate4sd1_1
XFILLER_0_96_606 VGND VGND VPWR VPWR sky130_fd_sc_hd__decap_3
XFILLER_0_83_94 VGND VGND VPWR VPWR sky130_fd_sc_hd__decap_8
XTAP_TAPCELL_ROW_1_245 VGND VPWR sky130_fd_sc_hd__tapvpwrvgnd_1
XTAP_TAPCELL_ROW_65_984 VGND VPWR sky130_fd_sc_hd__tapvpwrvgnd_1
XTAP_TAPCELL_ROW_37_664 VGND VPWR sky130_fd_sc_hd__tapvpwrvgnd_1
XFILLER_0_95_149 VGND VGND VPWR VPWR sky130_fd_sc_hd__fill_1
X_6937_ _2485_ _2681_ _0867_ _1075_ VGND VGND VPWR VPWR _2395_ sky130_fd_sc_hd__and4_1
X_6868_ _2315_ _2319_ VGND VGND VPWR VPWR _2320_ sky130_fd_sc_hd__nor2_1
XFILLER_0_76_363 VGND VGND VPWR VPWR sky130_fd_sc_hd__fill_1
XFILLER_0_9_641 VGND VGND VPWR VPWR sky130_fd_sc_hd__decap_8
XFILLER_0_64_569 VPWR VGND VPWR VGND sky130_ef_sc_hd__decap_12
X_5819_ _1171_ _1172_ VGND VGND VPWR VPWR _1174_ sky130_fd_sc_hd__nor2_1
XFILLER_0_107_649 VGND VGND VPWR VPWR sky130_fd_sc_hd__decap_3
XFILLER_0_91_388 VGND VGND VPWR VPWR sky130_fd_sc_hd__decap_4
XFILLER_0_32_400 VPWR VGND VPWR VGND sky130_ef_sc_hd__decap_12
X_6799_ _2096_ _2118_ _2242_ _2243_ VGND VGND VPWR VPWR _2245_ sky130_fd_sc_hd__o211a_4
XFILLER_0_32_455 VGND VGND VPWR VPWR sky130_fd_sc_hd__fill_1
XFILLER_0_102_321 VGND VGND VPWR VPWR sky130_fd_sc_hd__decap_8
XFILLER_0_32_477 VGND VGND VPWR VPWR sky130_fd_sc_hd__decap_3
XFILLER_0_102_365 VPWR VGND VPWR VGND sky130_ef_sc_hd__decap_12
XTAP_TAPCELL_ROW_9_345 VGND VPWR sky130_fd_sc_hd__tapvpwrvgnd_1
XFILLER_0_87_617 VPWR VGND VPWR VGND sky130_ef_sc_hd__decap_12
XFILLER_0_86_138 VGND VGND VPWR VPWR sky130_fd_sc_hd__fill_2
XFILLER_0_86_127 VGND VGND VPWR VPWR sky130_fd_sc_hd__fill_2
XFILLER_0_67_341 VGND VGND VPWR VPWR sky130_fd_sc_hd__fill_1
XFILLER_0_103_15 VPWR VGND VPWR VGND sky130_ef_sc_hd__decap_12
XFILLER_0_94_171 VGND VGND VPWR VPWR sky130_fd_sc_hd__fill_1
XFILLER_0_55_503 VGND VGND VPWR VPWR sky130_fd_sc_hd__fill_1
XFILLER_0_27_205 VPWR VGND VPWR VGND sky130_ef_sc_hd__decap_12
XFILLER_0_82_333 VPWR VGND VPWR VGND sky130_ef_sc_hd__decap_12
XFILLER_0_67_396 VGND VGND VPWR VPWR sky130_fd_sc_hd__decap_6
XFILLER_0_27_249 VPWR VGND VPWR VGND sky130_ef_sc_hd__decap_12
XFILLER_0_82_377 VPWR VGND VPWR VGND sky130_ef_sc_hd__decap_12
XFILLER_0_63_591 VGND VGND VPWR VPWR sky130_fd_sc_hd__decap_8
XTAP_TAPCELL_ROW_93_1305 VGND VPWR sky130_fd_sc_hd__tapvpwrvgnd_1
XFILLER_0_23_444 VGND VGND VPWR VPWR sky130_fd_sc_hd__decap_4
XFILLER_0_50_230 VGND VGND VPWR VPWR sky130_fd_sc_hd__decap_8
XFILLER_0_11_617 VPWR VGND VPWR VGND sky130_ef_sc_hd__decap_12
XFILLER_0_10_116 VPWR VGND VPWR VGND sky130_ef_sc_hd__decap_12
X_4150_ _3260_ _3261_ VGND VGND VPWR VPWR _3262_ sky130_fd_sc_hd__nand2_2
Xoutput90 net90 VGND VGND VPWR VPWR result[29] sky130_fd_sc_hd__clkbuf_4
X_4081_ _2627_ VGND VGND VPWR VPWR _2638_ sky130_fd_sc_hd__buf_4
XTAP_TAPCELL_ROW_102_1412 VGND VPWR sky130_fd_sc_hd__tapvpwrvgnd_1
XFILLER_0_58_341 VPWR VGND VPWR VGND sky130_ef_sc_hd__decap_12
XTAP_TAPCELL_ROW_34_623 VGND VPWR sky130_fd_sc_hd__tapvpwrvgnd_1
X_4983_ _0259_ _0260_ _0220_ VGND VGND VPWR VPWR _0262_ sky130_fd_sc_hd__a21oi_1
XFILLER_0_53_86 VGND VGND VPWR VPWR sky130_fd_sc_hd__fill_2
XFILLER_0_73_300 VGND VGND VPWR VPWR sky130_fd_sc_hd__fill_2
XTAP_TAPCELL_ROW_62_954 VGND VPWR sky130_fd_sc_hd__tapvpwrvgnd_1
X_6722_ _1838_ _2017_ VGND VGND VPWR VPWR _2160_ sky130_fd_sc_hd__nor2_1
X_3934_ _1020_ VGND VGND VPWR VPWR _1031_ sky130_fd_sc_hd__clkbuf_4
X_3865_ _0105_ _0126_ _0235_ _0268_ VGND VGND VPWR VPWR _0279_ sky130_fd_sc_hd__o211a_1
XFILLER_0_73_333 VGND VGND VPWR VPWR sky130_fd_sc_hd__decap_3
XFILLER_0_18_227 VGND VGND VPWR VPWR sky130_fd_sc_hd__fill_1
X_6653_ _1920_ _1923_ _1921_ VGND VGND VPWR VPWR _2085_ sky130_fd_sc_hd__o21ba_1
XFILLER_0_46_569 VPWR VGND VPWR VGND sky130_ef_sc_hd__decap_12
X_5604_ _0937_ _0746_ _0938_ VGND VGND VPWR VPWR _0939_ sky130_fd_sc_hd__and3_1
X_6584_ _3328_ _0159_ net47 _3332_ VGND VGND VPWR VPWR _2009_ sky130_fd_sc_hd__a22o_1
XFILLER_0_14_444 VGND VGND VPWR VPWR sky130_fd_sc_hd__decap_3
XFILLER_0_14_455 VGND VGND VPWR VPWR sky130_fd_sc_hd__fill_1
X_5535_ net29 _1785_ _0093_ _3267_ VGND VGND VPWR VPWR _0863_ sky130_fd_sc_hd__a22o_1
XFILLER_0_41_230 VGND VGND VPWR VPWR sky130_fd_sc_hd__fill_2
X_5466_ _2616_ _1938_ _0660_ net152 VGND VGND VPWR VPWR _0788_ sky130_fd_sc_hd__a22oi_1
XFILLER_0_14_477 VGND VGND VPWR VPWR sky130_fd_sc_hd__decap_8
X_7205_ _0322_ _0311_ VGND VGND VPWR VPWR _2688_ sky130_fd_sc_hd__nor2_1
XFILLER_0_78_83 VGND VGND VPWR VPWR sky130_fd_sc_hd__fill_1
X_4417_ _3525_ _3523_ VGND VGND VPWR VPWR _3526_ sky130_fd_sc_hd__xnor2_4
XFILLER_0_41_296 VGND VGND VPWR VPWR sky130_fd_sc_hd__fill_2
X_5397_ _3262_ _0599_ _3260_ VGND VGND VPWR VPWR _0713_ sky130_fd_sc_hd__o21ai_1
XTAP_TAPCELL_ROW_6_304 VGND VPWR sky130_fd_sc_hd__tapvpwrvgnd_1
X_4348_ _3457_ _3458_ _3313_ VGND VGND VPWR VPWR _3459_ sky130_fd_sc_hd__mux2_1
X_7136_ _2437_ _2445_ VGND VGND VPWR VPWR _2613_ sky130_fd_sc_hd__nand2_1
X_4279_ _3043_ VGND VGND VPWR VPWR _3391_ sky130_fd_sc_hd__inv_2
X_7067_ _2349_ _2357_ VGND VGND VPWR VPWR _2537_ sky130_fd_sc_hd__or2b_1
XFILLER_0_94_93 VGND VGND VPWR VPWR sky130_fd_sc_hd__decap_3
X_6018_ _1388_ _1389_ VGND VGND VPWR VPWR _1390_ sky130_fd_sc_hd__and2_1
XTAP_TAPCELL_ROW_68_1020 VGND VPWR sky130_fd_sc_hd__tapvpwrvgnd_1
XFILLER_0_96_414 VGND VGND VPWR VPWR sky130_fd_sc_hd__decap_3
XFILLER_0_84_609 VPWR VGND VPWR VGND sky130_ef_sc_hd__decap_12
XFILLER_0_68_149 VGND VGND VPWR VPWR sky130_fd_sc_hd__fill_2
XFILLER_0_49_341 VGND VGND VPWR VPWR sky130_fd_sc_hd__decap_3
XFILLER_0_37_503 VGND VGND VPWR VPWR sky130_fd_sc_hd__fill_1
XFILLER_0_92_631 VPWR VGND VPWR VGND sky130_ef_sc_hd__decap_12
XFILLER_0_76_171 VGND VGND VPWR VPWR sky130_fd_sc_hd__fill_1
XFILLER_0_64_333 VPWR VGND VPWR VGND sky130_ef_sc_hd__decap_12
XFILLER_0_9_493 VGND VGND VPWR VPWR sky130_fd_sc_hd__fill_1
XFILLER_0_24_208 VGND VGND VPWR VPWR sky130_fd_sc_hd__decap_8
XFILLER_0_64_388 VPWR VGND VPWR VGND sky130_ef_sc_hd__decap_12
XFILLER_0_45_580 VGND VGND VPWR VPWR sky130_fd_sc_hd__decap_3
XFILLER_0_60_550 VGND VGND VPWR VPWR sky130_fd_sc_hd__fill_2
XFILLER_0_17_293 VPWR VGND VPWR VGND sky130_ef_sc_hd__decap_12
XFILLER_0_103_641 VGND VGND VPWR VPWR sky130_fd_sc_hd__decap_8
XFILLER_0_60_583 VGND VGND VPWR VPWR sky130_fd_sc_hd__decap_4
XFILLER_0_74_19 VGND VGND VPWR VPWR sky130_fd_sc_hd__decap_4
XFILLER_0_99_241 VPWR VGND VPWR VGND sky130_ef_sc_hd__decap_12
XFILLER_0_67_160 VGND VGND VPWR VPWR sky130_fd_sc_hd__decap_8
XFILLER_0_55_344 VGND VGND VPWR VPWR sky130_fd_sc_hd__decap_6
XFILLER_0_99_27 VPWR VGND VPWR VGND sky130_ef_sc_hd__decap_12
XFILLER_0_82_141 VGND VGND VPWR VPWR sky130_fd_sc_hd__fill_1
XFILLER_0_43_517 VGND VGND VPWR VPWR sky130_fd_sc_hd__decap_8
XFILLER_0_82_185 VGND VGND VPWR VPWR sky130_fd_sc_hd__decap_8
XTAP_TAPCELL_ROW_11_361 VGND VPWR sky130_fd_sc_hd__tapvpwrvgnd_1
XFILLER_0_3_614 VGND VGND VPWR VPWR sky130_fd_sc_hd__fill_2
Xrebuffer1 _1793_ VGND VGND VPWR VPWR net119 sky130_fd_sc_hd__clkbuf_2
XFILLER_0_11_414 VGND VGND VPWR VPWR sky130_fd_sc_hd__fill_1
X_5320_ _0532_ _0531_ VGND VGND VPWR VPWR _0629_ sky130_fd_sc_hd__and2b_1
XFILLER_0_51_572 VGND VGND VPWR VPWR sky130_fd_sc_hd__fill_1
X_5251_ _0240_ _0552_ _0553_ VGND VGND VPWR VPWR _0554_ sky130_fd_sc_hd__a21bo_1
XFILLER_0_2_157 VGND VGND VPWR VPWR sky130_fd_sc_hd__fill_1
X_4202_ _3313_ VGND VGND VPWR VPWR _3314_ sky130_fd_sc_hd__clkbuf_4
X_5182_ _0455_ _0477_ _0478_ VGND VGND VPWR VPWR _0479_ sky130_fd_sc_hd__and3_1
XFILLER_0_48_75 VGND VGND VPWR VPWR sky130_fd_sc_hd__decap_8
X_4133_ _3043_ _3196_ VGND VGND VPWR VPWR _3207_ sky130_fd_sc_hd__and2b_1
XFILLER_0_47_7 VGND VGND VPWR VPWR sky130_fd_sc_hd__fill_1
X_4064_ net59 VGND VGND VPWR VPWR _2452_ sky130_fd_sc_hd__buf_4
XFILLER_0_3_55 VGND VGND VPWR VPWR sky130_fd_sc_hd__fill_1
XFILLER_0_64_41 VGND VGND VPWR VPWR sky130_fd_sc_hd__fill_2
XFILLER_0_78_414 VGND VGND VPWR VPWR sky130_fd_sc_hd__fill_1
XFILLER_0_64_85 VGND VGND VPWR VPWR sky130_fd_sc_hd__fill_1
XFILLER_0_64_74 VGND VGND VPWR VPWR sky130_fd_sc_hd__decap_8
XTAP_TAPCELL_ROW_19_450 VGND VPWR sky130_fd_sc_hd__tapvpwrvgnd_1
XFILLER_0_66_609 VGND VGND VPWR VPWR sky130_fd_sc_hd__fill_1
XTAP_TAPCELL_ROW_47_781 VGND VPWR sky130_fd_sc_hd__tapvpwrvgnd_1
XFILLER_0_93_406 VGND VGND VPWR VPWR sky130_fd_sc_hd__fill_2
XFILLER_0_46_300 VGND VGND VPWR VPWR sky130_fd_sc_hd__fill_1
X_6705_ _1980_ _2141_ VGND VGND VPWR VPWR _2142_ sky130_fd_sc_hd__or2_1
X_4966_ _0242_ _3520_ net31 _3267_ VGND VGND VPWR VPWR _0243_ sky130_fd_sc_hd__and4_1
X_7685_ _3463_ _0376_ _0378_ _3212_ _3213_ VGND VGND VPWR VPWR _3214_ sky130_fd_sc_hd__o221a_1
X_3917_ _0824_ _0835_ VGND VGND VPWR VPWR _0846_ sky130_fd_sc_hd__nand2b_2
X_4897_ _0074_ _0166_ _0167_ VGND VGND VPWR VPWR _0168_ sky130_fd_sc_hd__nor3_2
XFILLER_0_46_344 VGND VGND VPWR VPWR sky130_fd_sc_hd__decap_8
X_3848_ net18 VGND VGND VPWR VPWR _0094_ sky130_fd_sc_hd__clkbuf_4
X_6636_ _3032_ net16 VGND VGND VPWR VPWR _2066_ sky130_fd_sc_hd__and2_1
XFILLER_0_104_438 VGND VGND VPWR VPWR sky130_fd_sc_hd__fill_2
X_6567_ _0595_ _1990_ _3651_ VGND VGND VPWR VPWR _1991_ sky130_fd_sc_hd__a21oi_1
X_5518_ _0386_ _0197_ VGND VGND VPWR VPWR _0845_ sky130_fd_sc_hd__nor2_1
XFILLER_0_89_71 VGND VGND VPWR VPWR sky130_fd_sc_hd__decap_3
XFILLER_0_14_285 VPWR VGND VPWR VGND sky130_ef_sc_hd__decap_12
X_6498_ _1911_ _1912_ _1913_ VGND VGND VPWR VPWR _1915_ sky130_fd_sc_hd__o21ai_1
XFILLER_0_100_622 VPWR VGND VPWR VGND sky130_ef_sc_hd__decap_12
X_5449_ _0766_ _0767_ _0759_ VGND VGND VPWR VPWR _0770_ sky130_fd_sc_hd__a21o_1
XTAP_TAPCELL_ROW_74_1090 VGND VPWR sky130_fd_sc_hd__tapvpwrvgnd_1
X_7119_ _2579_ _2592_ _2593_ VGND VGND VPWR VPWR _2595_ sky130_fd_sc_hd__or3_1
XFILLER_0_96_200 VGND VGND VPWR VPWR sky130_fd_sc_hd__decap_8
XFILLER_0_77_480 VPWR VGND VPWR VGND sky130_ef_sc_hd__decap_12
XFILLER_0_80_601 VPWR VGND VPWR VGND sky130_ef_sc_hd__decap_12
XFILLER_0_64_141 VGND VGND VPWR VPWR sky130_fd_sc_hd__decap_3
XFILLER_0_80_645 VGND VGND VPWR VPWR sky130_fd_sc_hd__decap_6
XFILLER_0_18_580 VGND VGND VPWR VPWR sky130_fd_sc_hd__decap_8
XTAP_TAPCELL_ROW_77_1119 VGND VPWR sky130_fd_sc_hd__tapvpwrvgnd_1
XFILLER_0_69_19 VGND VGND VPWR VPWR sky130_fd_sc_hd__decap_6
XFILLER_0_52_347 VPWR VGND VPWR VGND sky130_ef_sc_hd__decap_12
XFILLER_0_100_27 VGND VGND VPWR VPWR sky130_fd_sc_hd__fill_1
XFILLER_0_33_561 VPWR VGND VPWR VGND sky130_ef_sc_hd__decap_12
XFILLER_0_0_617 VPWR VGND VPWR VGND sky130_ef_sc_hd__decap_12
XFILLER_0_109_69 VGND VGND VPWR VPWR sky130_fd_sc_hd__decap_4
XPHY_EDGE_ROW_108_Left_218 VGND VGND VPWR VPWR sky130_fd_sc_hd__decap_3
XFILLER_0_18_67 VGND VGND VPWR VPWR sky130_fd_sc_hd__decap_4
XTAP_TAPCELL_ROW_88_1248 VGND VPWR sky130_fd_sc_hd__tapvpwrvgnd_1
XFILLER_0_34_11 VGND VGND VPWR VPWR sky130_fd_sc_hd__fill_1
XFILLER_0_75_417 VPWR VGND VPWR VGND sky130_ef_sc_hd__decap_12
X_4820_ _3492_ _0084_ VGND VGND VPWR VPWR _0085_ sky130_fd_sc_hd__nand2_1
XTAP_TAPCELL_ROW_16_420 VGND VPWR sky130_fd_sc_hd__tapvpwrvgnd_1
XTAP_TAPCELL_ROW_44_740 VGND VPWR sky130_fd_sc_hd__tapvpwrvgnd_1
XFILLER_0_47_119 VGND VGND VPWR VPWR sky130_fd_sc_hd__fill_1
X_4751_ _3271_ _3326_ _3309_ VGND VGND VPWR VPWR _0012_ sky130_fd_sc_hd__mux2_1
XFILLER_0_71_612 VGND VGND VPWR VPWR sky130_fd_sc_hd__decap_4
X_7470_ _2972_ _2978_ VGND VGND VPWR VPWR _2979_ sky130_fd_sc_hd__xor2_1
XFILLER_0_28_388 VGND VGND VPWR VPWR sky130_fd_sc_hd__decap_3
XFILLER_0_28_399 VPWR VGND VPWR VGND sky130_ef_sc_hd__decap_12
X_4682_ _3784_ _3785_ _3776_ VGND VGND VPWR VPWR _3787_ sky130_fd_sc_hd__a21o_1
XTAP_TAPCELL_ROW_99_1377 VGND VPWR sky130_fd_sc_hd__tapvpwrvgnd_1
XFILLER_0_70_144 VGND VGND VPWR VPWR sky130_fd_sc_hd__decap_3
X_6421_ _1682_ _1795_ _1797_ VGND VGND VPWR VPWR _1831_ sky130_fd_sc_hd__nor3_1
X_6352_ net59 net8 net7 net60 VGND VGND VPWR VPWR _1756_ sky130_fd_sc_hd__a22oi_1
X_5303_ _3343_ _3723_ _3536_ VGND VGND VPWR VPWR _0611_ sky130_fd_sc_hd__a21bo_1
XFILLER_0_11_244 VGND VGND VPWR VPWR sky130_fd_sc_hd__decap_6
XFILLER_0_3_499 VGND VGND VPWR VPWR sky130_fd_sc_hd__decap_4
X_6283_ _1562_ _1564_ _1679_ VGND VGND VPWR VPWR _1680_ sky130_fd_sc_hd__o21ai_1
X_5234_ _0519_ _0520_ _0534_ VGND VGND VPWR VPWR _0535_ sky130_fd_sc_hd__a21o_1
X_5165_ _0458_ _0459_ VGND VGND VPWR VPWR _0460_ sky130_fd_sc_hd__nor2_1
X_4116_ net42 VGND VGND VPWR VPWR _3021_ sky130_fd_sc_hd__buf_6
XFILLER_0_38_3 VGND VGND VPWR VPWR sky130_fd_sc_hd__decap_6
X_5096_ _0013_ _0384_ _3743_ VGND VGND VPWR VPWR _0385_ sky130_fd_sc_hd__mux2_1
X_4047_ _1009_ _2178_ VGND VGND VPWR VPWR _2266_ sky130_fd_sc_hd__nand2_1
Xclone6 net6 VGND VGND VPWR VPWR net124 sky130_fd_sc_hd__buf_2
XTAP_TAPCELL_ROW_108_1484 VGND VPWR sky130_fd_sc_hd__tapvpwrvgnd_1
XTAP_TAPCELL_ROW_108_1473 VGND VPWR sky130_fd_sc_hd__tapvpwrvgnd_1
XFILLER_0_91_72 VPWR VGND VPWR VGND sky130_ef_sc_hd__decap_12
XFILLER_0_78_277 VGND VGND VPWR VPWR sky130_fd_sc_hd__decap_6
XFILLER_0_66_406 VPWR VGND VPWR VGND sky130_ef_sc_hd__decap_12
XFILLER_0_109_519 VGND VGND VPWR VPWR sky130_fd_sc_hd__fill_2
X_5998_ _0110_ VGND VGND VPWR VPWR _1369_ sky130_fd_sc_hd__buf_2
XFILLER_0_93_225 VPWR VGND VPWR VGND sky130_ef_sc_hd__decap_12
XFILLER_0_19_311 VGND VGND VPWR VPWR sky130_fd_sc_hd__fill_1
XFILLER_0_19_322 VGND VGND VPWR VPWR sky130_fd_sc_hd__fill_1
XFILLER_0_47_631 VGND VGND VPWR VPWR sky130_fd_sc_hd__decap_4
XFILLER_0_19_344 VGND VGND VPWR VPWR sky130_fd_sc_hd__fill_1
X_4949_ _3130_ _1730_ VGND VGND VPWR VPWR _0225_ sky130_fd_sc_hd__nand2_1
X_7668_ _3030_ _3033_ VGND VGND VPWR VPWR _3195_ sky130_fd_sc_hd__nor2_1
XFILLER_0_62_612 VPWR VGND VPWR VGND sky130_ef_sc_hd__decap_12
XFILLER_0_62_645 VGND VGND VPWR VPWR sky130_fd_sc_hd__decap_6
XTAP_TAPCELL_ROW_22_489 VGND VPWR sky130_fd_sc_hd__tapvpwrvgnd_1
X_6619_ _3269_ _0791_ _2044_ _2045_ VGND VGND VPWR VPWR _2048_ sky130_fd_sc_hd__a22o_1
X_7599_ _3114_ _3115_ _3116_ _3117_ VGND VGND VPWR VPWR _3120_ sky130_fd_sc_hd__or4_1
XFILLER_0_15_561 VPWR VGND VPWR VGND sky130_ef_sc_hd__decap_12
XFILLER_0_34_369 VGND VGND VPWR VPWR sky130_fd_sc_hd__decap_6
XFILLER_0_104_279 VGND VGND VPWR VPWR sky130_fd_sc_hd__decap_8
XFILLER_0_30_531 VGND VGND VPWR VPWR sky130_fd_sc_hd__fill_1
XFILLER_0_97_542 VPWR VGND VPWR VGND sky130_ef_sc_hd__decap_12
XFILLER_0_69_222 VGND VGND VPWR VPWR sky130_fd_sc_hd__fill_2
XTAP_TAPCELL_ROW_58_898 VGND VPWR sky130_fd_sc_hd__tapvpwrvgnd_1
XFILLER_0_84_203 VGND VGND VPWR VPWR sky130_fd_sc_hd__fill_1
XFILLER_0_84_225 VGND VGND VPWR VPWR sky130_fd_sc_hd__decap_4
XTAP_TAPCELL_ROW_83_1189 VGND VPWR sky130_fd_sc_hd__tapvpwrvgnd_1
XFILLER_0_38_642 VGND VGND VPWR VPWR sky130_fd_sc_hd__fill_2
XTAP_TAPCELL_ROW_41_710 VGND VPWR sky130_fd_sc_hd__tapvpwrvgnd_1
XFILLER_0_108_552 VPWR VGND VPWR VGND sky130_ef_sc_hd__decap_12
XFILLER_0_37_163 VGND VGND VPWR VPWR sky130_fd_sc_hd__decap_4
XFILLER_0_37_185 VPWR VGND VPWR VGND sky130_ef_sc_hd__decap_12
XFILLER_0_80_475 VGND VGND VPWR VPWR sky130_fd_sc_hd__fill_1
Xmax_cap107 _1950_ VGND VGND VPWR VPWR net107 sky130_fd_sc_hd__clkbuf_2
Xmax_cap118 _3299_ VGND VGND VPWR VPWR net118 sky130_fd_sc_hd__clkbuf_2
XFILLER_0_40_339 VGND VGND VPWR VPWR sky130_fd_sc_hd__decap_4
XFILLER_0_0_436 VGND VGND VPWR VPWR sky130_fd_sc_hd__fill_1
XFILLER_0_0_447 VGND VGND VPWR VPWR sky130_fd_sc_hd__fill_1
XFILLER_0_21_597 VGND VGND VPWR VPWR sky130_fd_sc_hd__decap_4
XFILLER_0_29_55 VGND VGND VPWR VPWR sky130_fd_sc_hd__fill_1
X_6970_ _2389_ _2390_ _2429_ _2431_ VGND VGND VPWR VPWR _2432_ sky130_fd_sc_hd__or4_1
XFILLER_0_45_43 VGND VGND VPWR VPWR sky130_fd_sc_hd__fill_1
XFILLER_0_45_54 VGND VGND VPWR VPWR sky130_fd_sc_hd__fill_2
X_5921_ _1283_ _1284_ VGND VGND VPWR VPWR _1285_ sky130_fd_sc_hd__xnor2_1
XFILLER_0_45_76 VPWR VGND VPWR VGND sky130_ef_sc_hd__decap_12
XFILLER_0_75_236 VPWR VGND VPWR VGND sky130_ef_sc_hd__decap_12
XFILLER_0_48_439 VPWR VGND VPWR VGND sky130_ef_sc_hd__decap_12
X_5852_ _1208_ _1209_ VGND VGND VPWR VPWR _1210_ sky130_fd_sc_hd__nor2_4
X_5783_ _1111_ _1132_ _1133_ VGND VGND VPWR VPWR _1134_ sky130_fd_sc_hd__nor3_1
XFILLER_0_28_141 VPWR VGND VPWR VGND sky130_ef_sc_hd__decap_12
X_4803_ _0062_ _0063_ _0064_ VGND VGND VPWR VPWR _0066_ sky130_fd_sc_hd__a21o_1
X_7522_ _2827_ _2829_ _3035_ VGND VGND VPWR VPWR _3036_ sky130_fd_sc_hd__o21a_1
X_4734_ _3837_ _3836_ _3768_ VGND VGND VPWR VPWR _3838_ sky130_fd_sc_hd__nor3b_2
XFILLER_0_16_314 VGND VGND VPWR VPWR sky130_fd_sc_hd__decap_8
XFILLER_0_43_144 VGND VGND VPWR VPWR sky130_fd_sc_hd__decap_3
XFILLER_0_44_645 VGND VGND VPWR VPWR sky130_fd_sc_hd__decap_6
X_7453_ _2958_ _2959_ VGND VGND VPWR VPWR _2960_ sky130_fd_sc_hd__nor2_1
X_4665_ _3768_ _3769_ VGND VGND VPWR VPWR _3770_ sky130_fd_sc_hd__nor2_1
XFILLER_0_9_76 VGND VGND VPWR VPWR sky130_fd_sc_hd__decap_8
XFILLER_0_9_65 VGND VGND VPWR VPWR sky130_fd_sc_hd__fill_1
X_7384_ _3319_ net20 net19 _2878_ VGND VGND VPWR VPWR _2884_ sky130_fd_sc_hd__a22o_1
X_6404_ _2321_ _1668_ _0976_ VGND VGND VPWR VPWR _1813_ sky130_fd_sc_hd__o21ai_1
X_4596_ _3699_ _3700_ _3701_ VGND VGND VPWR VPWR _3702_ sky130_fd_sc_hd__nand3_1
XFILLER_0_12_531 VGND VGND VPWR VPWR sky130_fd_sc_hd__fill_1
XFILLER_0_12_553 VPWR VGND VPWR VGND sky130_ef_sc_hd__decap_12
X_6335_ _1938_ _1523_ VGND VGND VPWR VPWR _1737_ sky130_fd_sc_hd__nand2_1
XFILLER_0_12_586 VGND VGND VPWR VPWR sky130_fd_sc_hd__fill_2
XFILLER_0_86_83 VGND VGND VPWR VPWR sky130_fd_sc_hd__fill_1
X_6266_ _0900_ _0378_ _3717_ _1222_ _0717_ VGND VGND VPWR VPWR _1662_ sky130_fd_sc_hd__o221a_1
X_6197_ _1570_ _1571_ _1584_ VGND VGND VPWR VPWR _1586_ sky130_fd_sc_hd__nand3_1
X_5217_ _0430_ _0439_ VGND VGND VPWR VPWR _0516_ sky130_fd_sc_hd__or2b_1
X_5148_ _0426_ _0427_ _0440_ VGND VGND VPWR VPWR _0441_ sky130_fd_sc_hd__o21a_1
X_5079_ _0267_ _0364_ _0365_ VGND VGND VPWR VPWR _0367_ sky130_fd_sc_hd__nand3b_1
XTAP_TAPCELL_ROW_55_868 VGND VPWR sky130_fd_sc_hd__tapvpwrvgnd_1
XTAP_TAPCELL_ROW_27_548 VGND VPWR sky130_fd_sc_hd__tapvpwrvgnd_1
XFILLER_0_94_578 VGND VGND VPWR VPWR sky130_fd_sc_hd__decap_4
XFILLER_0_109_349 VGND VGND VPWR VPWR sky130_fd_sc_hd__decap_4
XFILLER_0_94_589 VGND VGND VPWR VPWR sky130_fd_sc_hd__decap_4
XFILLER_0_105_511 VGND VGND VPWR VPWR sky130_fd_sc_hd__fill_1
XFILLER_0_62_453 VGND VGND VPWR VPWR sky130_fd_sc_hd__decap_8
XFILLER_0_105_588 VPWR VGND VPWR VGND sky130_ef_sc_hd__decap_12
XFILLER_0_89_328 VGND VGND VPWR VPWR sky130_fd_sc_hd__decap_8
XFILLER_0_106_15 VPWR VGND VPWR VGND sky130_ef_sc_hd__decap_12
XTAP_TAPCELL_ROW_85_1218 VGND VPWR sky130_fd_sc_hd__tapvpwrvgnd_1
XFILLER_0_15_57 VGND VGND VPWR VPWR sky130_fd_sc_hd__decap_3
XFILLER_0_97_383 VGND VGND VPWR VPWR sky130_fd_sc_hd__decap_8
XFILLER_0_57_236 VGND VGND VPWR VPWR sky130_fd_sc_hd__decap_8
XFILLER_0_26_601 VPWR VGND VPWR VGND sky130_ef_sc_hd__decap_12
XFILLER_0_5_517 VGND VGND VPWR VPWR sky130_fd_sc_hd__decap_8
XFILLER_0_26_645 VGND VGND VPWR VPWR sky130_fd_sc_hd__decap_6
XFILLER_0_53_442 VGND VGND VPWR VPWR sky130_fd_sc_hd__decap_6
XFILLER_0_13_317 VGND VGND VPWR VPWR sky130_fd_sc_hd__fill_2
XTAP_TAPCELL_ROW_96_1336 VGND VPWR sky130_fd_sc_hd__tapvpwrvgnd_1
X_4450_ _3130_ _2867_ VGND VGND VPWR VPWR _3559_ sky130_fd_sc_hd__and2_1
X_4381_ _3298_ _3356_ VGND VGND VPWR VPWR _3491_ sky130_fd_sc_hd__nor2_1
X_6120_ _1385_ _1502_ VGND VGND VPWR VPWR _1503_ sky130_fd_sc_hd__xnor2_1
XFILLER_0_0_233 VGND VGND VPWR VPWR sky130_fd_sc_hd__fill_1
XFILLER_0_21_361 VPWR VGND VPWR VGND sky130_ef_sc_hd__decap_12
XFILLER_0_0_266 VGND VGND VPWR VPWR sky130_fd_sc_hd__decap_3
X_6051_ _1292_ _1294_ _1328_ _1329_ VGND VGND VPWR VPWR _1427_ sky130_fd_sc_hd__nor4_1
X_5002_ _3540_ _3550_ _3342_ VGND VGND VPWR VPWR _0283_ sky130_fd_sc_hd__mux2_1
X_6953_ _1675_ _0813_ _2270_ _2268_ VGND VGND VPWR VPWR _2413_ sky130_fd_sc_hd__a31o_1
XTAP_TAPCELL_ROW_105_1443 VGND VPWR sky130_fd_sc_hd__tapvpwrvgnd_1
X_6884_ _2333_ _2334_ _2335_ VGND VGND VPWR VPWR _2337_ sky130_fd_sc_hd__a21o_1
XFILLER_0_76_545 VPWR VGND VPWR VGND sky130_ef_sc_hd__decap_12
XFILLER_0_72_85 VPWR VGND VPWR VGND sky130_ef_sc_hd__decap_12
XTAP_TAPCELL_ROW_24_507 VGND VPWR sky130_fd_sc_hd__tapvpwrvgnd_1
XTAP_TAPCELL_ROW_24_518 VGND VPWR sky130_fd_sc_hd__tapvpwrvgnd_1
X_5904_ _1263_ _1264_ _1155_ _1237_ VGND VGND VPWR VPWR _1266_ sky130_fd_sc_hd__o211a_1
X_5835_ _1188_ _1189_ _1169_ VGND VGND VPWR VPWR _1191_ sky130_fd_sc_hd__a21oi_2
XFILLER_0_48_247 VGND VGND VPWR VPWR sky130_fd_sc_hd__decap_4
XTAP_TAPCELL_ROW_52_838 VGND VPWR sky130_fd_sc_hd__tapvpwrvgnd_1
XFILLER_0_8_377 VPWR VGND VPWR VGND sky130_ef_sc_hd__decap_12
XFILLER_0_16_122 VGND VGND VPWR VPWR sky130_fd_sc_hd__fill_2
X_5766_ _0986_ _0992_ VGND VGND VPWR VPWR _1115_ sky130_fd_sc_hd__or2b_1
XFILLER_0_71_261 VGND VGND VPWR VPWR sky130_fd_sc_hd__decap_4
X_7505_ _2770_ _2768_ VGND VGND VPWR VPWR _3017_ sky130_fd_sc_hd__and2b_1
X_5697_ _1036_ _1039_ VGND VGND VPWR VPWR _1040_ sky130_fd_sc_hd__xnor2_1
X_4717_ _3032_ _2386_ VGND VGND VPWR VPWR _3821_ sky130_fd_sc_hd__nand2_1
X_7436_ _2722_ _2924_ _2940_ VGND VGND VPWR VPWR _2941_ sky130_fd_sc_hd__a21oi_1
X_4648_ _3326_ _3325_ _2802_ _3324_ _3309_ _3314_ VGND VGND VPWR VPWR _3753_ sky130_fd_sc_hd__mux4_1
XFILLER_0_16_188 VGND VGND VPWR VPWR sky130_fd_sc_hd__decap_8
XFILLER_0_32_626 VGND VGND VPWR VPWR sky130_fd_sc_hd__fill_1
X_7367_ net23 _1360_ _1094_ _2858_ _2864_ VGND VGND VPWR VPWR _2865_ sky130_fd_sc_hd__o221a_1
X_4579_ _3449_ _3152_ _2474_ VGND VGND VPWR VPWR _3685_ sky130_fd_sc_hd__and3_1
X_7298_ _2774_ _2788_ _2789_ VGND VGND VPWR VPWR _2790_ sky130_fd_sc_hd__or3_1
X_6318_ _1701_ _1716_ _1717_ VGND VGND VPWR VPWR _1718_ sky130_fd_sc_hd__nor3_1
X_6249_ _1640_ _1641_ _1497_ VGND VGND VPWR VPWR _1644_ sky130_fd_sc_hd__a21o_1
XTAP_TAPCELL_ROW_4_287 VGND VPWR sky130_fd_sc_hd__tapvpwrvgnd_1
XFILLER_0_86_309 VGND VGND VPWR VPWR sky130_fd_sc_hd__decap_6
XFILLER_0_79_361 VGND VGND VPWR VPWR sky130_fd_sc_hd__decap_3
XFILLER_0_67_512 VPWR VGND VPWR VGND sky130_ef_sc_hd__decap_12
XFILLER_0_39_203 VPWR VGND VPWR VGND sky130_ef_sc_hd__decap_12
XFILLER_0_39_225 VPWR VGND VPWR VGND sky130_ef_sc_hd__decap_12
XFILLER_0_109_113 VPWR VGND VPWR VGND sky130_ef_sc_hd__decap_12
XFILLER_0_94_397 VGND VGND VPWR VPWR sky130_fd_sc_hd__fill_1
XTAP_TAPCELL_ROW_80_1159 VGND VPWR sky130_fd_sc_hd__tapvpwrvgnd_1
XFILLER_0_67_589 VPWR VGND VPWR VGND sky130_ef_sc_hd__decap_12
XFILLER_0_23_615 VGND VGND VPWR VPWR sky130_fd_sc_hd__fill_1
XFILLER_0_50_401 VPWR VGND VPWR VGND sky130_ef_sc_hd__decap_12
XFILLER_0_105_330 VGND VGND VPWR VPWR sky130_fd_sc_hd__decap_6
XFILLER_0_22_103 VPWR VGND VPWR VGND sky130_ef_sc_hd__decap_12
XFILLER_0_105_374 VPWR VGND VPWR VGND sky130_ef_sc_hd__decap_12
XFILLER_0_22_147 VGND VGND VPWR VPWR sky130_fd_sc_hd__fill_1
XFILLER_0_50_456 VGND VGND VPWR VPWR sky130_fd_sc_hd__fill_2
XFILLER_0_50_489 VGND VGND VPWR VPWR sky130_fd_sc_hd__decap_8
XTAP_TAPCELL_ROW_91_1288 VGND VPWR sky130_fd_sc_hd__tapvpwrvgnd_1
XFILLER_0_26_34 VGND VGND VPWR VPWR sky130_fd_sc_hd__decap_8
XFILLER_0_89_169 VGND VGND VPWR VPWR sky130_fd_sc_hd__decap_3
X_3950_ _1195_ VGND VGND VPWR VPWR _1206_ sky130_fd_sc_hd__buf_2
XFILLER_0_58_545 VPWR VGND VPWR VGND sky130_ef_sc_hd__decap_12
XFILLER_0_9_108 VGND VGND VPWR VPWR sky130_fd_sc_hd__decap_4
X_3881_ _0333_ _0355_ VGND VGND VPWR VPWR _0453_ sky130_fd_sc_hd__or2_1
XFILLER_0_58_578 VGND VGND VPWR VPWR sky130_fd_sc_hd__decap_4
X_5620_ _0682_ _0739_ _0956_ VGND VGND VPWR VPWR _0957_ sky130_fd_sc_hd__a21o_1
XTAP_TAPCELL_ROW_100_1384 VGND VPWR sky130_fd_sc_hd__tapvpwrvgnd_1
X_5551_ _0877_ _0879_ _0766_ _0768_ VGND VGND VPWR VPWR _0881_ sky130_fd_sc_hd__o211a_1
X_4502_ _3403_ _3594_ _3595_ _3603_ _3609_ VGND VGND VPWR VPWR _3610_ sky130_fd_sc_hd__a311o_1
XFILLER_0_14_626 VPWR VGND VPWR VGND sky130_ef_sc_hd__decap_12
X_7221_ _2638_ _0137_ VGND VGND VPWR VPWR _2706_ sky130_fd_sc_hd__nand2_1
XFILLER_0_77_7 VGND VGND VPWR VPWR sky130_fd_sc_hd__fill_1
X_5482_ _0805_ _0804_ _0785_ VGND VGND VPWR VPWR _0806_ sky130_fd_sc_hd__and3_1
X_4433_ _3396_ _3535_ _3537_ _3541_ VGND VGND VPWR VPWR _3542_ sky130_fd_sc_hd__a211o_1
X_4364_ _3302_ _3473_ VGND VGND VPWR VPWR _3474_ sky130_fd_sc_hd__nand2_1
X_7152_ _2448_ _2447_ VGND VGND VPWR VPWR _2631_ sky130_fd_sc_hd__and2b_1
X_7083_ _2536_ _2537_ _2553_ VGND VGND VPWR VPWR _2555_ sky130_fd_sc_hd__nand3_1
XFILLER_0_67_52 VGND VGND VPWR VPWR sky130_fd_sc_hd__fill_1
XFILLER_0_6_77 VGND VGND VPWR VPWR sky130_fd_sc_hd__decap_6
X_6103_ _1323_ _1451_ _1482_ _1483_ VGND VGND VPWR VPWR _1484_ sky130_fd_sc_hd__a211oi_4
X_4295_ _3185_ VGND VGND VPWR VPWR _3406_ sky130_fd_sc_hd__inv_2
X_6034_ _2922_ _0791_ _1255_ _1254_ VGND VGND VPWR VPWR _1408_ sky130_fd_sc_hd__a31o_1
Xrebuffer11 _1058_ VGND VGND VPWR VPWR net154 sky130_fd_sc_hd__dlymetal6s2s_1
XFILLER_0_20_3 VPWR VGND VPWR VGND sky130_ef_sc_hd__decap_12
XFILLER_0_68_309 VPWR VGND VPWR VGND sky130_ef_sc_hd__decap_12
XTAP_TAPCELL_ROW_1_246 VGND VPWR sky130_fd_sc_hd__tapvpwrvgnd_1
XTAP_TAPCELL_ROW_65_985 VGND VPWR sky130_fd_sc_hd__tapvpwrvgnd_1
X_6936_ _2681_ _0867_ _1075_ _2485_ VGND VGND VPWR VPWR _2394_ sky130_fd_sc_hd__a22oi_1
XTAP_TAPCELL_ROW_37_665 VGND VPWR sky130_fd_sc_hd__tapvpwrvgnd_1
XFILLER_0_49_512 VPWR VGND VPWR VGND sky130_ef_sc_hd__decap_12
X_6867_ _1088_ _0199_ _2316_ _2318_ VGND VGND VPWR VPWR _2319_ sky130_fd_sc_hd__a211o_1
XFILLER_0_107_617 VPWR VGND VPWR VGND sky130_ef_sc_hd__decap_12
XFILLER_0_91_334 VGND VGND VPWR VPWR sky130_fd_sc_hd__fill_2
X_5818_ _3622_ _2036_ _1260_ _3448_ VGND VGND VPWR VPWR _1172_ sky130_fd_sc_hd__a22oi_2
XFILLER_0_8_141 VGND VGND VPWR VPWR sky130_fd_sc_hd__decap_8
XFILLER_0_17_420 VGND VGND VPWR VPWR sky130_fd_sc_hd__fill_1
X_6798_ _2217_ _2218_ _2240_ _2241_ VGND VGND VPWR VPWR _2243_ sky130_fd_sc_hd__o22ai_1
X_5749_ _1238_ _1096_ _0378_ _1228_ VGND VGND VPWR VPWR _1098_ sky130_fd_sc_hd__o2bb2a_1
XFILLER_0_32_412 VGND VGND VPWR VPWR sky130_fd_sc_hd__fill_1
XFILLER_0_102_300 VGND VGND VPWR VPWR sky130_fd_sc_hd__decap_8
X_7419_ _2738_ _2745_ _2921_ VGND VGND VPWR VPWR _2923_ sky130_fd_sc_hd__a21oi_1
XFILLER_0_102_377 VPWR VGND VPWR VGND sky130_ef_sc_hd__decap_12
XTAP_TAPCELL_ROW_9_335 VGND VPWR sky130_fd_sc_hd__tapvpwrvgnd_1
XFILLER_0_99_478 VGND VGND VPWR VPWR sky130_fd_sc_hd__decap_3
XFILLER_0_87_629 VPWR VGND VPWR VGND sky130_ef_sc_hd__decap_12
XFILLER_0_67_386 VGND VGND VPWR VPWR sky130_fd_sc_hd__decap_6
XFILLER_0_27_217 VGND VGND VPWR VPWR sky130_fd_sc_hd__decap_6
XFILLER_0_103_27 VPWR VGND VPWR VGND sky130_ef_sc_hd__decap_12
XFILLER_0_82_345 VPWR VGND VPWR VGND sky130_ef_sc_hd__decap_12
XFILLER_0_82_389 VPWR VGND VPWR VGND sky130_ef_sc_hd__decap_12
XFILLER_0_23_423 VGND VGND VPWR VPWR sky130_fd_sc_hd__fill_1
XTAP_TAPCELL_ROW_93_1306 VGND VPWR sky130_fd_sc_hd__tapvpwrvgnd_1
XFILLER_0_88_29 VPWR VGND VPWR VGND sky130_ef_sc_hd__decap_12
XFILLER_0_11_629 VPWR VGND VPWR VGND sky130_ef_sc_hd__decap_12
XFILLER_0_50_253 VPWR VGND VPWR VGND sky130_ef_sc_hd__decap_12
Xoutput80 net80 VGND VGND VPWR VPWR result[1] sky130_fd_sc_hd__buf_2
Xoutput91 net91 VGND VGND VPWR VPWR result[2] sky130_fd_sc_hd__buf_2
XFILLER_0_37_55 VGND VGND VPWR VPWR sky130_fd_sc_hd__fill_1
X_4080_ _2616_ VGND VGND VPWR VPWR _2627_ sky130_fd_sc_hd__buf_4
XFILLER_0_53_54 VGND VGND VPWR VPWR sky130_fd_sc_hd__fill_2
XTAP_TAPCELL_ROW_102_1413 VGND VPWR sky130_fd_sc_hd__tapvpwrvgnd_1
XFILLER_0_86_651 VGND VGND VPWR VPWR sky130_fd_sc_hd__fill_1
XTAP_TAPCELL_ROW_34_624 VGND VPWR sky130_fd_sc_hd__tapvpwrvgnd_1
X_4982_ _0220_ _0259_ _0260_ VGND VGND VPWR VPWR _0261_ sky130_fd_sc_hd__and3_1
XTAP_TAPCELL_ROW_62_955 VGND VPWR sky130_fd_sc_hd__tapvpwrvgnd_1
XTAP_TAPCELL_ROW_62_944 VGND VPWR sky130_fd_sc_hd__tapvpwrvgnd_1
XFILLER_0_58_353 VGND VGND VPWR VPWR sky130_fd_sc_hd__decap_6
X_6721_ _2022_ _2125_ _2126_ VGND VGND VPWR VPWR _2159_ sky130_fd_sc_hd__nor3_1
X_3933_ net43 VGND VGND VPWR VPWR _1020_ sky130_fd_sc_hd__buf_2
X_3864_ _0246_ _0257_ VGND VGND VPWR VPWR _0268_ sky130_fd_sc_hd__or2b_1
XFILLER_0_6_601 VPWR VGND VPWR VGND sky130_ef_sc_hd__decap_12
X_6652_ _1934_ _1936_ _1933_ VGND VGND VPWR VPWR _2084_ sky130_fd_sc_hd__o21ba_1
XFILLER_0_6_645 VGND VGND VPWR VPWR sky130_fd_sc_hd__decap_6
XFILLER_0_5_111 VGND VGND VPWR VPWR sky130_fd_sc_hd__fill_1
X_5603_ _0935_ _0936_ _0812_ _0858_ VGND VGND VPWR VPWR _0938_ sky130_fd_sc_hd__o211ai_2
XTAP_TAPCELL_ROW_14_392 VGND VPWR sky130_fd_sc_hd__tapvpwrvgnd_1
XFILLER_0_5_155 VGND VGND VPWR VPWR sky130_fd_sc_hd__fill_2
X_6583_ _3332_ net46 _1857_ _1855_ VGND VGND VPWR VPWR _2008_ sky130_fd_sc_hd__a31o_1
XFILLER_0_54_581 VGND VGND VPWR VPWR sky130_fd_sc_hd__decap_6
X_5534_ _2375_ _0433_ _1599_ _3267_ VGND VGND VPWR VPWR _0862_ sky130_fd_sc_hd__nand4_1
XFILLER_0_78_40 VPWR VGND VPWR VGND sky130_ef_sc_hd__decap_12
X_5465_ _3448_ _3622_ _1927_ _0660_ VGND VGND VPWR VPWR _0787_ sky130_fd_sc_hd__and4_1
X_7204_ _0412_ _1085_ _2686_ _0407_ _1088_ VGND VGND VPWR VPWR _2687_ sky130_fd_sc_hd__a32o_1
XFILLER_0_68_3 VGND VGND VPWR VPWR sky130_fd_sc_hd__fill_1
X_4416_ _3310_ _3524_ VGND VGND VPWR VPWR _3525_ sky130_fd_sc_hd__nand2_2
X_5396_ _0620_ _0591_ _0710_ VGND VGND VPWR VPWR _0712_ sky130_fd_sc_hd__o21ai_1
XFILLER_0_10_651 VGND VGND VPWR VPWR sky130_fd_sc_hd__fill_1
XTAP_TAPCELL_ROW_6_305 VGND VPWR sky130_fd_sc_hd__tapvpwrvgnd_1
X_7135_ _2438_ _2444_ VGND VGND VPWR VPWR _2612_ sky130_fd_sc_hd__or2b_1
X_4347_ _1894_ _1949_ _3308_ VGND VGND VPWR VPWR _3458_ sky130_fd_sc_hd__mux2_2
X_4278_ _3345_ net20 _3389_ VGND VGND VPWR VPWR _3390_ sky130_fd_sc_hd__a21o_1
XFILLER_0_94_72 VPWR VGND VPWR VGND sky130_ef_sc_hd__decap_12
X_7066_ _2350_ _2356_ VGND VGND VPWR VPWR _2536_ sky130_fd_sc_hd__or2b_1
X_6017_ _1245_ _1265_ _1267_ VGND VGND VPWR VPWR _1389_ sky130_fd_sc_hd__or3_1
XTAP_TAPCELL_ROW_68_1021 VGND VPWR sky130_fd_sc_hd__tapvpwrvgnd_1
XFILLER_0_77_640 VGND VGND VPWR VPWR sky130_fd_sc_hd__fill_1
XFILLER_0_68_139 VGND VGND VPWR VPWR sky130_fd_sc_hd__fill_1
XFILLER_0_83_109 VGND VGND VPWR VPWR sky130_fd_sc_hd__decap_3
XFILLER_0_76_161 VGND VGND VPWR VPWR sky130_fd_sc_hd__decap_6
X_6919_ _2373_ _2374_ VGND VGND VPWR VPWR _2376_ sky130_fd_sc_hd__nor2_1
XFILLER_0_107_403 VGND VGND VPWR VPWR sky130_fd_sc_hd__decap_4
XFILLER_0_92_643 VGND VGND VPWR VPWR sky130_fd_sc_hd__fill_1
XFILLER_0_64_345 VGND VGND VPWR VPWR sky130_fd_sc_hd__fill_1
XFILLER_0_107_447 VGND VGND VPWR VPWR sky130_fd_sc_hd__fill_1
XFILLER_0_91_186 VGND VGND VPWR VPWR sky130_fd_sc_hd__decap_8
XFILLER_0_17_261 VPWR VGND VPWR VGND sky130_ef_sc_hd__decap_12
XTAP_TAPCELL_ROW_79_1150 VGND VPWR sky130_fd_sc_hd__tapvpwrvgnd_1
XFILLER_0_60_562 VGND VGND VPWR VPWR sky130_fd_sc_hd__fill_1
XFILLER_0_32_253 VGND VGND VPWR VPWR sky130_fd_sc_hd__decap_8
XFILLER_0_20_426 VPWR VGND VPWR VGND sky130_ef_sc_hd__decap_12
XFILLER_0_32_286 VPWR VGND VPWR VGND sky130_ef_sc_hd__decap_12
XFILLER_0_102_163 VPWR VGND VPWR VGND sky130_ef_sc_hd__decap_12
XFILLER_0_99_253 VGND VGND VPWR VPWR sky130_fd_sc_hd__fill_2
XFILLER_0_99_275 VGND VGND VPWR VPWR sky130_fd_sc_hd__fill_1
XFILLER_0_87_426 VGND VGND VPWR VPWR sky130_fd_sc_hd__fill_1
XFILLER_0_87_459 VGND VGND VPWR VPWR sky130_fd_sc_hd__decap_4
XFILLER_0_68_651 VGND VGND VPWR VPWR sky130_fd_sc_hd__fill_1
XFILLER_0_74_109 VGND VGND VPWR VPWR sky130_fd_sc_hd__fill_1
XFILLER_0_83_632 VGND VGND VPWR VPWR sky130_fd_sc_hd__fill_1
XFILLER_0_55_323 VPWR VGND VPWR VGND sky130_ef_sc_hd__decap_12
XFILLER_0_99_39 VPWR VGND VPWR VGND sky130_ef_sc_hd__decap_12
XFILLER_0_70_315 VGND VGND VPWR VPWR sky130_fd_sc_hd__decap_4
XFILLER_0_82_197 VPWR VGND VPWR VGND sky130_ef_sc_hd__decap_12
XFILLER_0_70_348 VGND VGND VPWR VPWR sky130_fd_sc_hd__decap_8
XTAP_TAPCELL_ROW_11_362 VGND VPWR sky130_fd_sc_hd__tapvpwrvgnd_1
Xrebuffer2 _1199_ VGND VGND VPWR VPWR net120 sky130_fd_sc_hd__buf_6
XFILLER_0_23_242 VPWR VGND VPWR VGND sky130_ef_sc_hd__decap_12
X_5250_ net155 net5 _1829_ net142 VGND VGND VPWR VPWR _0553_ sky130_fd_sc_hd__a22o_1
X_4201_ _3312_ VGND VGND VPWR VPWR _3313_ sky130_fd_sc_hd__clkbuf_4
X_5181_ _0473_ _0474_ _0476_ VGND VGND VPWR VPWR _0478_ sky130_fd_sc_hd__a21o_1
X_4132_ _3185_ VGND VGND VPWR VPWR _3196_ sky130_fd_sc_hd__clkbuf_8
X_4063_ net28 VGND VGND VPWR VPWR _2441_ sky130_fd_sc_hd__clkbuf_4
XTAP_TAPCELL_ROW_19_451 VGND VPWR sky130_fd_sc_hd__tapvpwrvgnd_1
XTAP_TAPCELL_ROW_47_782 VGND VPWR sky130_fd_sc_hd__tapvpwrvgnd_1
X_4965_ net56 VGND VGND VPWR VPWR _0242_ sky130_fd_sc_hd__buf_6
X_6704_ _0213_ _0192_ VGND VGND VPWR VPWR _2141_ sky130_fd_sc_hd__and2b_1
X_3916_ _0780_ _0813_ VGND VGND VPWR VPWR _0835_ sky130_fd_sc_hd__nand2_1
XFILLER_0_74_643 VGND VGND VPWR VPWR sky130_fd_sc_hd__fill_1
XFILLER_0_74_621 VGND VGND VPWR VPWR sky130_fd_sc_hd__fill_2
XFILLER_0_58_194 VGND VGND VPWR VPWR sky130_fd_sc_hd__fill_2
XFILLER_0_19_526 VGND VGND VPWR VPWR sky130_fd_sc_hd__decap_6
XFILLER_0_19_537 VGND VGND VPWR VPWR sky130_fd_sc_hd__decap_6
X_7684_ _3463_ net118 _1094_ _3059_ VGND VGND VPWR VPWR _3213_ sky130_fd_sc_hd__o2bb2a_1
XFILLER_0_80_85 VPWR VGND VPWR VGND sky130_ef_sc_hd__decap_12
X_4896_ _0164_ _0165_ _0033_ VGND VGND VPWR VPWR _0167_ sky130_fd_sc_hd__o21ba_1
X_3847_ net51 VGND VGND VPWR VPWR _0083_ sky130_fd_sc_hd__inv_2
XFILLER_0_46_389 VPWR VGND VPWR VGND sky130_ef_sc_hd__decap_12
X_6635_ _3521_ net15 net14 _2867_ VGND VGND VPWR VPWR _2065_ sky130_fd_sc_hd__a22o_1
XFILLER_0_104_406 VGND VGND VPWR VPWR sky130_fd_sc_hd__decap_6
X_6566_ _0900_ _0966_ _1655_ _0955_ VGND VGND VPWR VPWR _1990_ sky130_fd_sc_hd__a31o_1
XFILLER_0_61_337 VPWR VGND VPWR VGND sky130_ef_sc_hd__decap_12
XFILLER_0_6_475 VGND VGND VPWR VPWR sky130_fd_sc_hd__fill_1
X_5517_ _0384_ _0843_ _0402_ VGND VGND VPWR VPWR _0844_ sky130_fd_sc_hd__mux2_1
XFILLER_0_14_253 VPWR VGND VPWR VGND sky130_ef_sc_hd__decap_12
XFILLER_0_14_297 VGND VGND VPWR VPWR sky130_fd_sc_hd__decap_8
X_6497_ _1911_ _1912_ _1913_ VGND VGND VPWR VPWR _1914_ sky130_fd_sc_hd__or3_1
XFILLER_0_100_634 VGND VGND VPWR VPWR sky130_fd_sc_hd__decap_8
X_5448_ _0759_ _0766_ _0767_ VGND VGND VPWR VPWR _0768_ sky130_fd_sc_hd__nand3_2
XFILLER_0_100_645 VGND VGND VPWR VPWR sky130_fd_sc_hd__decap_6
XTAP_TAPCELL_ROW_74_1091 VGND VPWR sky130_fd_sc_hd__tapvpwrvgnd_1
X_5379_ _0651_ _0652_ _0690_ _0691_ VGND VGND VPWR VPWR _0694_ sky130_fd_sc_hd__a22oi_2
X_7118_ _2580_ _2581_ _2591_ VGND VGND VPWR VPWR _2593_ sky130_fd_sc_hd__and3_1
X_7049_ _1752_ _1271_ _2354_ _2351_ VGND VGND VPWR VPWR _2518_ sky130_fd_sc_hd__a31o_1
XPHY_EDGE_ROW_29_Right_29 VGND VGND VPWR VPWR sky130_fd_sc_hd__decap_3
XFILLER_0_84_418 VGND VGND VPWR VPWR sky130_fd_sc_hd__fill_2
XFILLER_0_77_492 VGND VGND VPWR VPWR sky130_fd_sc_hd__decap_4
XFILLER_0_107_211 VGND VGND VPWR VPWR sky130_fd_sc_hd__fill_1
XFILLER_0_92_462 VGND VGND VPWR VPWR sky130_fd_sc_hd__decap_6
XFILLER_0_64_153 VPWR VGND VPWR VGND sky130_ef_sc_hd__decap_12
XFILLER_0_37_367 VPWR VGND VPWR VGND sky130_ef_sc_hd__decap_12
XFILLER_0_80_613 VPWR VGND VPWR VGND sky130_ef_sc_hd__decap_12
XFILLER_0_37_389 VGND VGND VPWR VPWR sky130_fd_sc_hd__decap_3
XPHY_EDGE_ROW_38_Right_38 VGND VGND VPWR VPWR sky130_fd_sc_hd__decap_3
XFILLER_0_64_197 VGND VGND VPWR VPWR sky130_fd_sc_hd__decap_8
XFILLER_0_52_359 VGND VGND VPWR VPWR sky130_fd_sc_hd__decap_4
XFILLER_0_33_573 VPWR VGND VPWR VGND sky130_ef_sc_hd__decap_12
XFILLER_0_103_461 VGND VGND VPWR VPWR sky130_fd_sc_hd__fill_1
XFILLER_0_0_629 VPWR VGND VPWR VGND sky130_ef_sc_hd__decap_12
XFILLER_0_109_15 VPWR VGND VPWR VGND sky130_ef_sc_hd__decap_12
XPHY_EDGE_ROW_47_Right_47 VGND VGND VPWR VPWR sky130_fd_sc_hd__decap_3
XTAP_TAPCELL_ROW_88_1249 VGND VPWR sky130_fd_sc_hd__tapvpwrvgnd_1
XFILLER_0_18_79 VGND VGND VPWR VPWR sky130_fd_sc_hd__decap_4
XFILLER_0_87_245 VGND VGND VPWR VPWR sky130_fd_sc_hd__decap_8
XFILLER_0_75_429 VPWR VGND VPWR VGND sky130_ef_sc_hd__decap_12
XTAP_TAPCELL_ROW_16_421 VGND VPWR sky130_fd_sc_hd__tapvpwrvgnd_1
XTAP_TAPCELL_ROW_44_741 VGND VPWR sky130_fd_sc_hd__tapvpwrvgnd_1
X_4750_ _3370_ _0010_ VGND VGND VPWR VPWR _0011_ sky130_fd_sc_hd__nor2_2
XPHY_EDGE_ROW_56_Right_56 VGND VGND VPWR VPWR sky130_fd_sc_hd__decap_3
XFILLER_0_56_643 VGND VGND VPWR VPWR sky130_fd_sc_hd__fill_1
XFILLER_0_28_356 VGND VGND VPWR VPWR sky130_fd_sc_hd__decap_8
XFILLER_0_50_22 VGND VGND VPWR VPWR sky130_fd_sc_hd__decap_6
XFILLER_0_70_101 VGND VGND VPWR VPWR sky130_fd_sc_hd__fill_2
XFILLER_0_16_529 VGND VGND VPWR VPWR sky130_fd_sc_hd__decap_3
X_4681_ _3776_ _3784_ _3785_ VGND VGND VPWR VPWR _3786_ sky130_fd_sc_hd__nand3_1
XTAP_TAPCELL_ROW_99_1378 VGND VPWR sky130_fd_sc_hd__tapvpwrvgnd_1
X_6420_ _0977_ _1812_ _1830_ VGND VGND VPWR VPWR net84 sky130_fd_sc_hd__a21o_1
XFILLER_0_3_412 VPWR VGND VPWR VGND sky130_ef_sc_hd__decap_12
XFILLER_0_43_337 VPWR VGND VPWR VGND sky130_ef_sc_hd__decap_12
XFILLER_0_43_359 VGND VGND VPWR VPWR sky130_fd_sc_hd__decap_8
X_6351_ net60 net59 net8 net7 VGND VGND VPWR VPWR _1755_ sky130_fd_sc_hd__and4_1
X_5302_ _3721_ _3388_ VGND VGND VPWR VPWR _0610_ sky130_fd_sc_hd__nand2_1
XFILLER_0_11_223 VGND VGND VPWR VPWR sky130_fd_sc_hd__fill_1
XFILLER_0_11_201 VGND VGND VPWR VPWR sky130_fd_sc_hd__decap_6
X_6282_ _1536_ _1674_ _1677_ _1678_ VGND VGND VPWR VPWR _1679_ sky130_fd_sc_hd__a2bb2o_1
XPHY_EDGE_ROW_65_Right_65 VGND VGND VPWR VPWR sky130_fd_sc_hd__decap_3
X_5233_ _0525_ _0533_ VGND VGND VPWR VPWR _0534_ sky130_fd_sc_hd__xnor2_1
X_5164_ _3448_ _1381_ _1643_ _2616_ VGND VGND VPWR VPWR _0459_ sky130_fd_sc_hd__a22oi_2
X_4115_ net11 VGND VGND VPWR VPWR _3010_ sky130_fd_sc_hd__clkbuf_4
X_5095_ _0194_ _0383_ _3482_ VGND VGND VPWR VPWR _0384_ sky130_fd_sc_hd__mux2_1
X_4046_ _2211_ _2222_ _2233_ _2244_ _1315_ VGND VGND VPWR VPWR _2255_ sky130_fd_sc_hd__o311a_1
XTAP_TAPCELL_ROW_108_1474 VGND VPWR sky130_fd_sc_hd__tapvpwrvgnd_1
XFILLER_0_91_51 VGND VGND VPWR VPWR sky130_fd_sc_hd__decap_4
XFILLER_0_91_84 VGND VGND VPWR VPWR sky130_fd_sc_hd__fill_2
XFILLER_0_66_418 VGND VGND VPWR VPWR sky130_fd_sc_hd__fill_2
XFILLER_0_38_109 VGND VGND VPWR VPWR sky130_fd_sc_hd__decap_8
X_5997_ _0385_ _1367_ _0390_ VGND VGND VPWR VPWR _1368_ sky130_fd_sc_hd__mux2_1
XFILLER_0_78_289 VGND VGND VPWR VPWR sky130_fd_sc_hd__decap_8
XPHY_EDGE_ROW_74_Right_74 VGND VGND VPWR VPWR sky130_fd_sc_hd__decap_3
XFILLER_0_19_301 VGND VGND VPWR VPWR sky130_fd_sc_hd__fill_2
XFILLER_0_19_334 VGND VGND VPWR VPWR sky130_fd_sc_hd__fill_2
X_4948_ _2671_ _2692_ _0140_ _0139_ VGND VGND VPWR VPWR _0223_ sky130_fd_sc_hd__a31o_1
X_7667_ _3019_ _3025_ _3027_ VGND VGND VPWR VPWR _3194_ sky130_fd_sc_hd__a21o_1
XFILLER_0_62_624 VPWR VGND VPWR VGND sky130_ef_sc_hd__decap_12
XFILLER_0_62_602 VGND VGND VPWR VPWR sky130_fd_sc_hd__decap_3
XFILLER_0_61_101 VGND VGND VPWR VPWR sky130_fd_sc_hd__decap_8
XFILLER_0_19_389 VGND VGND VPWR VPWR sky130_fd_sc_hd__decap_3
XFILLER_0_34_304 VGND VGND VPWR VPWR sky130_fd_sc_hd__decap_4
XFILLER_0_34_315 VPWR VGND VPWR VGND sky130_ef_sc_hd__decap_12
X_4879_ _0053_ _0055_ _0054_ VGND VGND VPWR VPWR _0149_ sky130_fd_sc_hd__o21bai_1
XFILLER_0_61_123 VPWR VGND VPWR VGND sky130_ef_sc_hd__decap_12
X_6618_ _3269_ _0802_ _2044_ _2045_ VGND VGND VPWR VPWR _2046_ sky130_fd_sc_hd__nand4_2
XFILLER_0_46_197 VGND VGND VPWR VPWR sky130_fd_sc_hd__decap_8
X_7598_ _3114_ _3115_ _3116_ _3117_ VGND VGND VPWR VPWR _3118_ sky130_fd_sc_hd__o22a_1
XFILLER_0_61_156 VPWR VGND VPWR VGND sky130_ef_sc_hd__decap_12
XFILLER_0_15_551 VGND VGND VPWR VPWR sky130_fd_sc_hd__decap_8
XFILLER_0_15_573 VGND VGND VPWR VPWR sky130_fd_sc_hd__decap_4
X_6549_ _1352_ _1967_ _1969_ _1970_ VGND VGND VPWR VPWR _1972_ sky130_fd_sc_hd__o31a_1
XPHY_EDGE_ROW_83_Right_83 VGND VGND VPWR VPWR sky130_fd_sc_hd__decap_3
XFILLER_0_100_453 VPWR VGND VPWR VGND sky130_ef_sc_hd__decap_12
XFILLER_0_30_587 VGND VGND VPWR VPWR sky130_fd_sc_hd__fill_1
XFILLER_0_97_554 VGND VGND VPWR VPWR sky130_fd_sc_hd__decap_6
XTAP_TAPCELL_ROW_58_899 VGND VPWR sky130_fd_sc_hd__tapvpwrvgnd_1
XPHY_EDGE_ROW_92_Right_92 VGND VGND VPWR VPWR sky130_fd_sc_hd__decap_3
XFILLER_0_57_429 VGND VGND VPWR VPWR sky130_fd_sc_hd__fill_1
XTAP_TAPCELL_ROW_41_711 VGND VPWR sky130_fd_sc_hd__tapvpwrvgnd_1
XFILLER_0_108_531 VGND VGND VPWR VPWR sky130_fd_sc_hd__fill_1
XFILLER_0_108_564 VPWR VGND VPWR VGND sky130_ef_sc_hd__decap_12
XFILLER_0_80_421 VGND VGND VPWR VPWR sky130_fd_sc_hd__decap_8
XFILLER_0_25_337 VGND VGND VPWR VPWR sky130_fd_sc_hd__fill_1
XFILLER_0_37_197 VPWR VGND VPWR VGND sky130_ef_sc_hd__decap_12
Xmax_cap108 _1631_ VGND VGND VPWR VPWR net108 sky130_fd_sc_hd__clkbuf_2
XFILLER_0_52_167 VGND VGND VPWR VPWR sky130_fd_sc_hd__fill_1
XFILLER_0_21_532 VGND VGND VPWR VPWR sky130_fd_sc_hd__fill_1
XFILLER_0_96_29 VPWR VGND VPWR VGND sky130_ef_sc_hd__decap_12
XTAP_TAPCELL_ROW_49_800 VGND VPWR sky130_fd_sc_hd__tapvpwrvgnd_1
X_5920_ _1523_ _1654_ VGND VGND VPWR VPWR _1284_ sky130_fd_sc_hd__nand2_1
XFILLER_0_45_88 VGND VGND VPWR VPWR sky130_fd_sc_hd__decap_4
XFILLER_0_45_99 VPWR VGND VPWR VGND sky130_ef_sc_hd__decap_12
XFILLER_0_88_587 VGND VGND VPWR VPWR sky130_fd_sc_hd__fill_1
XFILLER_0_0_57 VPWR VGND VPWR VGND sky130_ef_sc_hd__decap_12
X_5851_ _1207_ _1205_ _1071_ VGND VGND VPWR VPWR _1209_ sky130_fd_sc_hd__a21oi_4
XPHY_EDGE_ROW_100_Right_100 VGND VGND VPWR VPWR sky130_fd_sc_hd__decap_3
XFILLER_0_75_248 VGND VGND VPWR VPWR sky130_fd_sc_hd__decap_4
XFILLER_0_61_54 VGND VGND VPWR VPWR sky130_fd_sc_hd__fill_2
XFILLER_0_56_440 VGND VGND VPWR VPWR sky130_fd_sc_hd__decap_6
XFILLER_0_8_526 VGND VGND VPWR VPWR sky130_fd_sc_hd__fill_1
X_5782_ _1130_ _1131_ _1021_ _1023_ VGND VGND VPWR VPWR _1133_ sky130_fd_sc_hd__a211oi_1
XFILLER_0_28_120 VPWR VGND VPWR VGND sky130_ef_sc_hd__decap_12
X_4802_ _0062_ _0063_ _0064_ VGND VGND VPWR VPWR _0065_ sky130_fd_sc_hd__nand3_2
X_7521_ _3033_ _3034_ VGND VGND VPWR VPWR _3035_ sky130_fd_sc_hd__nor2_1
X_4733_ _3834_ _3835_ _3789_ _3791_ VGND VGND VPWR VPWR _3837_ sky130_fd_sc_hd__o211a_1
X_7452_ _1949_ _1577_ _1293_ _1206_ VGND VGND VPWR VPWR _2959_ sky130_fd_sc_hd__and4_1
X_4664_ _3767_ _3766_ VGND VGND VPWR VPWR _3769_ sky130_fd_sc_hd__and2b_1
XFILLER_0_9_55 VGND VGND VPWR VPWR sky130_fd_sc_hd__fill_1
X_6403_ _1810_ _1811_ VGND VGND VPWR VPWR _1812_ sky130_fd_sc_hd__xnor2_1
X_7383_ _2878_ _3319_ net19 VGND VGND VPWR VPWR _2883_ sky130_fd_sc_hd__and3_1
X_4595_ _3627_ _3634_ _3633_ VGND VGND VPWR VPWR _3701_ sky130_fd_sc_hd__a21bo_1
XFILLER_0_12_565 VGND VGND VPWR VPWR sky130_fd_sc_hd__decap_3
XFILLER_0_12_543 VGND VGND VPWR VPWR sky130_fd_sc_hd__fill_2
X_6334_ _0457_ _0433_ _1599_ net145 VGND VGND VPWR VPWR _1736_ sky130_fd_sc_hd__a22oi_2
X_6265_ _2157_ _1360_ _1094_ _0911_ _1660_ VGND VGND VPWR VPWR _1661_ sky130_fd_sc_hd__o221a_1
X_5216_ _0438_ _0437_ VGND VGND VPWR VPWR _0515_ sky130_fd_sc_hd__or2b_1
XFILLER_0_50_3 VGND VGND VPWR VPWR sky130_fd_sc_hd__decap_4
XTAP_TAPCELL_ROW_71_1050 VGND VPWR sky130_fd_sc_hd__tapvpwrvgnd_1
X_6196_ _1570_ _1571_ _1584_ VGND VGND VPWR VPWR _1585_ sky130_fd_sc_hd__a21o_1
X_5147_ _0430_ _0439_ VGND VGND VPWR VPWR _0440_ sky130_fd_sc_hd__xnor2_1
XFILLER_0_98_329 VGND VGND VPWR VPWR sky130_fd_sc_hd__fill_2
XFILLER_0_98_318 VGND VGND VPWR VPWR sky130_fd_sc_hd__decap_8
XFILLER_0_98_307 VGND VGND VPWR VPWR sky130_fd_sc_hd__fill_1
X_5078_ _0362_ _0363_ _0263_ _0265_ VGND VGND VPWR VPWR _0365_ sky130_fd_sc_hd__o211ai_2
X_4029_ net37 VGND VGND VPWR VPWR _2069_ sky130_fd_sc_hd__buf_2
XTAP_TAPCELL_ROW_55_869 VGND VPWR sky130_fd_sc_hd__tapvpwrvgnd_1
XTAP_TAPCELL_ROW_27_549 VGND VPWR sky130_fd_sc_hd__tapvpwrvgnd_1
XFILLER_0_79_587 VGND VGND VPWR VPWR sky130_fd_sc_hd__fill_2
XFILLER_0_109_317 VGND VGND VPWR VPWR sky130_fd_sc_hd__fill_1
XFILLER_0_47_440 VGND VGND VPWR VPWR sky130_fd_sc_hd__fill_2
X_7719_ _0486_ _2669_ _3246_ _3247_ VGND VGND VPWR VPWR _3249_ sky130_fd_sc_hd__o211a_1
XFILLER_0_81_207 VGND VGND VPWR VPWR sky130_fd_sc_hd__fill_2
XFILLER_0_19_175 VGND VGND VPWR VPWR sky130_fd_sc_hd__fill_1
XFILLER_0_105_501 VGND VGND VPWR VPWR sky130_fd_sc_hd__decap_3
XFILLER_0_62_421 VGND VGND VPWR VPWR sky130_fd_sc_hd__decap_8
XFILLER_0_7_592 VPWR VGND VPWR VGND sky130_ef_sc_hd__decap_12
XFILLER_0_100_283 VGND VGND VPWR VPWR sky130_fd_sc_hd__decap_8
XFILLER_0_106_27 VGND VGND VPWR VPWR sky130_fd_sc_hd__fill_1
XTAP_TAPCELL_ROW_85_1219 VGND VPWR sky130_fd_sc_hd__tapvpwrvgnd_1
XFILLER_0_15_36 VGND VGND VPWR VPWR sky130_fd_sc_hd__decap_4
XFILLER_0_97_373 VGND VGND VPWR VPWR sky130_fd_sc_hd__fill_1
XFILLER_0_85_579 VGND VGND VPWR VPWR sky130_fd_sc_hd__decap_8
XFILLER_0_85_568 VGND VGND VPWR VPWR sky130_fd_sc_hd__decap_4
XFILLER_0_26_613 VGND VGND VPWR VPWR sky130_fd_sc_hd__decap_3
XFILLER_0_38_473 VGND VGND VPWR VPWR sky130_fd_sc_hd__decap_3
XFILLER_0_65_281 VGND VGND VPWR VPWR sky130_fd_sc_hd__decap_8
XFILLER_0_31_57 VPWR VGND VPWR VGND sky130_ef_sc_hd__decap_12
XFILLER_0_108_383 VGND VGND VPWR VPWR sky130_fd_sc_hd__decap_6
XFILLER_0_80_251 VGND VGND VPWR VPWR sky130_fd_sc_hd__fill_1
XFILLER_0_25_167 VGND VGND VPWR VPWR sky130_fd_sc_hd__fill_1
XFILLER_0_53_465 VGND VGND VPWR VPWR sky130_fd_sc_hd__fill_1
XTAP_TAPCELL_ROW_96_1337 VGND VPWR sky130_fd_sc_hd__tapvpwrvgnd_1
XFILLER_0_41_649 VGND VGND VPWR VPWR sky130_fd_sc_hd__decap_3
X_4380_ _3479_ _3484_ _3488_ _3343_ _3489_ VGND VGND VPWR VPWR _3490_ sky130_fd_sc_hd__o221a_1
XFILLER_0_21_373 VPWR VGND VPWR VGND sky130_ef_sc_hd__decap_12
XFILLER_0_0_289 VGND VGND VPWR VPWR sky130_fd_sc_hd__fill_1
X_6050_ _1422_ _1423_ _1393_ _1394_ VGND VGND VPWR VPWR _1426_ sky130_fd_sc_hd__o211a_1
X_5001_ _3545_ _0102_ _0281_ _3371_ VGND VGND VPWR VPWR _0282_ sky130_fd_sc_hd__o2bb2a_1
XFILLER_0_56_98 VGND VGND VPWR VPWR sky130_fd_sc_hd__decap_4
X_6952_ _2264_ _2273_ VGND VGND VPWR VPWR _2412_ sky130_fd_sc_hd__nand2_1
XTAP_TAPCELL_ROW_105_1444 VGND VPWR sky130_fd_sc_hd__tapvpwrvgnd_1
X_6883_ _2333_ _2334_ _2335_ VGND VGND VPWR VPWR _2336_ sky130_fd_sc_hd__nand3_2
XFILLER_0_72_75 VGND VGND VPWR VPWR sky130_fd_sc_hd__decap_8
XTAP_TAPCELL_ROW_24_508 VGND VPWR sky130_fd_sc_hd__tapvpwrvgnd_1
X_5903_ _1155_ _1237_ _1263_ _1264_ VGND VGND VPWR VPWR _1265_ sky130_fd_sc_hd__a211oi_2
XFILLER_0_48_204 VGND VGND VPWR VPWR sky130_fd_sc_hd__decap_4
XFILLER_0_76_557 VPWR VGND VPWR VGND sky130_ef_sc_hd__decap_12
XFILLER_0_72_97 VGND VGND VPWR VPWR sky130_fd_sc_hd__decap_6
X_5834_ _1189_ _1188_ _1169_ VGND VGND VPWR VPWR _1190_ sky130_fd_sc_hd__and3_1
XTAP_TAPCELL_ROW_52_839 VGND VPWR sky130_fd_sc_hd__tapvpwrvgnd_1
XFILLER_0_91_505 VPWR VGND VPWR VGND sky130_ef_sc_hd__decap_12
XFILLER_0_29_473 VGND VGND VPWR VPWR sky130_fd_sc_hd__decap_8
XFILLER_0_106_309 VGND VGND VPWR VPWR sky130_fd_sc_hd__fill_2
X_5765_ _0984_ _1113_ VGND VGND VPWR VPWR _1114_ sky130_fd_sc_hd__or2_1
XFILLER_0_44_421 VGND VGND VPWR VPWR sky130_fd_sc_hd__decap_4
XFILLER_0_44_432 VGND VGND VPWR VPWR sky130_fd_sc_hd__fill_2
XFILLER_0_98_3 VPWR VGND VPWR VGND sky130_ef_sc_hd__decap_12
XFILLER_0_71_240 VGND VGND VPWR VPWR sky130_fd_sc_hd__fill_2
X_7504_ _2817_ _2825_ VGND VGND VPWR VPWR _3016_ sky130_fd_sc_hd__or2b_1
XFILLER_0_8_389 VPWR VGND VPWR VGND sky130_ef_sc_hd__decap_12
X_5696_ _1037_ _1038_ VGND VGND VPWR VPWR _1039_ sky130_fd_sc_hd__nor2_1
XFILLER_0_16_156 VGND VGND VPWR VPWR sky130_fd_sc_hd__decap_8
X_4716_ _3818_ _3819_ VGND VGND VPWR VPWR _3820_ sky130_fd_sc_hd__xnor2_1
X_7435_ _2938_ _2939_ VGND VGND VPWR VPWR _2940_ sky130_fd_sc_hd__or2_1
X_4647_ _3326_ _3358_ _3751_ _2430_ VGND VGND VPWR VPWR _3752_ sky130_fd_sc_hd__o22a_1
X_7366_ _0097_ _2862_ _2863_ _0378_ VGND VGND VPWR VPWR _2864_ sky130_fd_sc_hd__o22a_1
X_4578_ _3682_ _3683_ VGND VGND VPWR VPWR _3684_ sky130_fd_sc_hd__nor2_1
X_6317_ _1702_ _1703_ _1715_ VGND VGND VPWR VPWR _1717_ sky130_fd_sc_hd__and3_1
XFILLER_0_97_94 VPWR VGND VPWR VGND sky130_ef_sc_hd__decap_12
X_7297_ _2775_ _2776_ _2787_ VGND VGND VPWR VPWR _2789_ sky130_fd_sc_hd__and3_1
X_6248_ _1497_ _1640_ _1641_ VGND VGND VPWR VPWR _1642_ sky130_fd_sc_hd__nand3_1
X_6179_ _1449_ _1450_ _1484_ _1485_ VGND VGND VPWR VPWR _1567_ sky130_fd_sc_hd__nor4_2
XFILLER_0_99_649 VGND VGND VPWR VPWR sky130_fd_sc_hd__decap_3
XTAP_TAPCELL_ROW_4_288 VGND VPWR sky130_fd_sc_hd__tapvpwrvgnd_1
XTAP_TAPCELL_ROW_4_277 VGND VPWR sky130_fd_sc_hd__tapvpwrvgnd_1
XFILLER_0_79_384 VGND VGND VPWR VPWR sky130_fd_sc_hd__fill_1
XFILLER_0_67_524 VPWR VGND VPWR VGND sky130_ef_sc_hd__decap_12
XFILLER_0_39_215 VGND VGND VPWR VPWR sky130_fd_sc_hd__decap_8
XFILLER_0_39_237 VGND VGND VPWR VPWR sky130_fd_sc_hd__decap_8
XFILLER_0_109_125 VPWR VGND VPWR VGND sky130_ef_sc_hd__decap_12
XFILLER_0_109_169 VPWR VGND VPWR VGND sky130_ef_sc_hd__decap_12
XFILLER_0_109_158 VGND VGND VPWR VPWR sky130_fd_sc_hd__decap_8
XFILLER_0_47_281 VGND VGND VPWR VPWR sky130_fd_sc_hd__decap_8
XFILLER_0_35_443 VGND VGND VPWR VPWR sky130_fd_sc_hd__fill_1
XFILLER_0_35_465 VGND VGND VPWR VPWR sky130_fd_sc_hd__decap_8
XFILLER_0_105_353 VGND VGND VPWR VPWR sky130_fd_sc_hd__decap_8
XFILLER_0_90_593 VPWR VGND VPWR VGND sky130_ef_sc_hd__decap_12
XFILLER_0_62_273 VGND VGND VPWR VPWR sky130_fd_sc_hd__decap_8
XFILLER_0_22_115 VPWR VGND VPWR VGND sky130_ef_sc_hd__decap_12
XFILLER_0_23_649 VGND VGND VPWR VPWR sky130_fd_sc_hd__decap_3
XFILLER_0_50_413 VGND VGND VPWR VPWR sky130_fd_sc_hd__decap_6
XFILLER_0_105_386 VGND VGND VPWR VPWR sky130_fd_sc_hd__decap_6
XTAP_TAPCELL_ROW_91_1278 VGND VPWR sky130_fd_sc_hd__tapvpwrvgnd_1
XFILLER_0_89_148 VPWR VGND VPWR VGND sky130_ef_sc_hd__decap_12
XPHY_EDGE_ROW_11_Left_121 VGND VGND VPWR VPWR sky130_fd_sc_hd__decap_3
XFILLER_0_58_557 VGND VGND VPWR VPWR sky130_fd_sc_hd__fill_2
X_3880_ _0420_ _0431_ VGND VGND VPWR VPWR _0442_ sky130_fd_sc_hd__nor2b_2
XFILLER_0_73_505 VGND VGND VPWR VPWR sky130_fd_sc_hd__decap_3
XFILLER_0_42_67 VGND VGND VPWR VPWR sky130_fd_sc_hd__decap_8
XFILLER_0_26_421 VGND VGND VPWR VPWR sky130_fd_sc_hd__fill_2
XFILLER_0_26_432 VGND VGND VPWR VPWR sky130_fd_sc_hd__decap_8
XFILLER_0_38_281 VGND VGND VPWR VPWR sky130_fd_sc_hd__fill_2
XTAP_TAPCELL_ROW_100_1385 VGND VPWR sky130_fd_sc_hd__tapvpwrvgnd_1
X_5550_ _0766_ _0768_ _0877_ _0879_ VGND VGND VPWR VPWR _0880_ sky130_fd_sc_hd__a211oi_2
XFILLER_0_5_337 VGND VGND VPWR VPWR sky130_fd_sc_hd__decap_8
X_4501_ _2780_ _3605_ _3608_ VGND VGND VPWR VPWR _3609_ sky130_fd_sc_hd__o21a_1
X_5481_ _0801_ _0800_ _0803_ VGND VGND VPWR VPWR _0805_ sky130_fd_sc_hd__a21o_1
XFILLER_0_14_638 VGND VGND VPWR VPWR sky130_fd_sc_hd__decap_6
X_4432_ _2944_ _3540_ VGND VGND VPWR VPWR _3541_ sky130_fd_sc_hd__and2_1
X_7220_ _2702_ _2704_ VGND VGND VPWR VPWR _2705_ sky130_fd_sc_hd__xnor2_1
XPHY_EDGE_ROW_20_Left_130 VGND VGND VPWR VPWR sky130_fd_sc_hd__decap_3
XFILLER_0_1_543 VGND VGND VPWR VPWR sky130_fd_sc_hd__fill_1
X_4363_ _3395_ _3466_ _3471_ VGND VGND VPWR VPWR _3473_ sky130_fd_sc_hd__a21o_1
X_7151_ _2436_ _2446_ VGND VGND VPWR VPWR _2630_ sky130_fd_sc_hd__and2b_1
X_4294_ _3354_ _3365_ VGND VGND VPWR VPWR _3405_ sky130_fd_sc_hd__nand2_4
X_7082_ _2536_ _2537_ _2553_ VGND VGND VPWR VPWR _2554_ sky130_fd_sc_hd__a21o_1
XFILLER_0_67_42 VGND VGND VPWR VPWR sky130_fd_sc_hd__decap_3
X_6102_ _1480_ _1481_ _1461_ VGND VGND VPWR VPWR _1483_ sky130_fd_sc_hd__a21oi_1
X_6033_ _1251_ _1258_ VGND VGND VPWR VPWR _1407_ sky130_fd_sc_hd__nand2_1
Xrebuffer12 _1973_ VGND VGND VPWR VPWR net130 sky130_fd_sc_hd__dlymetal6s2s_1
XFILLER_0_13_3 VPWR VGND VPWR VGND sky130_ef_sc_hd__decap_12
XTAP_TAPCELL_ROW_1_247 VGND VPWR sky130_fd_sc_hd__tapvpwrvgnd_1
Xrebuffer23 _1203_ VGND VGND VPWR VPWR net141 sky130_fd_sc_hd__clkbuf_1
XFILLER_0_107_81 VPWR VGND VPWR VGND sky130_ef_sc_hd__decap_12
XFILLER_0_88_170 VGND VGND VPWR VPWR sky130_fd_sc_hd__fill_1
X_6935_ _2238_ VGND VGND VPWR VPWR _2393_ sky130_fd_sc_hd__inv_2
XTAP_TAPCELL_ROW_37_666 VGND VPWR sky130_fd_sc_hd__tapvpwrvgnd_1
XFILLER_0_49_524 VGND VGND VPWR VPWR sky130_fd_sc_hd__decap_4
XFILLER_0_88_192 VGND VGND VPWR VPWR sky130_fd_sc_hd__decap_4
XTAP_TAPCELL_ROW_65_986 VGND VPWR sky130_fd_sc_hd__tapvpwrvgnd_1
XFILLER_0_49_535 VGND VGND VPWR VPWR sky130_fd_sc_hd__decap_8
X_6866_ _0617_ _1096_ _3512_ _2317_ _0848_ VGND VGND VPWR VPWR _2318_ sky130_fd_sc_hd__a221o_1
XFILLER_0_64_505 VPWR VGND VPWR VGND sky130_ef_sc_hd__decap_12
XFILLER_0_91_346 VGND VGND VPWR VPWR sky130_fd_sc_hd__decap_6
X_5817_ _3064_ _2605_ net124 net10 VGND VGND VPWR VPWR _1171_ sky130_fd_sc_hd__and4_1
XFILLER_0_29_281 VGND VGND VPWR VPWR sky130_fd_sc_hd__decap_8
X_6797_ _2217_ _2218_ _2240_ _2241_ VGND VGND VPWR VPWR _2242_ sky130_fd_sc_hd__or4_4
XFILLER_0_107_629 VPWR VGND VPWR VGND sky130_ef_sc_hd__decap_12
XFILLER_0_91_357 VGND VGND VPWR VPWR sky130_fd_sc_hd__decap_4
X_5748_ net117 VGND VGND VPWR VPWR _1096_ sky130_fd_sc_hd__clkbuf_4
XFILLER_0_8_197 VGND VGND VPWR VPWR sky130_fd_sc_hd__decap_4
XFILLER_0_44_251 VGND VGND VPWR VPWR sky130_fd_sc_hd__fill_1
XFILLER_0_72_571 VGND VGND VPWR VPWR sky130_fd_sc_hd__fill_1
XFILLER_0_44_273 VGND VGND VPWR VPWR sky130_fd_sc_hd__fill_1
X_5679_ _1004_ _1005_ _1019_ VGND VGND VPWR VPWR _1021_ sky130_fd_sc_hd__a21oi_2
X_7418_ _2744_ _2743_ VGND VGND VPWR VPWR _2921_ sky130_fd_sc_hd__and2b_1
X_7349_ _2844_ _2845_ VGND VGND VPWR VPWR _2847_ sky130_fd_sc_hd__xnor2_1
XTAP_TAPCELL_ROW_9_336 VGND VPWR sky130_fd_sc_hd__tapvpwrvgnd_1
XFILLER_0_102_389 VPWR VGND VPWR VGND sky130_ef_sc_hd__decap_12
XFILLER_0_99_446 VGND VGND VPWR VPWR sky130_fd_sc_hd__fill_2
XFILLER_0_95_641 VGND VGND VPWR VPWR sky130_fd_sc_hd__decap_8
XFILLER_0_79_181 VGND VGND VPWR VPWR sky130_fd_sc_hd__decap_8
XFILLER_0_67_321 VGND VGND VPWR VPWR sky130_fd_sc_hd__fill_1
XFILLER_0_55_505 VGND VGND VPWR VPWR sky130_fd_sc_hd__decap_3
XFILLER_0_103_39 VPWR VGND VPWR VGND sky130_ef_sc_hd__decap_12
XFILLER_0_12_15 VPWR VGND VPWR VGND sky130_ef_sc_hd__decap_12
XFILLER_0_82_357 VGND VGND VPWR VPWR sky130_fd_sc_hd__decap_6
XFILLER_0_106_651 VGND VGND VPWR VPWR sky130_fd_sc_hd__fill_1
XTAP_TAPCELL_ROW_93_1307 VGND VPWR sky130_fd_sc_hd__tapvpwrvgnd_1
XFILLER_0_2_307 VGND VGND VPWR VPWR sky130_fd_sc_hd__fill_1
XFILLER_0_50_210 VGND VGND VPWR VPWR sky130_fd_sc_hd__decap_4
XFILLER_0_11_608 VGND VGND VPWR VPWR sky130_fd_sc_hd__decap_8
XFILLER_0_50_265 VPWR VGND VPWR VGND sky130_ef_sc_hd__decap_12
Xoutput70 net70 VGND VGND VPWR VPWR result[10] sky130_fd_sc_hd__buf_2
Xoutput92 net92 VGND VGND VPWR VPWR result[30] sky130_fd_sc_hd__clkbuf_4
Xoutput81 net81 VGND VGND VPWR VPWR result[20] sky130_fd_sc_hd__clkbuf_4
XFILLER_0_53_22 VPWR VGND VPWR VGND sky130_ef_sc_hd__decap_12
XFILLER_0_58_321 VGND VGND VPWR VPWR sky130_fd_sc_hd__fill_1
XTAP_TAPCELL_ROW_34_625 VGND VPWR sky130_fd_sc_hd__tapvpwrvgnd_1
X_4981_ _0256_ _0258_ _0155_ _0221_ VGND VGND VPWR VPWR _0260_ sky130_fd_sc_hd__o211ai_2
XTAP_TAPCELL_ROW_102_1414 VGND VPWR sky130_fd_sc_hd__tapvpwrvgnd_1
XFILLER_0_85_140 VGND VGND VPWR VPWR sky130_fd_sc_hd__decap_4
X_3932_ _0998_ VGND VGND VPWR VPWR _1009_ sky130_fd_sc_hd__clkbuf_4
XTAP_TAPCELL_ROW_62_945 VGND VPWR sky130_fd_sc_hd__tapvpwrvgnd_1
XFILLER_0_58_365 VPWR VGND VPWR VGND sky130_ef_sc_hd__decap_12
X_6720_ _2006_ _2021_ VGND VGND VPWR VPWR _2158_ sky130_fd_sc_hd__and2_1
XFILLER_0_85_195 VPWR VGND VPWR VGND sky130_ef_sc_hd__decap_12
X_3863_ net50 VGND VGND VPWR VPWR _0257_ sky130_fd_sc_hd__buf_2
X_6651_ _2078_ _2079_ _2081_ VGND VGND VPWR VPWR _2083_ sky130_fd_sc_hd__a21o_1
XFILLER_0_6_613 VPWR VGND VPWR VGND sky130_ef_sc_hd__decap_12
X_5602_ _0812_ _0858_ _0935_ _0936_ VGND VGND VPWR VPWR _0937_ sky130_fd_sc_hd__a211o_1
X_6582_ _1853_ _1860_ VGND VGND VPWR VPWR _2007_ sky130_fd_sc_hd__nor2_1
XTAP_TAPCELL_ROW_14_393 VGND VPWR sky130_fd_sc_hd__tapvpwrvgnd_1
XFILLER_0_14_402 VPWR VGND VPWR VGND sky130_ef_sc_hd__decap_12
X_5533_ _2441_ net33 VGND VGND VPWR VPWR _0861_ sky130_fd_sc_hd__nand2_1
XFILLER_0_81_390 VGND VGND VPWR VPWR sky130_fd_sc_hd__fill_2
XFILLER_0_5_189 VGND VGND VPWR VPWR sky130_fd_sc_hd__decap_3
XFILLER_0_41_210 VPWR VGND VPWR VGND sky130_ef_sc_hd__decap_12
X_5464_ _0332_ _1566_ VGND VGND VPWR VPWR _0786_ sky130_fd_sc_hd__nand2_1
X_7203_ _0382_ _1509_ _2685_ VGND VGND VPWR VPWR _2686_ sky130_fd_sc_hd__a21oi_1
XFILLER_0_78_52 VGND VGND VPWR VPWR sky130_fd_sc_hd__decap_8
X_5395_ _0620_ _0591_ _0710_ VGND VGND VPWR VPWR _0711_ sky130_fd_sc_hd__or3_1
X_4415_ _3163_ VGND VGND VPWR VPWR _3524_ sky130_fd_sc_hd__buf_6
XFILLER_0_1_340 VGND VGND VPWR VPWR sky130_fd_sc_hd__decap_4
X_4346_ _3305_ _1850_ _3308_ VGND VGND VPWR VPWR _3457_ sky130_fd_sc_hd__mux2_1
X_7134_ _3406_ _0083_ _2454_ VGND VGND VPWR VPWR _2611_ sky130_fd_sc_hd__or3_1
XTAP_TAPCELL_ROW_6_306 VGND VPWR sky130_fd_sc_hd__tapvpwrvgnd_1
X_4277_ _3306_ net21 VGND VGND VPWR VPWR _3389_ sky130_fd_sc_hd__and2_2
X_7065_ _2372_ _2380_ VGND VGND VPWR VPWR _2535_ sky130_fd_sc_hd__and2_1
X_6016_ _1265_ _1267_ _1245_ VGND VGND VPWR VPWR _1388_ sky130_fd_sc_hd__o21ai_2
XFILLER_0_69_608 VGND VGND VPWR VPWR sky130_fd_sc_hd__fill_2
XTAP_TAPCELL_ROW_68_1022 VGND VPWR sky130_fd_sc_hd__tapvpwrvgnd_1
XFILLER_0_96_438 VGND VGND VPWR VPWR sky130_fd_sc_hd__decap_3
XFILLER_0_96_449 VGND VGND VPWR VPWR sky130_fd_sc_hd__fill_1
X_6918_ _1621_ _1162_ _0769_ _1807_ VGND VGND VPWR VPWR _2374_ sky130_fd_sc_hd__a22oi_1
XFILLER_0_37_505 VGND VGND VPWR VPWR sky130_fd_sc_hd__decap_6
XFILLER_0_64_324 VGND VGND VPWR VPWR sky130_fd_sc_hd__decap_3
X_6849_ _2136_ _2140_ _2298_ VGND VGND VPWR VPWR _2300_ sky130_fd_sc_hd__or3_1
XFILLER_0_17_240 VGND VGND VPWR VPWR sky130_fd_sc_hd__decap_6
XFILLER_0_17_273 VGND VGND VPWR VPWR sky130_fd_sc_hd__decap_6
XTAP_TAPCELL_ROW_79_1140 VGND VPWR sky130_fd_sc_hd__tapvpwrvgnd_1
XFILLER_0_60_541 VGND VGND VPWR VPWR sky130_fd_sc_hd__decap_6
XFILLER_0_32_210 VGND VGND VPWR VPWR sky130_fd_sc_hd__decap_4
XFILLER_0_32_221 VGND VGND VPWR VPWR sky130_fd_sc_hd__fill_1
XFILLER_0_102_120 VPWR VGND VPWR VGND sky130_ef_sc_hd__decap_12
XFILLER_0_20_416 VGND VGND VPWR VPWR sky130_fd_sc_hd__decap_4
XFILLER_0_60_596 VGND VGND VPWR VPWR sky130_fd_sc_hd__decap_4
XFILLER_0_20_438 VPWR VGND VPWR VGND sky130_ef_sc_hd__decap_12
XFILLER_0_32_298 VGND VGND VPWR VPWR sky130_fd_sc_hd__decap_8
XFILLER_0_102_175 VGND VGND VPWR VPWR sky130_fd_sc_hd__decap_3
XFILLER_0_2_3 VPWR VGND VPWR VGND sky130_ef_sc_hd__decap_12
XFILLER_0_87_449 VGND VGND VPWR VPWR sky130_fd_sc_hd__decap_4
XFILLER_0_83_600 VGND VGND VPWR VPWR sky130_fd_sc_hd__decap_4
XFILLER_0_55_335 VGND VGND VPWR VPWR sky130_fd_sc_hd__fill_1
XFILLER_0_36_582 VGND VGND VPWR VPWR sky130_fd_sc_hd__decap_6
XFILLER_0_70_338 VGND VGND VPWR VPWR sky130_fd_sc_hd__decap_4
XTAP_TAPCELL_ROW_11_363 VGND VPWR sky130_fd_sc_hd__tapvpwrvgnd_1
Xrebuffer3 _1625_ VGND VGND VPWR VPWR net121 sky130_fd_sc_hd__clkbuf_1
XFILLER_0_51_541 VGND VGND VPWR VPWR sky130_fd_sc_hd__decap_6
XFILLER_0_3_649 VGND VGND VPWR VPWR sky130_fd_sc_hd__decap_3
XFILLER_0_23_254 VPWR VGND VPWR VGND sky130_ef_sc_hd__decap_12
XFILLER_0_51_552 VGND VGND VPWR VPWR sky130_fd_sc_hd__fill_2
XFILLER_0_11_449 VPWR VGND VPWR VGND sky130_ef_sc_hd__decap_12
XFILLER_0_11_438 VGND VGND VPWR VPWR sky130_fd_sc_hd__decap_8
XFILLER_0_51_585 VGND VGND VPWR VPWR sky130_fd_sc_hd__fill_1
X_4200_ _3311_ VGND VGND VPWR VPWR _3312_ sky130_fd_sc_hd__buf_6
X_5180_ _0473_ _0474_ _0476_ VGND VGND VPWR VPWR _0477_ sky130_fd_sc_hd__nand3_2
X_4131_ net11 VGND VGND VPWR VPWR _3185_ sky130_fd_sc_hd__buf_6
X_4062_ _2408_ _2419_ VGND VGND VPWR VPWR _2430_ sky130_fd_sc_hd__nor2_2
XFILLER_0_3_57 VPWR VGND VPWR VGND sky130_ef_sc_hd__decap_12
XTAP_TAPCELL_ROW_19_452 VGND VPWR sky130_fd_sc_hd__tapvpwrvgnd_1
XTAP_TAPCELL_ROW_47_772 VGND VPWR sky130_fd_sc_hd__tapvpwrvgnd_1
X_4964_ net132 _0240_ VGND VGND VPWR VPWR _0241_ sky130_fd_sc_hd__nand2_1
XFILLER_0_86_493 VGND VGND VPWR VPWR sky130_fd_sc_hd__fill_1
X_3915_ _0780_ _0813_ VGND VGND VPWR VPWR _0824_ sky130_fd_sc_hd__nor2_1
X_6703_ _1963_ _1975_ _2138_ VGND VGND VPWR VPWR _2140_ sky130_fd_sc_hd__a21oi_1
X_7683_ _3463_ net55 VGND VGND VPWR VPWR _3212_ sky130_fd_sc_hd__nand2_1
XFILLER_0_80_97 VGND VGND VPWR VPWR sky130_fd_sc_hd__decap_3
X_4895_ _0164_ _0165_ _0033_ VGND VGND VPWR VPWR _0166_ sky130_fd_sc_hd__nor3b_2
X_3846_ net20 VGND VGND VPWR VPWR _0072_ sky130_fd_sc_hd__buf_2
XFILLER_0_73_165 VGND VGND VPWR VPWR sky130_fd_sc_hd__decap_3
XFILLER_0_61_305 VGND VGND VPWR VPWR sky130_fd_sc_hd__fill_1
XFILLER_0_6_421 VPWR VGND VPWR VGND sky130_ef_sc_hd__decap_12
XFILLER_0_27_571 VPWR VGND VPWR VGND sky130_ef_sc_hd__decap_12
X_6634_ _2867_ _2977_ _0922_ net14 VGND VGND VPWR VPWR _2064_ sky130_fd_sc_hd__nand4_1
X_6565_ _0015_ _1985_ _1988_ _0011_ VGND VGND VPWR VPWR _1989_ sky130_fd_sc_hd__a22o_1
XFILLER_0_89_51 VGND VGND VPWR VPWR sky130_fd_sc_hd__decap_4
XFILLER_0_80_3 VGND VGND VPWR VPWR sky130_fd_sc_hd__decap_4
X_5516_ _0605_ _0841_ _0842_ VGND VGND VPWR VPWR _0843_ sky130_fd_sc_hd__mux2_1
XFILLER_0_14_265 VPWR VGND VPWR VGND sky130_ef_sc_hd__decap_12
X_6496_ _3032_ net15 VGND VGND VPWR VPWR _1913_ sky130_fd_sc_hd__nand2_1
X_5447_ _0763_ _0764_ _0765_ VGND VGND VPWR VPWR _0767_ sky130_fd_sc_hd__a21o_1
X_5378_ _0651_ _0652_ _0690_ _0691_ VGND VGND VPWR VPWR _0692_ sky130_fd_sc_hd__and4_4
XFILLER_0_10_471 VGND VGND VPWR VPWR sky130_fd_sc_hd__decap_4
X_4329_ _3430_ _3439_ _3394_ VGND VGND VPWR VPWR _3440_ sky130_fd_sc_hd__mux2_1
XTAP_TAPCELL_ROW_74_1092 VGND VPWR sky130_fd_sc_hd__tapvpwrvgnd_1
X_7117_ _2580_ _2581_ _2591_ VGND VGND VPWR VPWR _2592_ sky130_fd_sc_hd__a21oi_2
X_7048_ _2336_ _2344_ _2514_ VGND VGND VPWR VPWR _2516_ sky130_fd_sc_hd__and3_1
XFILLER_0_69_405 VPWR VGND VPWR VGND sky130_ef_sc_hd__decap_12
XFILLER_0_69_449 VPWR VGND VPWR VGND sky130_ef_sc_hd__decap_12
XFILLER_0_77_460 VGND VGND VPWR VPWR sky130_fd_sc_hd__fill_1
XFILLER_0_37_335 VGND VGND VPWR VPWR sky130_fd_sc_hd__fill_1
XFILLER_0_92_474 VGND VGND VPWR VPWR sky130_fd_sc_hd__fill_2
XFILLER_0_80_625 VPWR VGND VPWR VGND sky130_ef_sc_hd__decap_12
XFILLER_0_64_165 VGND VGND VPWR VPWR sky130_fd_sc_hd__decap_8
XFILLER_0_9_281 VGND VGND VPWR VPWR sky130_fd_sc_hd__decap_6
XFILLER_0_18_560 VGND VGND VPWR VPWR sky130_fd_sc_hd__fill_1
XFILLER_0_37_379 VGND VGND VPWR VPWR sky130_fd_sc_hd__fill_1
XFILLER_0_64_187 VGND VGND VPWR VPWR sky130_fd_sc_hd__fill_1
XFILLER_0_100_29 VPWR VGND VPWR VGND sky130_ef_sc_hd__decap_12
XFILLER_0_33_585 VGND VGND VPWR VPWR sky130_fd_sc_hd__decap_8
XFILLER_0_20_257 VGND VGND VPWR VPWR sky130_fd_sc_hd__fill_1
XFILLER_0_109_27 VGND VGND VPWR VPWR sky130_fd_sc_hd__fill_1
XFILLER_0_34_24 VGND VGND VPWR VPWR sky130_fd_sc_hd__decap_4
XTAP_TAPCELL_ROW_16_422 VGND VPWR sky130_fd_sc_hd__tapvpwrvgnd_1
XTAP_TAPCELL_ROW_44_742 VGND VPWR sky130_fd_sc_hd__tapvpwrvgnd_1
XFILLER_0_55_176 VPWR VGND VPWR VGND sky130_ef_sc_hd__decap_12
XFILLER_0_28_379 VGND VGND VPWR VPWR sky130_fd_sc_hd__fill_1
XFILLER_0_43_305 VPWR VGND VPWR VGND sky130_ef_sc_hd__decap_12
XFILLER_0_50_67 VGND VGND VPWR VPWR sky130_fd_sc_hd__fill_2
X_4680_ _3781_ _3782_ _3783_ VGND VGND VPWR VPWR _3785_ sky130_fd_sc_hd__a21o_1
XFILLER_0_83_496 VGND VGND VPWR VPWR sky130_fd_sc_hd__fill_1
XFILLER_0_43_349 VGND VGND VPWR VPWR sky130_fd_sc_hd__decap_3
XTAP_TAPCELL_ROW_99_1379 VGND VPWR sky130_fd_sc_hd__tapvpwrvgnd_1
X_6350_ _0332_ _0758_ _1604_ _1603_ _1162_ VGND VGND VPWR VPWR _1754_ sky130_fd_sc_hd__a32o_1
XFILLER_0_3_424 VGND VGND VPWR VPWR sky130_fd_sc_hd__decap_4
XFILLER_0_24_563 VPWR VGND VPWR VGND sky130_ef_sc_hd__decap_12
X_5301_ _0110_ _0608_ _0197_ _3717_ VGND VGND VPWR VPWR _0609_ sky130_fd_sc_hd__o2bb2a_1
XFILLER_0_3_446 VGND VGND VPWR VPWR sky130_fd_sc_hd__fill_2
XFILLER_0_59_65 VGND VGND VPWR VPWR sky130_fd_sc_hd__fill_1
X_6281_ _1535_ _1676_ VGND VGND VPWR VPWR _1678_ sky130_fd_sc_hd__or2_1
X_5232_ _0531_ _0532_ VGND VGND VPWR VPWR _0533_ sky130_fd_sc_hd__xnor2_1
X_5163_ _3448_ _3622_ _0457_ _1643_ VGND VGND VPWR VPWR _0458_ sky130_fd_sc_hd__and4_1
X_4114_ _2933_ _2944_ _2988_ VGND VGND VPWR VPWR _2999_ sky130_fd_sc_hd__a21oi_1
XFILLER_0_75_64 VPWR VGND VPWR VGND sky130_ef_sc_hd__decap_12
X_5094_ _1960_ _1894_ _3360_ VGND VGND VPWR VPWR _0383_ sky130_fd_sc_hd__mux2_1
XPHY_EDGE_ROW_3_Left_113 VGND VGND VPWR VPWR sky130_fd_sc_hd__decap_3
X_4045_ _1173_ _1217_ VGND VGND VPWR VPWR _2244_ sky130_fd_sc_hd__or2b_1
XTAP_TAPCELL_ROW_108_1475 VGND VPWR sky130_fd_sc_hd__tapvpwrvgnd_1
XFILLER_0_78_213 VGND VGND VPWR VPWR sky130_fd_sc_hd__fill_1
X_5996_ _0843_ _1365_ _1366_ VGND VGND VPWR VPWR _1367_ sky130_fd_sc_hd__mux2_1
XFILLER_0_59_493 VGND VGND VPWR VPWR sky130_fd_sc_hd__decap_8
XFILLER_0_19_357 VGND VGND VPWR VPWR sky130_fd_sc_hd__decap_4
X_4947_ _3334_ _1741_ _0133_ _0132_ VGND VGND VPWR VPWR _0222_ sky130_fd_sc_hd__a31o_1
X_7666_ _3189_ _3192_ VGND VGND VPWR VPWR _3193_ sky130_fd_sc_hd__xnor2_1
XFILLER_0_74_485 VGND VGND VPWR VPWR sky130_fd_sc_hd__decap_3
XFILLER_0_74_474 VGND VGND VPWR VPWR sky130_fd_sc_hd__fill_2
X_4878_ _0144_ _0145_ _0143_ VGND VGND VPWR VPWR _0147_ sky130_fd_sc_hd__o21ai_1
XFILLER_0_62_636 VGND VGND VPWR VPWR sky130_fd_sc_hd__decap_8
XFILLER_0_61_135 VPWR VGND VPWR VGND sky130_ef_sc_hd__decap_12
XFILLER_0_34_327 VPWR VGND VPWR VGND sky130_ef_sc_hd__decap_12
X_6617_ _2069_ _1839_ _1665_ _0693_ VGND VGND VPWR VPWR _2045_ sky130_fd_sc_hd__a22o_1
XPHY_EDGE_ROW_49_Left_159 VGND VGND VPWR VPWR sky130_fd_sc_hd__decap_3
X_7597_ _1960_ _1304_ _1217_ _3316_ VGND VGND VPWR VPWR _3117_ sky130_fd_sc_hd__a22oi_1
XTAP_TAPCELL_ROW_76_1110 VGND VPWR sky130_fd_sc_hd__tapvpwrvgnd_1
XFILLER_0_42_360 VGND VGND VPWR VPWR sky130_fd_sc_hd__decap_4
X_6548_ _1645_ _1805_ _1806_ _1808_ VGND VGND VPWR VPWR _1970_ sky130_fd_sc_hd__a31oi_1
X_6479_ _1381_ _1533_ VGND VGND VPWR VPWR _1895_ sky130_fd_sc_hd__nand2_1
XFILLER_0_42_393 VGND VGND VPWR VPWR sky130_fd_sc_hd__fill_1
XPHY_EDGE_ROW_58_Left_168 VGND VGND VPWR VPWR sky130_fd_sc_hd__decap_3
XFILLER_0_69_202 VPWR VGND VPWR VGND sky130_ef_sc_hd__decap_12
XFILLER_0_69_257 VPWR VGND VPWR VGND sky130_ef_sc_hd__decap_12
XFILLER_0_69_279 VGND VGND VPWR VPWR sky130_fd_sc_hd__fill_1
XFILLER_0_38_611 VPWR VGND VPWR VGND sky130_ef_sc_hd__decap_12
XFILLER_0_77_290 VGND VGND VPWR VPWR sky130_fd_sc_hd__decap_4
XFILLER_0_65_441 VGND VGND VPWR VPWR sky130_fd_sc_hd__decap_6
XFILLER_0_37_110 VGND VGND VPWR VPWR sky130_fd_sc_hd__fill_2
XTAP_TAPCELL_ROW_41_712 VGND VPWR sky130_fd_sc_hd__tapvpwrvgnd_1
XFILLER_0_80_411 VGND VGND VPWR VPWR sky130_fd_sc_hd__decap_8
XPHY_EDGE_ROW_67_Left_177 VGND VGND VPWR VPWR sky130_fd_sc_hd__decap_3
XFILLER_0_65_463 VGND VGND VPWR VPWR sky130_fd_sc_hd__fill_1
XFILLER_0_25_305 VPWR VGND VPWR VGND sky130_ef_sc_hd__decap_12
XFILLER_0_108_576 VPWR VGND VPWR VGND sky130_ef_sc_hd__decap_12
XFILLER_0_20_15 VPWR VGND VPWR VGND sky130_ef_sc_hd__decap_12
XFILLER_0_53_647 VGND VGND VPWR VPWR sky130_fd_sc_hd__fill_1
XTAP_TAPCELL_ROW_21_480 VGND VPWR sky130_fd_sc_hd__tapvpwrvgnd_1
XFILLER_0_21_500 VGND VGND VPWR VPWR sky130_fd_sc_hd__decap_4
Xmax_cap109 _1564_ VGND VGND VPWR VPWR net109 sky130_fd_sc_hd__clkbuf_1
XFILLER_0_33_360 VPWR VGND VPWR VGND sky130_ef_sc_hd__decap_12
XFILLER_0_96_19 VGND VGND VPWR VPWR sky130_fd_sc_hd__decap_8
XFILLER_0_0_405 VPWR VGND VPWR VGND sky130_ef_sc_hd__decap_12
XFILLER_0_33_393 VGND VGND VPWR VPWR sky130_fd_sc_hd__decap_3
XFILLER_0_103_281 VGND VGND VPWR VPWR sky130_fd_sc_hd__decap_3
XPHY_EDGE_ROW_76_Left_186 VGND VGND VPWR VPWR sky130_fd_sc_hd__decap_3
XFILLER_0_29_57 VGND VGND VPWR VPWR sky130_fd_sc_hd__decap_8
XTAP_TAPCELL_ROW_49_801 VGND VPWR sky130_fd_sc_hd__tapvpwrvgnd_1
XFILLER_0_88_533 VPWR VGND VPWR VGND sky130_ef_sc_hd__decap_12
Xmax_cap1 _1002_ VGND VGND VPWR VPWR net150 sky130_fd_sc_hd__clkbuf_1
XFILLER_0_88_599 VGND VGND VPWR VPWR sky130_fd_sc_hd__decap_3
XPHY_EDGE_ROW_85_Left_195 VGND VGND VPWR VPWR sky130_fd_sc_hd__decap_3
XFILLER_0_75_205 VGND VGND VPWR VPWR sky130_fd_sc_hd__fill_1
XFILLER_0_29_611 VGND VGND VPWR VPWR sky130_fd_sc_hd__decap_4
XFILLER_0_48_419 VGND VGND VPWR VPWR sky130_fd_sc_hd__fill_1
X_5850_ _1207_ _1205_ _1071_ VGND VGND VPWR VPWR _1208_ sky130_fd_sc_hd__and3_4
XFILLER_0_61_77 VPWR VGND VPWR VGND sky130_ef_sc_hd__decap_12
XFILLER_0_0_69 VPWR VGND VPWR VGND sky130_ef_sc_hd__decap_12
X_5781_ _1021_ _1023_ _1130_ _1131_ VGND VGND VPWR VPWR _1132_ sky130_fd_sc_hd__o211a_1
XFILLER_0_28_132 VGND VGND VPWR VPWR sky130_fd_sc_hd__decap_8
X_4801_ _3820_ _3828_ _3827_ VGND VGND VPWR VPWR _0064_ sky130_fd_sc_hd__a21bo_1
X_7520_ _3030_ _3031_ _3015_ _3016_ VGND VGND VPWR VPWR _3034_ sky130_fd_sc_hd__o211a_1
XFILLER_0_56_463 VGND VGND VPWR VPWR sky130_fd_sc_hd__fill_1
X_4732_ _3789_ _3791_ _3834_ _3835_ VGND VGND VPWR VPWR _3836_ sky130_fd_sc_hd__a211oi_2
XFILLER_0_71_444 VGND VGND VPWR VPWR sky130_fd_sc_hd__fill_1
X_7451_ _1577_ _1304_ _1217_ _1949_ VGND VGND VPWR VPWR _2958_ sky130_fd_sc_hd__a22oi_1
X_4663_ _3766_ _3767_ VGND VGND VPWR VPWR _3768_ sky130_fd_sc_hd__and2b_1
XFILLER_0_16_349 VPWR VGND VPWR VGND sky130_ef_sc_hd__decap_12
XFILLER_0_43_113 VGND VGND VPWR VPWR sky130_fd_sc_hd__fill_1
XFILLER_0_43_124 VPWR VGND VPWR VGND sky130_ef_sc_hd__decap_12
XFILLER_0_31_308 VPWR VGND VPWR VGND sky130_ef_sc_hd__decap_12
X_6402_ _1647_ _1649_ _1645_ VGND VGND VPWR VPWR _1811_ sky130_fd_sc_hd__a21oi_1
X_7382_ _2705_ _2710_ VGND VGND VPWR VPWR _2882_ sky130_fd_sc_hd__nand2_1
X_4594_ _3697_ _3698_ _3689_ VGND VGND VPWR VPWR _3700_ sky130_fd_sc_hd__a21o_1
XFILLER_0_12_533 VGND VGND VPWR VPWR sky130_fd_sc_hd__fill_2
XFILLER_0_10_70 VPWR VGND VPWR VGND sky130_ef_sc_hd__decap_12
X_6333_ net145 _0457_ _0433_ _0093_ VGND VGND VPWR VPWR _1735_ sky130_fd_sc_hd__and4_1
X_6264_ _0889_ _1096_ VGND VGND VPWR VPWR _1660_ sky130_fd_sc_hd__nand2_1
XFILLER_0_10_92 VPWR VGND VPWR VGND sky130_ef_sc_hd__decap_12
X_5215_ _0512_ _0513_ VGND VGND VPWR VPWR _0514_ sky130_fd_sc_hd__and2_1
XFILLER_0_86_85 VPWR VGND VPWR VGND sky130_ef_sc_hd__decap_12
XTAP_TAPCELL_ROW_71_1051 VGND VPWR sky130_fd_sc_hd__tapvpwrvgnd_1
X_6195_ _1576_ _1583_ VGND VGND VPWR VPWR _1584_ sky130_fd_sc_hd__xnor2_1
XFILLER_0_43_3 VPWR VGND VPWR VGND sky130_ef_sc_hd__decap_12
X_5146_ _0437_ _0438_ VGND VGND VPWR VPWR _0439_ sky130_fd_sc_hd__xnor2_1
X_5077_ _0263_ _0265_ _0362_ _0363_ VGND VGND VPWR VPWR _0364_ sky130_fd_sc_hd__a211o_1
X_4028_ _2047_ VGND VGND VPWR VPWR _2058_ sky130_fd_sc_hd__clkbuf_4
XFILLER_0_94_525 VGND VGND VPWR VPWR sky130_fd_sc_hd__decap_6
X_5979_ _0855_ _0948_ _0946_ VGND VGND VPWR VPWR _1349_ sky130_fd_sc_hd__a21oi_1
X_7718_ _0355_ _0464_ _0475_ _0344_ VGND VGND VPWR VPWR _3247_ sky130_fd_sc_hd__or4_1
XTAP_TAPCELL_ROW_82_1180 VGND VPWR sky130_fd_sc_hd__tapvpwrvgnd_1
XFILLER_0_35_614 VGND VGND VPWR VPWR sky130_fd_sc_hd__fill_2
XFILLER_0_34_102 VPWR VGND VPWR VGND sky130_ef_sc_hd__decap_12
XFILLER_0_47_496 VGND VGND VPWR VPWR sky130_fd_sc_hd__decap_8
XFILLER_0_105_535 VGND VGND VPWR VPWR sky130_fd_sc_hd__fill_1
X_7649_ _3166_ _3173_ VGND VGND VPWR VPWR _3175_ sky130_fd_sc_hd__xnor2_1
XFILLER_0_62_477 VGND VGND VPWR VPWR sky130_fd_sc_hd__fill_2
XFILLER_0_105_546 VGND VGND VPWR VPWR sky130_fd_sc_hd__decap_6
XFILLER_0_15_382 VGND VGND VPWR VPWR sky130_fd_sc_hd__decap_8
XFILLER_0_100_240 VGND VGND VPWR VPWR sky130_fd_sc_hd__decap_4
XFILLER_0_100_273 VGND VGND VPWR VPWR sky130_fd_sc_hd__decap_3
XTAP_TAPCELL_ROW_85_1209 VGND VPWR sky130_fd_sc_hd__tapvpwrvgnd_1
XFILLER_0_15_15 VPWR VGND VPWR VGND sky130_ef_sc_hd__decap_12
XFILLER_0_57_216 VGND VGND VPWR VPWR sky130_fd_sc_hd__decap_8
XFILLER_0_53_400 VPWR VGND VPWR VGND sky130_ef_sc_hd__decap_12
XFILLER_0_65_293 VPWR VGND VPWR VGND sky130_ef_sc_hd__decap_12
XFILLER_0_25_113 VPWR VGND VPWR VGND sky130_ef_sc_hd__decap_12
XFILLER_0_31_69 VGND VGND VPWR VPWR sky130_fd_sc_hd__decap_3
XFILLER_0_41_617 VGND VGND VPWR VPWR sky130_fd_sc_hd__fill_2
XTAP_TAPCELL_ROW_96_1338 VGND VPWR sky130_fd_sc_hd__tapvpwrvgnd_1
XFILLER_0_21_330 VGND VGND VPWR VPWR sky130_fd_sc_hd__decap_6
XFILLER_0_0_279 VGND VGND VPWR VPWR sky130_fd_sc_hd__fill_1
XFILLER_0_21_385 VGND VGND VPWR VPWR sky130_fd_sc_hd__decap_6
X_5000_ _3396_ _3534_ _0280_ VGND VGND VPWR VPWR _0281_ sky130_fd_sc_hd__o21a_1
XPHY_EDGE_ROW_93_Left_203 VGND VGND VPWR VPWR sky130_fd_sc_hd__decap_3
XFILLER_0_88_330 VPWR VGND VPWR VGND sky130_ef_sc_hd__decap_12
X_6951_ _2267_ _2272_ VGND VGND VPWR VPWR _2411_ sky130_fd_sc_hd__nand2_1
XTAP_TAPCELL_ROW_105_1445 VGND VPWR sky130_fd_sc_hd__tapvpwrvgnd_1
XFILLER_0_88_385 VPWR VGND VPWR VGND sky130_ef_sc_hd__decap_12
XFILLER_0_88_363 VGND VGND VPWR VPWR sky130_fd_sc_hd__fill_1
XTAP_TAPCELL_ROW_24_509 VGND VPWR sky130_fd_sc_hd__tapvpwrvgnd_1
X_5902_ _1261_ _1262_ _1247_ VGND VGND VPWR VPWR _1264_ sky130_fd_sc_hd__o21a_1
X_6882_ _2186_ _2187_ _2185_ VGND VGND VPWR VPWR _2335_ sky130_fd_sc_hd__o21bai_2
XFILLER_0_76_569 VPWR VGND VPWR VGND sky130_ef_sc_hd__decap_12
X_5833_ _1186_ _1185_ _1187_ VGND VGND VPWR VPWR _1189_ sky130_fd_sc_hd__a21o_1
XTAP_TAPCELL_ROW_52_829 VGND VPWR sky130_fd_sc_hd__tapvpwrvgnd_1
XFILLER_0_91_517 VGND VGND VPWR VPWR sky130_fd_sc_hd__decap_6
XFILLER_0_8_324 VGND VGND VPWR VPWR sky130_fd_sc_hd__decap_8
X_7503_ _2818_ _2823_ VGND VGND VPWR VPWR _3015_ sky130_fd_sc_hd__or2b_1
X_5764_ _3185_ _1282_ VGND VGND VPWR VPWR _1113_ sky130_fd_sc_hd__nand2_1
X_5695_ _3622_ net145 net9 _3448_ VGND VGND VPWR VPWR _1038_ sky130_fd_sc_hd__a22oi_1
XFILLER_0_44_466 VGND VGND VPWR VPWR sky130_fd_sc_hd__decap_4
X_4715_ _2758_ _3450_ VGND VGND VPWR VPWR _3819_ sky130_fd_sc_hd__xor2_1
X_7434_ _2929_ _2937_ VGND VGND VPWR VPWR _2939_ sky130_fd_sc_hd__nor2_1
X_4646_ _3405_ VGND VGND VPWR VPWR _3751_ sky130_fd_sc_hd__buf_2
XFILLER_0_21_91 VPWR VGND VPWR VGND sky130_ef_sc_hd__decap_12
XFILLER_0_31_105 VGND VGND VPWR VPWR sky130_fd_sc_hd__decap_6
XFILLER_0_102_505 VGND VGND VPWR VPWR sky130_fd_sc_hd__fill_1
X_7365_ net23 net54 VGND VGND VPWR VPWR _2863_ sky130_fd_sc_hd__nand2_1
X_4577_ _3328_ _2517_ _3620_ _3681_ VGND VGND VPWR VPWR _3683_ sky130_fd_sc_hd__a211oi_1
Xfanout3 _3075_ VGND VGND VPWR VPWR net152 sky130_fd_sc_hd__buf_8
XFILLER_0_97_62 VGND VGND VPWR VPWR sky130_fd_sc_hd__fill_2
X_6316_ _1702_ _1703_ _1715_ VGND VGND VPWR VPWR _1716_ sky130_fd_sc_hd__a21oi_2
X_7296_ _2775_ _2776_ _2787_ VGND VGND VPWR VPWR _2788_ sky130_fd_sc_hd__a21oi_1
X_6247_ _1638_ _1639_ _1388_ VGND VGND VPWR VPWR _1641_ sky130_fd_sc_hd__o21ai_1
X_6178_ _1562_ _1563_ _1531_ VGND VGND VPWR VPWR _1565_ sky130_fd_sc_hd__o21a_1
XFILLER_0_99_617 VPWR VGND VPWR VGND sky130_ef_sc_hd__decap_12
X_5129_ _0218_ _0360_ _0361_ VGND VGND VPWR VPWR _0421_ sky130_fd_sc_hd__nand3_1
XFILLER_0_98_127 VGND VGND VPWR VPWR sky130_fd_sc_hd__decap_8
XTAP_TAPCELL_ROW_4_278 VGND VPWR sky130_fd_sc_hd__tapvpwrvgnd_1
XFILLER_0_98_149 VGND VGND VPWR VPWR sky130_fd_sc_hd__decap_8
XFILLER_0_79_330 VGND VGND VPWR VPWR sky130_fd_sc_hd__decap_6
XFILLER_0_67_503 VGND VGND VPWR VPWR sky130_fd_sc_hd__fill_1
XFILLER_0_67_547 VPWR VGND VPWR VGND sky130_ef_sc_hd__decap_12
XFILLER_0_67_536 VGND VGND VPWR VPWR sky130_fd_sc_hd__decap_4
XFILLER_0_109_137 VGND VGND VPWR VPWR sky130_fd_sc_hd__decap_3
XFILLER_0_94_355 VGND VGND VPWR VPWR sky130_fd_sc_hd__decap_8
XFILLER_0_105_343 VGND VGND VPWR VPWR sky130_fd_sc_hd__fill_1
XFILLER_0_23_617 VPWR VGND VPWR VGND sky130_ef_sc_hd__decap_12
XFILLER_0_22_127 VGND VGND VPWR VPWR sky130_fd_sc_hd__decap_6
XFILLER_0_30_160 VPWR VGND VPWR VGND sky130_ef_sc_hd__decap_12
XTAP_TAPCELL_ROW_91_1279 VGND VPWR sky130_fd_sc_hd__tapvpwrvgnd_1
XFILLER_0_89_105 VGND VGND VPWR VPWR sky130_fd_sc_hd__decap_6
XFILLER_0_45_208 VPWR VGND VPWR VGND sky130_ef_sc_hd__decap_12
XTAP_TAPCELL_ROW_100_1386 VGND VPWR sky130_fd_sc_hd__tapvpwrvgnd_1
XFILLER_0_5_305 VPWR VGND VPWR VGND sky130_ef_sc_hd__decap_12
X_4500_ _3606_ _3607_ VGND VGND VPWR VPWR _3608_ sky130_fd_sc_hd__nor2_1
XFILLER_0_13_105 VGND VGND VPWR VPWR sky130_fd_sc_hd__decap_6
X_5480_ _0800_ _0801_ _0803_ VGND VGND VPWR VPWR _0804_ sky130_fd_sc_hd__nand3_4
X_4431_ _3538_ _3539_ _3319_ VGND VGND VPWR VPWR _3540_ sky130_fd_sc_hd__mux2_1
XFILLER_0_101_3 VPWR VGND VPWR VGND sky130_ef_sc_hd__decap_12
XANTENNA_1 _0419_ VGND VGND VPWR VPWR sky130_fd_sc_hd__diode_2
XFILLER_0_41_447 VGND VGND VPWR VPWR sky130_fd_sc_hd__fill_1
X_4362_ _3396_ _3467_ _3471_ VGND VGND VPWR VPWR _3472_ sky130_fd_sc_hd__a21oi_1
X_7150_ _2625_ _2626_ _2612_ _2613_ VGND VGND VPWR VPWR _2629_ sky130_fd_sc_hd__o211a_1
X_4293_ _3330_ _3345_ _3289_ VGND VGND VPWR VPWR _3404_ sky130_fd_sc_hd__or3_1
X_7081_ _2551_ _2552_ VGND VGND VPWR VPWR _2553_ sky130_fd_sc_hd__or2_1
X_6101_ _1481_ _1480_ _1461_ VGND VGND VPWR VPWR _1482_ sky130_fd_sc_hd__and3_1
X_6032_ _1252_ _1257_ VGND VGND VPWR VPWR _1406_ sky130_fd_sc_hd__or2b_1
XTAP_TAPCELL_ROW_1_248 VGND VPWR sky130_fd_sc_hd__tapvpwrvgnd_1
Xrebuffer13 _0913_ VGND VGND VPWR VPWR net131 sky130_fd_sc_hd__buf_6
XFILLER_0_107_93 VPWR VGND VPWR VGND sky130_ef_sc_hd__decap_12
XTAP_TAPCELL_ROW_37_667 VGND VPWR sky130_fd_sc_hd__tapvpwrvgnd_1
X_6934_ _2278_ VGND VGND VPWR VPWR _2392_ sky130_fd_sc_hd__inv_2
XFILLER_0_49_503 VGND VGND VPWR VPWR sky130_fd_sc_hd__fill_1
XTAP_TAPCELL_ROW_65_987 VGND VPWR sky130_fd_sc_hd__tapvpwrvgnd_1
XFILLER_0_9_600 VPWR VGND VPWR VGND sky130_ef_sc_hd__decap_12
X_6865_ _0105_ _0116_ VGND VGND VPWR VPWR _2317_ sky130_fd_sc_hd__and2_1
XFILLER_0_76_355 VGND VGND VPWR VPWR sky130_fd_sc_hd__decap_3
XFILLER_0_64_517 VPWR VGND VPWR VGND sky130_ef_sc_hd__decap_12
XFILLER_0_76_388 VGND VGND VPWR VPWR sky130_fd_sc_hd__fill_1
X_5816_ net58 _1457_ VGND VGND VPWR VPWR _1170_ sky130_fd_sc_hd__nand2_1
XFILLER_0_8_154 VPWR VGND VPWR VGND sky130_ef_sc_hd__decap_12
X_6796_ _2238_ _2239_ _2219_ _2220_ VGND VGND VPWR VPWR _2241_ sky130_fd_sc_hd__a211oi_1
X_5747_ _1184_ _0376_ _1094_ _1249_ _0717_ VGND VGND VPWR VPWR _1095_ sky130_fd_sc_hd__o221a_1
XFILLER_0_8_176 VPWR VGND VPWR VGND sky130_ef_sc_hd__decap_12
XFILLER_0_44_263 VGND VGND VPWR VPWR sky130_fd_sc_hd__decap_3
X_7417_ _2918_ _2919_ VGND VGND VPWR VPWR _2920_ sky130_fd_sc_hd__or2b_1
X_5678_ _1011_ _1018_ VGND VGND VPWR VPWR _1019_ sky130_fd_sc_hd__xnor2_1
XFILLER_0_32_447 VGND VGND VPWR VPWR sky130_fd_sc_hd__decap_8
X_4629_ _3713_ _3720_ _3730_ _3734_ VGND VGND VPWR VPWR _3735_ sky130_fd_sc_hd__or4b_1
X_7348_ _2637_ _2640_ VGND VGND VPWR VPWR _2845_ sky130_fd_sc_hd__and2b_1
XTAP_TAPCELL_ROW_9_337 VGND VPWR sky130_fd_sc_hd__tapvpwrvgnd_1
X_7279_ _2569_ _2573_ _2570_ VGND VGND VPWR VPWR _2770_ sky130_fd_sc_hd__o21ba_1
XFILLER_0_12_193 VGND VGND VPWR VPWR sky130_fd_sc_hd__decap_3
XFILLER_0_99_403 VGND VGND VPWR VPWR sky130_fd_sc_hd__fill_2
XFILLER_0_99_458 VPWR VGND VPWR VGND sky130_ef_sc_hd__decap_12
XFILLER_0_94_141 VPWR VGND VPWR VGND sky130_ef_sc_hd__decap_12
XFILLER_0_55_528 VPWR VGND VPWR VGND sky130_ef_sc_hd__decap_12
XFILLER_0_12_27 VGND VGND VPWR VPWR sky130_fd_sc_hd__fill_1
XFILLER_0_48_580 VGND VGND VPWR VPWR sky130_fd_sc_hd__decap_8
XFILLER_0_70_509 VGND VGND VPWR VPWR sky130_fd_sc_hd__decap_3
XFILLER_0_63_561 VPWR VGND VPWR VGND sky130_ef_sc_hd__decap_12
XTAP_TAPCELL_ROW_93_1308 VGND VPWR sky130_fd_sc_hd__tapvpwrvgnd_1
XFILLER_0_50_244 VGND VGND VPWR VPWR sky130_fd_sc_hd__decap_8
XFILLER_0_50_277 VPWR VGND VPWR VGND sky130_ef_sc_hd__decap_12
XFILLER_0_50_299 VGND VGND VPWR VPWR sky130_fd_sc_hd__decap_8
Xoutput93 net93 VGND VGND VPWR VPWR result[31] sky130_fd_sc_hd__clkbuf_4
Xoutput82 net82 VGND VGND VPWR VPWR result[21] sky130_fd_sc_hd__clkbuf_4
Xoutput71 net71 VGND VGND VPWR VPWR result[11] sky130_fd_sc_hd__buf_2
XFILLER_0_37_35 VPWR VGND VPWR VGND sky130_ef_sc_hd__decap_12
XFILLER_0_53_34 VPWR VGND VPWR VGND sky130_ef_sc_hd__decap_12
XTAP_TAPCELL_ROW_102_1404 VGND VPWR sky130_fd_sc_hd__tapvpwrvgnd_1
XFILLER_0_58_333 VGND VGND VPWR VPWR sky130_fd_sc_hd__fill_1
X_4980_ _0155_ _0221_ _0256_ _0258_ VGND VGND VPWR VPWR _0259_ sky130_fd_sc_hd__a211o_1
XTAP_TAPCELL_ROW_102_1415 VGND VPWR sky130_fd_sc_hd__tapvpwrvgnd_1
XFILLER_0_85_152 VGND VGND VPWR VPWR sky130_fd_sc_hd__decap_6
XTAP_TAPCELL_ROW_62_946 VGND VPWR sky130_fd_sc_hd__tapvpwrvgnd_1
X_3931_ _0987_ VGND VGND VPWR VPWR _0998_ sky130_fd_sc_hd__clkbuf_4
XFILLER_0_58_377 VPWR VGND VPWR VGND sky130_ef_sc_hd__decap_12
XTAP_TAPCELL_ROW_34_626 VGND VPWR sky130_fd_sc_hd__tapvpwrvgnd_1
X_3862_ net19 VGND VGND VPWR VPWR _0246_ sky130_fd_sc_hd__buf_2
XFILLER_0_73_314 VGND VGND VPWR VPWR sky130_fd_sc_hd__fill_1
X_6650_ _2078_ _2079_ _2081_ VGND VGND VPWR VPWR _2082_ sky130_fd_sc_hd__nand3_2
XFILLER_0_46_528 VGND VGND VPWR VPWR sky130_fd_sc_hd__decap_4
XFILLER_0_6_625 VPWR VGND VPWR VGND sky130_ef_sc_hd__decap_12
X_5601_ _0919_ _0920_ _0934_ VGND VGND VPWR VPWR _0936_ sky130_fd_sc_hd__o21ba_1
X_6581_ _1535_ _1676_ _1841_ VGND VGND VPWR VPWR _2006_ sky130_fd_sc_hd__and3_1
XTAP_TAPCELL_ROW_14_394 VGND VPWR sky130_fd_sc_hd__tapvpwrvgnd_1
X_5532_ _0776_ _0783_ _0782_ VGND VGND VPWR VPWR _0860_ sky130_fd_sc_hd__a21o_1
XFILLER_0_5_135 VPWR VGND VPWR VGND sky130_ef_sc_hd__decap_12
XFILLER_0_5_113 VGND VGND VPWR VPWR sky130_fd_sc_hd__decap_4
XFILLER_0_14_414 VGND VGND VPWR VPWR sky130_fd_sc_hd__decap_6
XFILLER_0_82_7 VGND VGND VPWR VPWR sky130_fd_sc_hd__decap_4
XFILLER_0_14_436 VGND VGND VPWR VPWR sky130_fd_sc_hd__decap_8
XFILLER_0_41_222 VGND VGND VPWR VPWR sky130_fd_sc_hd__fill_2
X_5463_ _0776_ _0784_ VGND VGND VPWR VPWR _0785_ sky130_fd_sc_hd__xor2_2
X_7202_ _1366_ _2150_ _2684_ _1369_ VGND VGND VPWR VPWR _2685_ sky130_fd_sc_hd__o211a_1
X_4414_ _3519_ _3522_ VGND VGND VPWR VPWR _3523_ sky130_fd_sc_hd__and2b_1
XFILLER_0_1_330 VGND VGND VPWR VPWR sky130_fd_sc_hd__decap_6
XFILLER_0_41_288 VGND VGND VPWR VPWR sky130_fd_sc_hd__decap_8
X_5394_ _0708_ _0709_ VGND VGND VPWR VPWR _0710_ sky130_fd_sc_hd__nor2_1
X_4345_ _3454_ _3455_ _3313_ VGND VGND VPWR VPWR _3456_ sky130_fd_sc_hd__mux2_1
X_7133_ _3330_ net51 _0257_ _3333_ VGND VGND VPWR VPWR _2610_ sky130_fd_sc_hd__a22o_1
XFILLER_0_10_642 VGND VGND VPWR VPWR sky130_fd_sc_hd__fill_2
XTAP_TAPCELL_ROW_6_307 VGND VPWR sky130_fd_sc_hd__tapvpwrvgnd_1
X_4276_ _3307_ net24 _3387_ VGND VGND VPWR VPWR _3388_ sky130_fd_sc_hd__a21o_1
XFILLER_0_94_63 VGND VGND VPWR VPWR sky130_fd_sc_hd__fill_2
XFILLER_0_94_41 VPWR VGND VPWR VGND sky130_ef_sc_hd__decap_12
X_7064_ _2379_ _2378_ VGND VGND VPWR VPWR _2534_ sky130_fd_sc_hd__and2b_1
XFILLER_0_94_85 VGND VGND VPWR VPWR sky130_fd_sc_hd__decap_8
X_6015_ _1342_ _1341_ VGND VGND VPWR VPWR _1387_ sky130_fd_sc_hd__and2b_1
XTAP_TAPCELL_ROW_68_1023 VGND VPWR sky130_fd_sc_hd__tapvpwrvgnd_1
XFILLER_0_92_601 VGND VGND VPWR VPWR sky130_fd_sc_hd__decap_8
XFILLER_0_76_141 VGND VGND VPWR VPWR sky130_fd_sc_hd__decap_8
X_6917_ _1807_ _1621_ _1162_ _0769_ VGND VGND VPWR VPWR _2373_ sky130_fd_sc_hd__and4_1
X_6848_ _2133_ _2297_ VGND VGND VPWR VPWR _2298_ sky130_fd_sc_hd__xnor2_2
XFILLER_0_92_645 VGND VGND VPWR VPWR sky130_fd_sc_hd__decap_6
X_6779_ _2084_ _2092_ VGND VGND VPWR VPWR _2223_ sky130_fd_sc_hd__and2b_1
XTAP_TAPCELL_ROW_79_1141 VGND VPWR sky130_fd_sc_hd__tapvpwrvgnd_1
XFILLER_0_60_520 VGND VGND VPWR VPWR sky130_fd_sc_hd__decap_3
XFILLER_0_102_132 VGND VGND VPWR VPWR sky130_fd_sc_hd__decap_8
XFILLER_0_23_15 VPWR VGND VPWR VGND sky130_ef_sc_hd__decap_12
XFILLER_0_82_166 VGND VGND VPWR VPWR sky130_fd_sc_hd__decap_3
XFILLER_0_36_561 VGND VGND VPWR VPWR sky130_fd_sc_hd__decap_3
XTAP_TAPCELL_ROW_11_364 VGND VPWR sky130_fd_sc_hd__tapvpwrvgnd_1
XFILLER_0_3_617 VPWR VGND VPWR VGND sky130_ef_sc_hd__decap_12
Xrebuffer4 net121 VGND VGND VPWR VPWR net122 sky130_fd_sc_hd__dlygate4sd1_1
XFILLER_0_23_233 VGND VGND VPWR VPWR sky130_fd_sc_hd__decap_6
XFILLER_0_23_266 VPWR VGND VPWR VGND sky130_ef_sc_hd__decap_12
X_4130_ _3163_ _2977_ VGND VGND VPWR VPWR _3174_ sky130_fd_sc_hd__xor2_2
X_4061_ _2397_ _2364_ VGND VGND VPWR VPWR _2419_ sky130_fd_sc_hd__and2b_1
XFILLER_0_3_69 VPWR VGND VPWR VGND sky130_ef_sc_hd__decap_12
XTAP_TAPCELL_ROW_19_453 VGND VPWR sky130_fd_sc_hd__tapvpwrvgnd_1
XTAP_TAPCELL_ROW_47_773 VGND VPWR sky130_fd_sc_hd__tapvpwrvgnd_1
XFILLER_0_80_32 VGND VGND VPWR VPWR sky130_fd_sc_hd__fill_1
XFILLER_0_74_601 VPWR VGND VPWR VGND sky130_ef_sc_hd__decap_12
XFILLER_0_58_141 VGND VGND VPWR VPWR sky130_fd_sc_hd__decap_8
X_4963_ net2 VGND VGND VPWR VPWR _0240_ sky130_fd_sc_hd__clkbuf_4
X_7682_ _3463_ net55 VGND VGND VPWR VPWR _3211_ sky130_fd_sc_hd__or2_1
XFILLER_0_80_54 VGND VGND VPWR VPWR sky130_fd_sc_hd__fill_1
X_6702_ _1963_ _1975_ _2138_ VGND VGND VPWR VPWR _2139_ sky130_fd_sc_hd__and3_1
XFILLER_0_58_174 VPWR VGND VPWR VGND sky130_ef_sc_hd__decap_12
X_3914_ _0802_ VGND VGND VPWR VPWR _0813_ sky130_fd_sc_hd__buf_2
XFILLER_0_73_122 VPWR VGND VPWR VGND sky130_ef_sc_hd__decap_12
X_6633_ _1929_ _1930_ _1940_ VGND VGND VPWR VPWR _2063_ sky130_fd_sc_hd__nand3_1
X_4894_ _0162_ _0163_ _0118_ _0119_ VGND VGND VPWR VPWR _0165_ sky130_fd_sc_hd__a211oi_1
XFILLER_0_104_83 VGND VGND VPWR VPWR sky130_fd_sc_hd__fill_1
X_3845_ _0050_ VGND VGND VPWR VPWR _0061_ sky130_fd_sc_hd__inv_2
XFILLER_0_6_433 VPWR VGND VPWR VGND sky130_ef_sc_hd__decap_12
XFILLER_0_104_419 VGND VGND VPWR VPWR sky130_fd_sc_hd__fill_1
X_6564_ _0384_ _0843_ _1365_ _1987_ _0402_ _0390_ VGND VGND VPWR VPWR _1988_ sky130_fd_sc_hd__mux4_1
XFILLER_0_73_199 VGND VGND VPWR VPWR sky130_fd_sc_hd__decap_3
XFILLER_0_6_477 VPWR VGND VPWR VGND sky130_ef_sc_hd__decap_12
XFILLER_0_27_583 VGND VGND VPWR VPWR sky130_fd_sc_hd__decap_4
X_5515_ _3482_ VGND VGND VPWR VPWR _0842_ sky130_fd_sc_hd__clkbuf_4
XFILLER_0_89_85 VGND VGND VPWR VPWR sky130_fd_sc_hd__decap_6
XFILLER_0_89_63 VGND VGND VPWR VPWR sky130_fd_sc_hd__fill_1
X_6495_ _2966_ net14 _1097_ _2857_ VGND VGND VPWR VPWR _1912_ sky130_fd_sc_hd__a22oi_2
XFILLER_0_73_3 VGND VGND VPWR VPWR sky130_fd_sc_hd__decap_3
XFILLER_0_14_277 VGND VGND VPWR VPWR sky130_fd_sc_hd__fill_1
X_5446_ _0763_ _0764_ _0765_ VGND VGND VPWR VPWR _0766_ sky130_fd_sc_hd__nand3_2
XTAP_TAPCELL_ROW_74_1082 VGND VPWR sky130_fd_sc_hd__tapvpwrvgnd_1
X_5377_ _0688_ _0689_ _0568_ _0653_ VGND VGND VPWR VPWR _0691_ sky130_fd_sc_hd__o211ai_2
X_4328_ _3438_ VGND VGND VPWR VPWR _3439_ sky130_fd_sc_hd__inv_2
XTAP_TAPCELL_ROW_74_1093 VGND VPWR sky130_fd_sc_hd__tapvpwrvgnd_1
X_7116_ _2582_ _2590_ VGND VGND VPWR VPWR _2591_ sky130_fd_sc_hd__xnor2_1
X_4259_ net63 net64 _3298_ VGND VGND VPWR VPWR _3371_ sky130_fd_sc_hd__or3_4
X_7047_ _2336_ _2344_ _2514_ VGND VGND VPWR VPWR _2515_ sky130_fd_sc_hd__a21oi_2
XFILLER_0_69_417 VGND VGND VPWR VPWR sky130_fd_sc_hd__decap_4
XFILLER_0_69_428 VPWR VGND VPWR VGND sky130_ef_sc_hd__decap_12
XFILLER_0_96_247 VGND VGND VPWR VPWR sky130_fd_sc_hd__decap_4
XFILLER_0_65_601 VGND VGND VPWR VPWR sky130_fd_sc_hd__fill_1
XFILLER_0_107_279 VGND VGND VPWR VPWR sky130_fd_sc_hd__fill_1
XFILLER_0_107_257 VGND VGND VPWR VPWR sky130_fd_sc_hd__decap_8
XFILLER_0_107_246 VGND VGND VPWR VPWR sky130_fd_sc_hd__decap_6
XFILLER_0_92_497 VGND VGND VPWR VPWR sky130_fd_sc_hd__decap_3
XFILLER_0_80_637 VGND VGND VPWR VPWR sky130_fd_sc_hd__decap_6
XFILLER_0_45_391 VGND VGND VPWR VPWR sky130_fd_sc_hd__fill_1
XFILLER_0_103_441 VGND VGND VPWR VPWR sky130_fd_sc_hd__decap_6
XFILLER_0_18_15 VPWR VGND VPWR VGND sky130_ef_sc_hd__decap_12
XFILLER_0_18_48 VGND VGND VPWR VPWR sky130_fd_sc_hd__fill_2
XFILLER_0_87_225 VGND VGND VPWR VPWR sky130_fd_sc_hd__decap_4
XFILLER_0_34_36 VGND VGND VPWR VPWR sky130_fd_sc_hd__fill_2
XTAP_TAPCELL_ROW_16_423 VGND VPWR sky130_fd_sc_hd__tapvpwrvgnd_1
XFILLER_0_34_69 VGND VGND VPWR VPWR sky130_fd_sc_hd__fill_1
XFILLER_0_56_601 VPWR VGND VPWR VGND sky130_ef_sc_hd__decap_12
XTAP_TAPCELL_ROW_44_743 VGND VPWR sky130_fd_sc_hd__tapvpwrvgnd_1
XFILLER_0_68_494 VPWR VGND VPWR VGND sky130_ef_sc_hd__decap_12
XFILLER_0_16_509 VPWR VGND VPWR VGND sky130_ef_sc_hd__decap_12
XFILLER_0_43_317 VPWR VGND VPWR VGND sky130_ef_sc_hd__decap_12
XFILLER_0_55_188 VPWR VGND VPWR VGND sky130_ef_sc_hd__decap_12
XFILLER_0_24_520 VPWR VGND VPWR VGND sky130_ef_sc_hd__decap_12
X_5300_ _0195_ _0607_ _3743_ VGND VGND VPWR VPWR _0608_ sky130_fd_sc_hd__mux2_1
XFILLER_0_24_575 VGND VGND VPWR VPWR sky130_fd_sc_hd__fill_2
XFILLER_0_51_361 VGND VGND VPWR VPWR sky130_fd_sc_hd__decap_8
XFILLER_0_59_55 VGND VGND VPWR VPWR sky130_fd_sc_hd__fill_1
X_6280_ _1535_ _1676_ VGND VGND VPWR VPWR _1677_ sky130_fd_sc_hd__nand2_1
X_5231_ _0432_ _0435_ _0434_ VGND VGND VPWR VPWR _0532_ sky130_fd_sc_hd__o21ba_1
X_5162_ net4 VGND VGND VPWR VPWR _0457_ sky130_fd_sc_hd__buf_6
X_5093_ _0107_ VGND VGND VPWR VPWR _0382_ sky130_fd_sc_hd__buf_2
X_4113_ _2977_ VGND VGND VPWR VPWR _2988_ sky130_fd_sc_hd__inv_2
XFILLER_0_75_54 VGND VGND VPWR VPWR sky130_fd_sc_hd__fill_2
XFILLER_0_75_76 VPWR VGND VPWR VGND sky130_ef_sc_hd__decap_12
X_4044_ _0813_ _0780_ VGND VGND VPWR VPWR _2233_ sky130_fd_sc_hd__and2b_1
XTAP_TAPCELL_ROW_108_1476 VGND VPWR sky130_fd_sc_hd__tapvpwrvgnd_1
X_5995_ _0402_ VGND VGND VPWR VPWR _1366_ sky130_fd_sc_hd__buf_2
XFILLER_0_59_461 VGND VGND VPWR VPWR sky130_fd_sc_hd__decap_3
XFILLER_0_46_100 VGND VGND VPWR VPWR sky130_fd_sc_hd__fill_1
XFILLER_0_24_80 VGND VGND VPWR VPWR sky130_fd_sc_hd__decap_4
X_4946_ _0138_ _0155_ _0156_ VGND VGND VPWR VPWR _0221_ sky130_fd_sc_hd__nand3_1
X_7665_ _3190_ _3191_ VGND VGND VPWR VPWR _3192_ sky130_fd_sc_hd__xnor2_1
XFILLER_0_74_464 VGND VGND VPWR VPWR sky130_fd_sc_hd__decap_3
X_4877_ _0143_ _0144_ _0145_ VGND VGND VPWR VPWR _0146_ sky130_fd_sc_hd__or3_1
XPHY_EDGE_ROW_104_Left_214 VGND VGND VPWR VPWR sky130_fd_sc_hd__decap_3
X_7596_ _3316_ _1960_ _1304_ _1217_ VGND VGND VPWR VPWR _3116_ sky130_fd_sc_hd__and4_1
X_6616_ _2080_ _1839_ _1665_ _0704_ VGND VGND VPWR VPWR _2044_ sky130_fd_sc_hd__nand4_2
XFILLER_0_61_147 VGND VGND VPWR VPWR sky130_fd_sc_hd__decap_3
XFILLER_0_27_391 VGND VGND VPWR VPWR sky130_fd_sc_hd__fill_1
X_6547_ _1345_ _1502_ VGND VGND VPWR VPWR _1969_ sky130_fd_sc_hd__nand2_1
XTAP_TAPCELL_ROW_76_1111 VGND VPWR sky130_fd_sc_hd__tapvpwrvgnd_1
XFILLER_0_100_400 VGND VGND VPWR VPWR sky130_fd_sc_hd__fill_1
X_6478_ _1891_ _1892_ VGND VGND VPWR VPWR _1893_ sky130_fd_sc_hd__nor2_1
X_5429_ _0648_ _0651_ _0745_ VGND VGND VPWR VPWR _0748_ sky130_fd_sc_hd__and3_1
XFILLER_0_100_477 VGND VGND VPWR VPWR sky130_fd_sc_hd__decap_4
XTAP_TAPCELL_ROW_87_1240 VGND VPWR sky130_fd_sc_hd__tapvpwrvgnd_1
XFILLER_0_69_225 VPWR VGND VPWR VGND sky130_ef_sc_hd__decap_12
XFILLER_0_69_214 VGND VGND VPWR VPWR sky130_fd_sc_hd__decap_8
XFILLER_0_69_269 VGND VGND VPWR VPWR sky130_fd_sc_hd__decap_4
XFILLER_0_57_409 VPWR VGND VPWR VGND sky130_ef_sc_hd__decap_12
XFILLER_0_38_623 VGND VGND VPWR VPWR sky130_fd_sc_hd__decap_4
XFILLER_0_84_239 VPWR VGND VPWR VGND sky130_ef_sc_hd__decap_12
XFILLER_0_38_634 VGND VGND VPWR VPWR sky130_fd_sc_hd__decap_8
XFILLER_0_38_645 VGND VGND VPWR VPWR sky130_fd_sc_hd__decap_6
XTAP_TAPCELL_ROW_41_713 VGND VPWR sky130_fd_sc_hd__tapvpwrvgnd_1
XFILLER_0_53_615 VGND VGND VPWR VPWR sky130_fd_sc_hd__fill_1
XFILLER_0_65_486 VGND VGND VPWR VPWR sky130_fd_sc_hd__decap_4
XFILLER_0_25_317 VGND VGND VPWR VPWR sky130_fd_sc_hd__fill_2
XFILLER_0_80_467 VGND VGND VPWR VPWR sky130_fd_sc_hd__decap_8
XFILLER_0_20_27 VGND VGND VPWR VPWR sky130_fd_sc_hd__fill_1
XTAP_TAPCELL_ROW_21_481 VGND VPWR sky130_fd_sc_hd__tapvpwrvgnd_1
XFILLER_0_33_372 VPWR VGND VPWR VGND sky130_ef_sc_hd__decap_12
XFILLER_0_0_417 VGND VGND VPWR VPWR sky130_fd_sc_hd__decap_3
XFILLER_0_21_556 VGND VGND VPWR VPWR sky130_fd_sc_hd__decap_4
XTAP_TAPCELL_ROW_49_802 VGND VPWR sky130_fd_sc_hd__tapvpwrvgnd_1
XFILLER_0_45_24 VGND VGND VPWR VPWR sky130_fd_sc_hd__decap_4
XFILLER_0_45_35 VGND VGND VPWR VPWR sky130_fd_sc_hd__decap_8
Xmax_cap2 _0649_ VGND VGND VPWR VPWR net151 sky130_fd_sc_hd__clkbuf_1
XFILLER_0_88_556 VGND VGND VPWR VPWR sky130_fd_sc_hd__decap_6
XFILLER_0_88_545 VGND VGND VPWR VPWR sky130_fd_sc_hd__fill_1
XTAP_TAPCELL_ROW_57_890 VGND VPWR sky130_fd_sc_hd__tapvpwrvgnd_1
XFILLER_0_0_15 VPWR VGND VPWR VGND sky130_ef_sc_hd__decap_12
XTAP_TAPCELL_ROW_29_570 VGND VPWR sky130_fd_sc_hd__tapvpwrvgnd_1
XFILLER_0_88_589 VGND VGND VPWR VPWR sky130_fd_sc_hd__decap_4
X_4800_ _0059_ _0060_ _0052_ VGND VGND VPWR VPWR _0063_ sky130_fd_sc_hd__a21o_1
XFILLER_0_8_506 VGND VGND VPWR VPWR sky130_fd_sc_hd__fill_2
X_5780_ _1112_ _1114_ _1127_ _1128_ VGND VGND VPWR VPWR _1131_ sky130_fd_sc_hd__a22o_1
XFILLER_0_61_89 VPWR VGND VPWR VGND sky130_ef_sc_hd__decap_12
XFILLER_0_56_475 VGND VGND VPWR VPWR sky130_fd_sc_hd__fill_1
XFILLER_0_44_604 VPWR VGND VPWR VGND sky130_ef_sc_hd__decap_12
X_4731_ _3832_ _3833_ _3817_ VGND VGND VPWR VPWR _3835_ sky130_fd_sc_hd__o21a_1
X_7450_ _2954_ _2956_ VGND VGND VPWR VPWR _2957_ sky130_fd_sc_hd__xor2_1
X_4662_ _3331_ _2714_ _3686_ _3685_ _2638_ VGND VGND VPWR VPWR _3767_ sky130_fd_sc_hd__a32o_1
XFILLER_0_9_57 VGND VGND VPWR VPWR sky130_fd_sc_hd__decap_8
XFILLER_0_43_136 VGND VGND VPWR VPWR sky130_fd_sc_hd__decap_8
X_6401_ _1808_ _1809_ VGND VGND VPWR VPWR _1810_ sky130_fd_sc_hd__nor2_1
X_7381_ _2704_ _2702_ VGND VGND VPWR VPWR _2881_ sky130_fd_sc_hd__or2b_1
XFILLER_0_101_51 VGND VGND VPWR VPWR sky130_fd_sc_hd__decap_4
X_4593_ _3689_ _3697_ _3698_ VGND VGND VPWR VPWR _3699_ sky130_fd_sc_hd__nand3_1
XFILLER_0_10_82 VGND VGND VPWR VPWR sky130_fd_sc_hd__fill_2
X_6332_ _1732_ _1733_ VGND VGND VPWR VPWR _1734_ sky130_fd_sc_hd__xnor2_1
X_6263_ _0382_ _0608_ _1658_ _1369_ _3728_ VGND VGND VPWR VPWR _1659_ sky130_fd_sc_hd__a221o_1
XFILLER_0_12_589 VPWR VGND VPWR VGND sky130_ef_sc_hd__decap_12
X_5214_ _0429_ _0441_ _0444_ VGND VGND VPWR VPWR _0513_ sky130_fd_sc_hd__or3_1
XFILLER_0_86_97 VGND VGND VPWR VPWR sky130_fd_sc_hd__decap_3
XTAP_TAPCELL_ROW_71_1052 VGND VPWR sky130_fd_sc_hd__tapvpwrvgnd_1
X_6194_ _1581_ _1582_ VGND VGND VPWR VPWR _1583_ sky130_fd_sc_hd__xnor2_1
XFILLER_0_19_91 VGND VGND VPWR VPWR sky130_fd_sc_hd__decap_8
X_5145_ _0310_ _0313_ _0312_ VGND VGND VPWR VPWR _0438_ sky130_fd_sc_hd__o21ba_1
XFILLER_0_36_3 VPWR VGND VPWR VGND sky130_ef_sc_hd__decap_12
X_5076_ _0360_ _0361_ _0218_ VGND VGND VPWR VPWR _0363_ sky130_fd_sc_hd__a21oi_1
X_4027_ _2036_ VGND VGND VPWR VPWR _2047_ sky130_fd_sc_hd__clkbuf_4
XFILLER_0_19_111 VGND VGND VPWR VPWR sky130_fd_sc_hd__fill_1
X_5978_ _0826_ _1211_ _1076_ _1346_ VGND VGND VPWR VPWR _1347_ sky130_fd_sc_hd__or4_4
X_7717_ _0061_ _0409_ _1214_ VGND VGND VPWR VPWR _3246_ sky130_fd_sc_hd__and3_1
XTAP_TAPCELL_ROW_82_1181 VGND VPWR sky130_fd_sc_hd__tapvpwrvgnd_1
X_4929_ _0174_ _0175_ _0202_ VGND VGND VPWR VPWR net70 sky130_fd_sc_hd__o21ai_1
XFILLER_0_62_401 VPWR VGND VPWR VGND sky130_ef_sc_hd__decap_12
XFILLER_0_19_133 VGND VGND VPWR VPWR sky130_fd_sc_hd__fill_2
XFILLER_0_19_166 VGND VGND VPWR VPWR sky130_fd_sc_hd__fill_2
X_7648_ _3171_ _3172_ VGND VGND VPWR VPWR _3173_ sky130_fd_sc_hd__and2b_1
XFILLER_0_34_114 VPWR VGND VPWR VGND sky130_ef_sc_hd__decap_12
X_7579_ _3096_ _2897_ _2890_ VGND VGND VPWR VPWR _3098_ sky130_fd_sc_hd__o21ai_1
XFILLER_0_22_309 VGND VGND VPWR VPWR sky130_fd_sc_hd__fill_2
XFILLER_0_50_618 VPWR VGND VPWR VGND sky130_ef_sc_hd__decap_12
XFILLER_0_106_29 VPWR VGND VPWR VGND sky130_ef_sc_hd__decap_12
XFILLER_0_15_27 VGND VGND VPWR VPWR sky130_fd_sc_hd__decap_4
XTAP_TAPCELL_ROW_26_540 VGND VPWR sky130_fd_sc_hd__tapvpwrvgnd_1
XFILLER_0_97_397 VGND VGND VPWR VPWR sky130_fd_sc_hd__fill_1
XFILLER_0_85_559 VGND VGND VPWR VPWR sky130_fd_sc_hd__fill_1
XTAP_TAPCELL_ROW_54_860 VGND VPWR sky130_fd_sc_hd__tapvpwrvgnd_1
XFILLER_0_72_209 VPWR VGND VPWR VGND sky130_ef_sc_hd__decap_12
XFILLER_0_25_125 VPWR VGND VPWR VGND sky130_ef_sc_hd__decap_12
XFILLER_0_38_486 VPWR VGND VPWR VGND sky130_ef_sc_hd__decap_12
XFILLER_0_53_412 VGND VGND VPWR VPWR sky130_fd_sc_hd__decap_3
XFILLER_0_108_363 VGND VGND VPWR VPWR sky130_fd_sc_hd__fill_1
XTAP_TAPCELL_ROW_96_1339 VGND VPWR sky130_fd_sc_hd__tapvpwrvgnd_1
XFILLER_0_25_169 VPWR VGND VPWR VGND sky130_ef_sc_hd__decap_12
XFILLER_0_40_139 VGND VGND VPWR VPWR sky130_fd_sc_hd__fill_1
XFILLER_0_0_258 VGND VGND VPWR VPWR sky130_fd_sc_hd__decap_8
XFILLER_0_0_247 VGND VGND VPWR VPWR sky130_fd_sc_hd__fill_1
XFILLER_0_56_45 VPWR VGND VPWR VGND sky130_ef_sc_hd__decap_12
XFILLER_0_56_78 VGND VGND VPWR VPWR sky130_fd_sc_hd__decap_6
X_6950_ _2407_ _2409_ VGND VGND VPWR VPWR _2410_ sky130_fd_sc_hd__or2_1
XFILLER_0_88_342 VGND VGND VPWR VPWR sky130_fd_sc_hd__decap_3
X_5901_ _1247_ _1261_ _1262_ VGND VGND VPWR VPWR _1263_ sky130_fd_sc_hd__nor3_1
XTAP_TAPCELL_ROW_105_1446 VGND VPWR sky130_fd_sc_hd__tapvpwrvgnd_1
X_6881_ _3310_ _0094_ _2330_ _2332_ VGND VGND VPWR VPWR _2334_ sky130_fd_sc_hd__a22o_1
XFILLER_0_88_397 VPWR VGND VPWR VGND sky130_ef_sc_hd__decap_12
XFILLER_0_8_303 VGND VGND VPWR VPWR sky130_fd_sc_hd__decap_4
X_5832_ _1185_ _1186_ _1187_ VGND VGND VPWR VPWR _1188_ sky130_fd_sc_hd__nand3_4
XFILLER_0_29_420 VGND VGND VPWR VPWR sky130_fd_sc_hd__decap_8
X_5763_ _3328_ _1304_ _1217_ _3332_ VGND VGND VPWR VPWR _1112_ sky130_fd_sc_hd__a22o_1
XFILLER_0_84_570 VPWR VGND VPWR VGND sky130_ef_sc_hd__decap_12
X_7502_ _3012_ _3013_ VGND VGND VPWR VPWR _3014_ sky130_fd_sc_hd__nand2_1
XFILLER_0_16_114 VGND VGND VPWR VPWR sky130_fd_sc_hd__decap_8
XFILLER_0_17_615 VGND VGND VPWR VPWR sky130_fd_sc_hd__fill_1
X_4714_ _2922_ _2703_ VGND VGND VPWR VPWR _3818_ sky130_fd_sc_hd__nand2_1
XFILLER_0_71_231 VGND VGND VPWR VPWR sky130_fd_sc_hd__fill_1
XFILLER_0_56_294 VGND VGND VPWR VPWR sky130_fd_sc_hd__fill_2
X_5694_ _3064_ _2605_ net145 net9 VGND VGND VPWR VPWR _1037_ sky130_fd_sc_hd__and4_1
X_4645_ _3326_ _2364_ net117 VGND VGND VPWR VPWR _3750_ sky130_fd_sc_hd__o21ai_1
X_7433_ _2929_ _2937_ VGND VGND VPWR VPWR _2938_ sky130_fd_sc_hd__and2_1
XFILLER_0_102_517 VGND VGND VPWR VPWR sky130_fd_sc_hd__fill_1
X_7364_ net23 net54 VGND VGND VPWR VPWR _2862_ sky130_fd_sc_hd__nor2_1
X_4576_ _3620_ _3681_ _3328_ _2517_ VGND VGND VPWR VPWR _3682_ sky130_fd_sc_hd__o211a_1
XFILLER_0_31_128 VPWR VGND VPWR VGND sky130_ef_sc_hd__decap_12
X_6315_ _1704_ _1714_ VGND VGND VPWR VPWR _1715_ sky130_fd_sc_hd__xnor2_1
XFILLER_0_40_651 VGND VGND VPWR VPWR sky130_fd_sc_hd__fill_1
X_7295_ _2777_ _2786_ VGND VGND VPWR VPWR _2787_ sky130_fd_sc_hd__xnor2_1
X_6246_ _1388_ _1638_ _1639_ VGND VGND VPWR VPWR _1640_ sky130_fd_sc_hd__or3_4
X_6177_ _1531_ _1562_ _1563_ VGND VGND VPWR VPWR _1564_ sky130_fd_sc_hd__nor3_1
XFILLER_0_99_629 VPWR VGND VPWR VGND sky130_ef_sc_hd__decap_12
X_5128_ _0386_ _0408_ _0418_ VGND VGND VPWR VPWR _0419_ sky130_fd_sc_hd__o21ai_2
XTAP_TAPCELL_ROW_4_279 VGND VPWR sky130_fd_sc_hd__tapvpwrvgnd_1
X_5059_ _0241_ _0244_ _0243_ VGND VGND VPWR VPWR _0345_ sky130_fd_sc_hd__o21bai_1
XFILLER_0_79_353 VGND VGND VPWR VPWR sky130_fd_sc_hd__decap_8
XFILLER_0_67_559 VGND VGND VPWR VPWR sky130_fd_sc_hd__fill_1
XFILLER_0_109_149 VGND VGND VPWR VPWR sky130_fd_sc_hd__decap_3
XFILLER_0_82_529 VGND VGND VPWR VPWR sky130_fd_sc_hd__decap_3
XFILLER_0_75_581 VPWR VGND VPWR VGND sky130_ef_sc_hd__decap_12
XPHY_EDGE_ROW_109_Right_109 VGND VGND VPWR VPWR sky130_fd_sc_hd__decap_3
XFILLER_0_62_220 VGND VGND VPWR VPWR sky130_fd_sc_hd__decap_4
XFILLER_0_23_629 VPWR VGND VPWR VGND sky130_ef_sc_hd__decap_12
XFILLER_0_50_437 VGND VGND VPWR VPWR sky130_fd_sc_hd__decap_4
XFILLER_0_30_172 VPWR VGND VPWR VGND sky130_ef_sc_hd__decap_12
XFILLER_0_30_194 VGND VGND VPWR VPWR sky130_fd_sc_hd__fill_2
XFILLER_0_26_15 VPWR VGND VPWR VGND sky130_ef_sc_hd__decap_12
XFILLER_0_98_651 VGND VGND VPWR VPWR sky130_fd_sc_hd__fill_1
XFILLER_0_98_640 VGND VGND VPWR VPWR sky130_fd_sc_hd__decap_4
XFILLER_0_81_540 VPWR VGND VPWR VGND sky130_ef_sc_hd__decap_12
XFILLER_0_5_317 VPWR VGND VPWR VGND sky130_ef_sc_hd__decap_12
XFILLER_0_53_231 VPWR VGND VPWR VGND sky130_ef_sc_hd__decap_12
XFILLER_0_108_182 VGND VGND VPWR VPWR sky130_fd_sc_hd__fill_1
XTAP_TAPCELL_ROW_100_1387 VGND VPWR sky130_fd_sc_hd__tapvpwrvgnd_1
X_4430_ _3428_ _3434_ _3310_ VGND VGND VPWR VPWR _3539_ sky130_fd_sc_hd__mux2_1
XANTENNA_2 _0660_ VGND VGND VPWR VPWR sky130_fd_sc_hd__diode_2
XFILLER_0_53_286 VGND VGND VPWR VPWR sky130_fd_sc_hd__decap_4
XFILLER_0_53_297 VPWR VGND VPWR VGND sky130_ef_sc_hd__decap_12
XFILLER_0_22_651 VGND VGND VPWR VPWR sky130_fd_sc_hd__fill_1
X_4361_ _3342_ _3470_ VGND VGND VPWR VPWR _3471_ sky130_fd_sc_hd__and2_1
X_6100_ _1477_ _1476_ _1478_ VGND VGND VPWR VPWR _1481_ sky130_fd_sc_hd__a21o_1
X_4292_ _3354_ _3365_ VGND VGND VPWR VPWR _3403_ sky130_fd_sc_hd__nor2b_2
X_7080_ _2542_ _2549_ VGND VGND VPWR VPWR _2552_ sky130_fd_sc_hd__nor2_1
XFILLER_0_67_88 VGND VGND VPWR VPWR sky130_fd_sc_hd__decap_8
X_6031_ _1403_ _1404_ VGND VGND VPWR VPWR _1405_ sky130_fd_sc_hd__xor2_1
XFILLER_0_83_65 VGND VGND VPWR VPWR sky130_fd_sc_hd__fill_1
XTAP_TAPCELL_ROW_1_249 VGND VPWR sky130_fd_sc_hd__tapvpwrvgnd_1
XTAP_TAPCELL_ROW_37_657 VGND VPWR sky130_fd_sc_hd__tapvpwrvgnd_1
X_6933_ _2275_ VGND VGND VPWR VPWR _2391_ sky130_fd_sc_hd__inv_2
X_6864_ _0105_ _1360_ _3558_ _2302_ VGND VGND VPWR VPWR _2316_ sky130_fd_sc_hd__a2bb2o_1
XTAP_TAPCELL_ROW_65_988 VGND VPWR sky130_fd_sc_hd__tapvpwrvgnd_1
XFILLER_0_49_548 VPWR VGND VPWR VGND sky130_ef_sc_hd__decap_12
XFILLER_0_9_612 VGND VGND VPWR VPWR sky130_fd_sc_hd__decap_4
X_5815_ _1160_ _1168_ VGND VGND VPWR VPWR _1169_ sky130_fd_sc_hd__xnor2_2
XFILLER_0_107_609 VGND VGND VPWR VPWR sky130_fd_sc_hd__decap_6
XFILLER_0_91_337 VGND VGND VPWR VPWR sky130_fd_sc_hd__fill_2
XFILLER_0_91_315 VGND VGND VPWR VPWR sky130_fd_sc_hd__decap_3
XFILLER_0_64_529 VGND VGND VPWR VPWR sky130_fd_sc_hd__decap_3
XFILLER_0_17_401 VGND VGND VPWR VPWR sky130_fd_sc_hd__decap_3
X_6795_ _2219_ _2220_ _2238_ _2239_ VGND VGND VPWR VPWR _2240_ sky130_fd_sc_hd__o211a_1
X_5746_ _3751_ VGND VGND VPWR VPWR _1094_ sky130_fd_sc_hd__clkbuf_4
XFILLER_0_8_188 VGND VGND VPWR VPWR sky130_fd_sc_hd__decap_8
XFILLER_0_8_166 VGND VGND VPWR VPWR sky130_fd_sc_hd__fill_2
X_5677_ _1016_ _1017_ VGND VGND VPWR VPWR _1018_ sky130_fd_sc_hd__xor2_1
XFILLER_0_44_253 VGND VGND VPWR VPWR sky130_fd_sc_hd__decap_4
X_7416_ _2915_ _2916_ _2917_ VGND VGND VPWR VPWR _2919_ sky130_fd_sc_hd__o21ai_1
X_4628_ _2539_ _3732_ _3733_ VGND VGND VPWR VPWR _3734_ sky130_fd_sc_hd__o21ai_1
XFILLER_0_102_336 VPWR VGND VPWR VGND sky130_ef_sc_hd__decap_12
XFILLER_0_4_383 VPWR VGND VPWR VGND sky130_ef_sc_hd__decap_12
X_4559_ _2791_ _3417_ _3662_ _3665_ VGND VGND VPWR VPWR _3666_ sky130_fd_sc_hd__o211a_1
X_7347_ _2842_ _2843_ VGND VGND VPWR VPWR _2844_ sky130_fd_sc_hd__xnor2_1
XFILLER_0_12_161 VPWR VGND VPWR VGND sky130_ef_sc_hd__decap_12
XTAP_TAPCELL_ROW_9_338 VGND VPWR sky130_fd_sc_hd__tapvpwrvgnd_1
X_7278_ _2766_ _2767_ VGND VGND VPWR VPWR _2768_ sky130_fd_sc_hd__xnor2_1
X_6229_ _1618_ _1617_ _1619_ VGND VGND VPWR VPWR _1622_ sky130_fd_sc_hd__a21o_1
XFILLER_0_86_109 VGND VGND VPWR VPWR sky130_fd_sc_hd__decap_6
XFILLER_0_94_153 VPWR VGND VPWR VGND sky130_ef_sc_hd__decap_12
XFILLER_0_94_197 VGND VGND VPWR VPWR sky130_fd_sc_hd__decap_4
XTAP_TAPCELL_ROW_93_1309 VGND VPWR sky130_fd_sc_hd__tapvpwrvgnd_1
XFILLER_0_50_289 VGND VGND VPWR VPWR sky130_fd_sc_hd__decap_4
Xoutput83 net83 VGND VGND VPWR VPWR result[22] sky130_fd_sc_hd__clkbuf_4
XFILLER_0_101_391 VGND VGND VPWR VPWR sky130_fd_sc_hd__fill_1
Xoutput94 net94 VGND VGND VPWR VPWR result[3] sky130_fd_sc_hd__buf_2
Xoutput72 net72 VGND VGND VPWR VPWR result[12] sky130_fd_sc_hd__buf_2
XFILLER_0_37_47 VGND VGND VPWR VPWR sky130_fd_sc_hd__decap_3
XFILLER_0_98_470 VGND VGND VPWR VPWR sky130_fd_sc_hd__decap_6
XFILLER_0_86_643 VGND VGND VPWR VPWR sky130_fd_sc_hd__fill_1
X_3930_ net12 VGND VGND VPWR VPWR _0987_ sky130_fd_sc_hd__clkbuf_4
XFILLER_0_53_46 VGND VGND VPWR VPWR sky130_fd_sc_hd__decap_4
XFILLER_0_53_57 VPWR VGND VPWR VGND sky130_ef_sc_hd__decap_12
XTAP_TAPCELL_ROW_102_1405 VGND VPWR sky130_fd_sc_hd__tapvpwrvgnd_1
XTAP_TAPCELL_ROW_62_947 VGND VPWR sky130_fd_sc_hd__tapvpwrvgnd_1
XTAP_TAPCELL_ROW_34_627 VGND VPWR sky130_fd_sc_hd__tapvpwrvgnd_1
XFILLER_0_46_507 VPWR VGND VPWR VGND sky130_ef_sc_hd__decap_12
X_3861_ _0105_ _0126_ _0170_ _0224_ VGND VGND VPWR VPWR _0235_ sky130_fd_sc_hd__a22o_1
XFILLER_0_18_209 VGND VGND VPWR VPWR sky130_fd_sc_hd__decap_8
X_5600_ _0920_ _0919_ _0934_ VGND VGND VPWR VPWR _0935_ sky130_fd_sc_hd__nor3b_4
X_6580_ _1843_ _1952_ _1953_ VGND VGND VPWR VPWR _2005_ sky130_fd_sc_hd__nor3_1
XFILLER_0_39_592 VGND VGND VPWR VPWR sky130_fd_sc_hd__fill_1
XFILLER_0_109_491 VGND VGND VPWR VPWR sky130_fd_sc_hd__fill_2
XTAP_TAPCELL_ROW_14_395 VGND VPWR sky130_fd_sc_hd__tapvpwrvgnd_1
X_5531_ _0774_ _0808_ _0809_ VGND VGND VPWR VPWR _0859_ sky130_fd_sc_hd__nor3_2
XFILLER_0_6_637 VGND VGND VPWR VPWR sky130_fd_sc_hd__decap_6
XFILLER_0_5_125 VGND VGND VPWR VPWR sky130_fd_sc_hd__decap_4
XFILLER_0_5_169 VPWR VGND VPWR VGND sky130_ef_sc_hd__decap_12
XFILLER_0_5_147 VGND VGND VPWR VPWR sky130_fd_sc_hd__decap_8
X_7201_ _3553_ _2477_ _2683_ _3348_ VGND VGND VPWR VPWR _2684_ sky130_fd_sc_hd__o22a_1
XFILLER_0_75_7 VPWR VGND VPWR VGND sky130_ef_sc_hd__decap_12
X_5462_ _0782_ _0783_ VGND VGND VPWR VPWR _0784_ sky130_fd_sc_hd__and2b_1
XFILLER_0_78_65 VPWR VGND VPWR VGND sky130_ef_sc_hd__decap_12
XFILLER_0_10_610 VPWR VGND VPWR VGND sky130_ef_sc_hd__decap_12
X_5393_ _0705_ _0706_ _0707_ VGND VGND VPWR VPWR _0709_ sky130_fd_sc_hd__and3_1
X_4413_ net1 _3518_ _3521_ _3185_ VGND VGND VPWR VPWR _3522_ sky130_fd_sc_hd__a22o_1
X_4344_ _2047_ _0682_ _3307_ VGND VGND VPWR VPWR _3455_ sky130_fd_sc_hd__mux2_1
X_7132_ _3330_ _0257_ _2453_ VGND VGND VPWR VPWR _2609_ sky130_fd_sc_hd__nand3_1
XTAP_TAPCELL_ROW_6_308 VGND VPWR sky130_fd_sc_hd__tapvpwrvgnd_1
XFILLER_0_1_364 VGND VGND VPWR VPWR sky130_fd_sc_hd__decap_8
X_7063_ _2530_ _2531_ _2347_ _2499_ VGND VGND VPWR VPWR _2533_ sky130_fd_sc_hd__o211a_1
X_4275_ _3345_ net23 VGND VGND VPWR VPWR _3387_ sky130_fd_sc_hd__and2_1
XFILLER_0_94_53 VGND VGND VPWR VPWR sky130_fd_sc_hd__decap_4
X_6014_ _1205_ _1343_ VGND VGND VPWR VPWR _1386_ sky130_fd_sc_hd__and2b_1
XTAP_TAPCELL_ROW_68_1013 VGND VPWR sky130_fd_sc_hd__tapvpwrvgnd_1
XTAP_TAPCELL_ROW_68_1024 VGND VPWR sky130_fd_sc_hd__tapvpwrvgnd_1
XFILLER_0_68_109 VPWR VGND VPWR VGND sky130_ef_sc_hd__decap_12
XFILLER_0_89_470 VGND VGND VPWR VPWR sky130_fd_sc_hd__fill_1
X_6916_ _2370_ _2371_ VGND VGND VPWR VPWR _2372_ sky130_fd_sc_hd__xnor2_2
XFILLER_0_49_356 VGND VGND VPWR VPWR sky130_fd_sc_hd__fill_1
XFILLER_0_9_442 VGND VGND VPWR VPWR sky130_fd_sc_hd__decap_6
X_6847_ _2295_ _2296_ VGND VGND VPWR VPWR _2297_ sky130_fd_sc_hd__and2_1
XFILLER_0_76_197 VPWR VGND VPWR VGND sky130_ef_sc_hd__decap_12
XFILLER_0_64_359 VGND VGND VPWR VPWR sky130_fd_sc_hd__decap_4
XFILLER_0_17_220 VGND VGND VPWR VPWR sky130_fd_sc_hd__decap_4
X_6778_ _2085_ _2090_ VGND VGND VPWR VPWR _2221_ sky130_fd_sc_hd__and2b_1
X_5729_ _0943_ _1074_ VGND VGND VPWR VPWR _1076_ sky130_fd_sc_hd__xor2_2
XTAP_TAPCELL_ROW_79_1142 VGND VPWR sky130_fd_sc_hd__tapvpwrvgnd_1
XFILLER_0_20_407 VGND VGND VPWR VPWR sky130_fd_sc_hd__fill_2
XFILLER_0_60_587 VGND VGND VPWR VPWR sky130_fd_sc_hd__fill_1
XFILLER_0_4_191 VGND VGND VPWR VPWR sky130_fd_sc_hd__decap_4
XFILLER_0_102_155 VGND VGND VPWR VPWR sky130_fd_sc_hd__fill_2
XFILLER_0_87_418 VGND VGND VPWR VPWR sky130_fd_sc_hd__decap_8
XFILLER_0_87_407 VGND VGND VPWR VPWR sky130_fd_sc_hd__fill_1
XFILLER_0_99_289 VGND VGND VPWR VPWR sky130_fd_sc_hd__fill_2
XFILLER_0_68_643 VGND VGND VPWR VPWR sky130_fd_sc_hd__fill_1
XFILLER_0_23_27 VPWR VGND VPWR VGND sky130_ef_sc_hd__decap_12
XFILLER_0_95_473 VPWR VGND VPWR VGND sky130_ef_sc_hd__decap_12
XFILLER_0_95_462 VGND VGND VPWR VPWR sky130_fd_sc_hd__decap_4
XFILLER_0_83_613 VGND VGND VPWR VPWR sky130_fd_sc_hd__decap_3
XTAP_TAPCELL_ROW_11_365 VGND VPWR sky130_fd_sc_hd__tapvpwrvgnd_1
Xrebuffer5 _1625_ VGND VGND VPWR VPWR net123 sky130_fd_sc_hd__dlygate4sd1_1
XFILLER_0_23_223 VGND VGND VPWR VPWR sky130_fd_sc_hd__fill_1
XFILLER_0_106_461 VPWR VGND VPWR VGND sky130_ef_sc_hd__decap_12
XFILLER_0_3_629 VPWR VGND VPWR VGND sky130_ef_sc_hd__decap_12
XFILLER_0_2_139 VGND VGND VPWR VPWR sky130_fd_sc_hd__fill_1
XFILLER_0_23_278 VGND VGND VPWR VPWR sky130_fd_sc_hd__fill_2
XFILLER_0_23_289 VGND VGND VPWR VPWR sky130_fd_sc_hd__fill_1
XFILLER_0_51_598 VGND VGND VPWR VPWR sky130_fd_sc_hd__decap_3
XFILLER_0_48_13 VGND VGND VPWR VPWR sky130_fd_sc_hd__decap_3
X_4060_ _2364_ _2397_ VGND VGND VPWR VPWR _2408_ sky130_fd_sc_hd__nor2b_2
XFILLER_0_3_15 VPWR VGND VPWR VGND sky130_ef_sc_hd__decap_12
XTAP_TAPCELL_ROW_19_454 VGND VPWR sky130_fd_sc_hd__tapvpwrvgnd_1
XTAP_TAPCELL_ROW_47_774 VGND VPWR sky130_fd_sc_hd__tapvpwrvgnd_1
XFILLER_0_86_451 VGND VGND VPWR VPWR sky130_fd_sc_hd__decap_8
X_4962_ _0234_ _0238_ VGND VGND VPWR VPWR _0239_ sky130_fd_sc_hd__xnor2_1
X_7681_ _3067_ _3055_ _3208_ VGND VGND VPWR VPWR _3210_ sky130_fd_sc_hd__a21o_1
XFILLER_0_74_613 VGND VGND VPWR VPWR sky130_fd_sc_hd__decap_8
X_6701_ _2136_ _2137_ VGND VGND VPWR VPWR _2138_ sky130_fd_sc_hd__or2_1
X_3913_ _0791_ VGND VGND VPWR VPWR _0802_ sky130_fd_sc_hd__clkbuf_4
X_4893_ _0118_ _0119_ _0162_ _0163_ VGND VGND VPWR VPWR _0164_ sky130_fd_sc_hd__o211a_1
X_3844_ net55 net24 VGND VGND VPWR VPWR _0050_ sky130_fd_sc_hd__and2b_1
XFILLER_0_58_197 VPWR VGND VPWR VGND sky130_ef_sc_hd__decap_12
XFILLER_0_58_186 VGND VGND VPWR VPWR sky130_fd_sc_hd__decap_8
XFILLER_0_6_401 VGND VGND VPWR VPWR sky130_fd_sc_hd__decap_6
X_6632_ _2059_ _2060_ _2023_ _2024_ VGND VGND VPWR VPWR _2062_ sky130_fd_sc_hd__o211a_1
XFILLER_0_73_156 VGND VGND VPWR VPWR sky130_fd_sc_hd__fill_2
XFILLER_0_13_93 VPWR VGND VPWR VGND sky130_ef_sc_hd__decap_12
XFILLER_0_13_71 VGND VGND VPWR VPWR sky130_fd_sc_hd__decap_4
XFILLER_0_6_445 VPWR VGND VPWR VGND sky130_ef_sc_hd__decap_12
X_6563_ _1656_ _1986_ _0842_ VGND VGND VPWR VPWR _1987_ sky130_fd_sc_hd__mux2_1
X_5514_ _0682_ _2058_ _3360_ VGND VGND VPWR VPWR _0841_ sky130_fd_sc_hd__mux2_1
XFILLER_0_6_489 VPWR VGND VPWR VGND sky130_ef_sc_hd__decap_12
X_6494_ _2857_ _2966_ net14 _1097_ VGND VGND VPWR VPWR _1911_ sky130_fd_sc_hd__and4_1
XFILLER_0_2_651 VGND VGND VPWR VPWR sky130_fd_sc_hd__fill_1
X_5445_ _2572_ _1533_ _0642_ _0641_ VGND VGND VPWR VPWR _0765_ sky130_fd_sc_hd__a31o_1
XFILLER_0_42_587 VGND VGND VPWR VPWR sky130_fd_sc_hd__fill_1
X_7115_ _2584_ _2589_ VGND VGND VPWR VPWR _2590_ sky130_fd_sc_hd__xnor2_1
X_5376_ _0568_ _0653_ _0688_ _0689_ VGND VGND VPWR VPWR _0690_ sky130_fd_sc_hd__a211o_1
X_4327_ _3320_ _3433_ _3437_ VGND VGND VPWR VPWR _3438_ sky130_fd_sc_hd__a21oi_1
XTAP_TAPCELL_ROW_74_1083 VGND VPWR sky130_fd_sc_hd__tapvpwrvgnd_1
X_4258_ _3350_ VGND VGND VPWR VPWR _3370_ sky130_fd_sc_hd__buf_2
X_7046_ _2507_ _2513_ VGND VGND VPWR VPWR _2514_ sky130_fd_sc_hd__xnor2_1
X_4189_ net66 net65 net64 net63 VGND VGND VPWR VPWR _3301_ sky130_fd_sc_hd__and4b_1
XFILLER_0_96_237 VGND VGND VPWR VPWR sky130_fd_sc_hd__fill_1
XFILLER_0_96_226 VGND VGND VPWR VPWR sky130_fd_sc_hd__fill_1
XFILLER_0_64_101 VGND VGND VPWR VPWR sky130_fd_sc_hd__fill_1
XFILLER_0_37_315 VGND VGND VPWR VPWR sky130_fd_sc_hd__decap_6
XFILLER_0_92_421 VPWR VGND VPWR VGND sky130_ef_sc_hd__decap_12
XFILLER_0_64_112 VPWR VGND VPWR VGND sky130_ef_sc_hd__decap_12
XFILLER_0_9_261 VPWR VGND VPWR VGND sky130_ef_sc_hd__decap_12
XFILLER_0_37_337 VPWR VGND VPWR VGND sky130_ef_sc_hd__decap_12
XFILLER_0_9_294 VGND VGND VPWR VPWR sky130_fd_sc_hd__decap_3
XFILLER_0_18_540 VGND VGND VPWR VPWR sky130_fd_sc_hd__decap_8
XFILLER_0_52_307 VGND VGND VPWR VPWR sky130_fd_sc_hd__fill_1
XFILLER_0_103_420 VGND VGND VPWR VPWR sky130_fd_sc_hd__decap_6
XFILLER_0_60_362 VGND VGND VPWR VPWR sky130_fd_sc_hd__fill_2
XFILLER_0_109_29 VPWR VGND VPWR VGND sky130_ef_sc_hd__decap_12
XFILLER_0_18_27 VGND VGND VPWR VPWR sky130_fd_sc_hd__fill_1
XPHY_EDGE_ROW_16_Right_16 VGND VGND VPWR VPWR sky130_fd_sc_hd__decap_3
XTAP_TAPCELL_ROW_16_424 VGND VPWR sky130_fd_sc_hd__tapvpwrvgnd_1
XFILLER_0_56_613 VGND VGND VPWR VPWR sky130_fd_sc_hd__decap_8
XFILLER_0_28_315 VGND VGND VPWR VPWR sky130_fd_sc_hd__fill_1
XTAP_TAPCELL_ROW_44_744 VGND VPWR sky130_fd_sc_hd__tapvpwrvgnd_1
XFILLER_0_55_101 VGND VGND VPWR VPWR sky130_fd_sc_hd__decap_8
XFILLER_0_28_348 VGND VGND VPWR VPWR sky130_fd_sc_hd__decap_4
XFILLER_0_43_329 VGND VGND VPWR VPWR sky130_fd_sc_hd__decap_6
XPHY_EDGE_ROW_25_Right_25 VGND VGND VPWR VPWR sky130_fd_sc_hd__decap_3
XFILLER_0_24_587 VGND VGND VPWR VPWR sky130_fd_sc_hd__fill_1
XFILLER_0_51_373 VGND VGND VPWR VPWR sky130_fd_sc_hd__decap_3
X_5230_ _0526_ _0530_ VGND VGND VPWR VPWR _0531_ sky130_fd_sc_hd__xnor2_1
XFILLER_0_11_259 VGND VGND VPWR VPWR sky130_fd_sc_hd__decap_4
X_5161_ _2692_ _3268_ VGND VGND VPWR VPWR _0456_ sky130_fd_sc_hd__nand2_1
X_5092_ _3318_ _3378_ _3382_ _3386_ _3322_ _3742_ VGND VGND VPWR VPWR _0381_ sky130_fd_sc_hd__mux4_1
XFILLER_0_75_22 VPWR VGND VPWR VGND sky130_ef_sc_hd__decap_12
X_4112_ _2966_ VGND VGND VPWR VPWR _2977_ sky130_fd_sc_hd__buf_8
XFILLER_0_75_88 VPWR VGND VPWR VGND sky130_ef_sc_hd__decap_12
X_4043_ _1217_ _1173_ VGND VGND VPWR VPWR _2222_ sky130_fd_sc_hd__and2b_1
XPHY_EDGE_ROW_34_Right_34 VGND VGND VPWR VPWR sky130_fd_sc_hd__decap_3
XFILLER_0_91_32 VPWR VGND VPWR VGND sky130_ef_sc_hd__decap_12
XFILLER_0_78_226 VGND VGND VPWR VPWR sky130_fd_sc_hd__decap_3
XFILLER_0_78_204 VGND VGND VPWR VPWR sky130_fd_sc_hd__decap_3
XTAP_TAPCELL_ROW_108_1477 VGND VPWR sky130_fd_sc_hd__tapvpwrvgnd_1
X_5994_ _1090_ _1364_ _0842_ VGND VGND VPWR VPWR _1365_ sky130_fd_sc_hd__mux2_1
XFILLER_0_78_237 VPWR VGND VPWR VGND sky130_ef_sc_hd__decap_12
X_4945_ _0218_ _0219_ VGND VGND VPWR VPWR _0220_ sky130_fd_sc_hd__nor2_1
XFILLER_0_74_443 VGND VGND VPWR VPWR sky130_fd_sc_hd__decap_8
XFILLER_0_74_432 VGND VGND VPWR VPWR sky130_fd_sc_hd__fill_1
X_7664_ _2962_ _2963_ _2965_ VGND VGND VPWR VPWR _3191_ sky130_fd_sc_hd__a21oi_1
X_4876_ _3518_ _3772_ _3268_ _3521_ VGND VGND VPWR VPWR _0145_ sky130_fd_sc_hd__a22oi_2
X_7595_ _1894_ _3271_ _0944_ _1031_ VGND VGND VPWR VPWR _3115_ sky130_fd_sc_hd__and4_1
X_6615_ _1889_ _1890_ _1888_ VGND VGND VPWR VPWR _2043_ sky130_fd_sc_hd__a21bo_1
XPHY_EDGE_ROW_43_Right_43 VGND VGND VPWR VPWR sky130_fd_sc_hd__decap_3
XFILLER_0_104_228 VGND VGND VPWR VPWR sky130_fd_sc_hd__fill_1
XFILLER_0_104_206 VGND VGND VPWR VPWR sky130_fd_sc_hd__fill_1
X_6546_ _1966_ _1967_ VGND VGND VPWR VPWR _1968_ sky130_fd_sc_hd__or2_1
XTAP_TAPCELL_ROW_76_1112 VGND VPWR sky130_fd_sc_hd__tapvpwrvgnd_1
XFILLER_0_30_513 VPWR VGND VPWR VGND sky130_ef_sc_hd__decap_12
X_6477_ _1888_ _1889_ _1890_ VGND VGND VPWR VPWR _1892_ sky130_fd_sc_hd__a21oi_1
XFILLER_0_2_492 VPWR VGND VPWR VGND sky130_ef_sc_hd__decap_12
X_5428_ _0648_ _0651_ _0745_ VGND VGND VPWR VPWR _0746_ sky130_fd_sc_hd__a21oi_2
XFILLER_0_30_579 VGND VGND VPWR VPWR sky130_fd_sc_hd__decap_8
X_5359_ _0332_ _1839_ _0668_ _0669_ VGND VGND VPWR VPWR _0672_ sky130_fd_sc_hd__o2bb2a_1
X_7029_ _2138_ _2469_ _2470_ _2298_ VGND VGND VPWR VPWR _2496_ sky130_fd_sc_hd__or4b_4
XPHY_EDGE_ROW_52_Right_52 VGND VGND VPWR VPWR sky130_fd_sc_hd__decap_3
XTAP_TAPCELL_ROW_87_1241 VGND VPWR sky130_fd_sc_hd__tapvpwrvgnd_1
XFILLER_0_97_568 VGND VGND VPWR VPWR sky130_fd_sc_hd__decap_4
XFILLER_0_69_248 VGND VGND VPWR VPWR sky130_fd_sc_hd__decap_3
XFILLER_0_69_237 VGND VGND VPWR VPWR sky130_fd_sc_hd__decap_4
XFILLER_0_97_579 VGND VGND VPWR VPWR sky130_fd_sc_hd__decap_6
XFILLER_0_84_229 VGND VGND VPWR VPWR sky130_fd_sc_hd__fill_1
XFILLER_0_108_501 VPWR VGND VPWR VGND sky130_ef_sc_hd__decap_12
XFILLER_0_77_281 VGND VGND VPWR VPWR sky130_fd_sc_hd__decap_6
XTAP_TAPCELL_ROW_41_703 VGND VPWR sky130_fd_sc_hd__tapvpwrvgnd_1
XPHY_EDGE_ROW_61_Right_61 VGND VGND VPWR VPWR sky130_fd_sc_hd__decap_3
XFILLER_0_37_167 VGND VGND VPWR VPWR sky130_fd_sc_hd__fill_1
XFILLER_0_108_589 VPWR VGND VPWR VGND sky130_ef_sc_hd__decap_12
XTAP_TAPCELL_ROW_21_482 VGND VPWR sky130_fd_sc_hd__tapvpwrvgnd_1
XFILLER_0_52_137 VGND VGND VPWR VPWR sky130_fd_sc_hd__decap_3
XFILLER_0_52_159 VGND VGND VPWR VPWR sky130_fd_sc_hd__decap_8
XFILLER_0_33_384 VGND VGND VPWR VPWR sky130_fd_sc_hd__decap_8
XFILLER_0_0_429 VGND VGND VPWR VPWR sky130_fd_sc_hd__fill_1
XFILLER_0_29_15 VPWR VGND VPWR VGND sky130_ef_sc_hd__decap_12
XPHY_EDGE_ROW_70_Right_70 VGND VGND VPWR VPWR sky130_fd_sc_hd__decap_3
XTAP_TAPCELL_ROW_49_803 VGND VPWR sky130_fd_sc_hd__tapvpwrvgnd_1
XFILLER_0_45_14 VGND VGND VPWR VPWR sky130_fd_sc_hd__decap_4
XFILLER_0_88_513 VGND VGND VPWR VPWR sky130_fd_sc_hd__decap_8
XTAP_TAPCELL_ROW_57_891 VGND VPWR sky130_fd_sc_hd__tapvpwrvgnd_1
XTAP_TAPCELL_ROW_29_571 VGND VPWR sky130_fd_sc_hd__tapvpwrvgnd_1
XFILLER_0_88_579 VGND VGND VPWR VPWR sky130_fd_sc_hd__decap_8
XFILLER_0_61_24 VGND VGND VPWR VPWR sky130_fd_sc_hd__decap_3
XFILLER_0_0_27 VGND VGND VPWR VPWR sky130_fd_sc_hd__fill_1
XFILLER_0_75_229 VGND VGND VPWR VPWR sky130_fd_sc_hd__fill_1
XFILLER_0_61_57 VPWR VGND VPWR VGND sky130_ef_sc_hd__decap_12
XFILLER_0_61_46 VGND VGND VPWR VPWR sky130_fd_sc_hd__decap_8
XFILLER_0_56_421 VGND VGND VPWR VPWR sky130_fd_sc_hd__decap_8
XFILLER_0_16_307 VGND VGND VPWR VPWR sky130_fd_sc_hd__fill_1
XFILLER_0_44_616 VGND VGND VPWR VPWR sky130_fd_sc_hd__decap_4
X_4730_ _3817_ _3832_ _3833_ VGND VGND VPWR VPWR _3834_ sky130_fd_sc_hd__nor3_4
XFILLER_0_28_178 VPWR VGND VPWR VGND sky130_ef_sc_hd__decap_12
X_4661_ _3764_ _3765_ VGND VGND VPWR VPWR _3766_ sky130_fd_sc_hd__or2_1
XFILLER_0_83_295 VGND VGND VPWR VPWR sky130_fd_sc_hd__fill_1
X_7380_ _2839_ _2840_ _2801_ VGND VGND VPWR VPWR _2880_ sky130_fd_sc_hd__or3b_1
X_6400_ _1805_ _1806_ _1672_ VGND VGND VPWR VPWR _1809_ sky130_fd_sc_hd__a21oi_1
XFILLER_0_24_373 VGND VGND VPWR VPWR sky130_fd_sc_hd__decap_3
X_6331_ _1490_ _1665_ VGND VGND VPWR VPWR _1733_ sky130_fd_sc_hd__nand2_1
X_4592_ _3694_ _3695_ _3696_ VGND VGND VPWR VPWR _3698_ sky130_fd_sc_hd__a21o_1
XFILLER_0_101_209 VPWR VGND VPWR VGND sky130_ef_sc_hd__decap_12
XFILLER_0_101_85 VPWR VGND VPWR VGND sky130_ef_sc_hd__decap_12
X_6262_ _1091_ _1657_ _1366_ VGND VGND VPWR VPWR _1658_ sky130_fd_sc_hd__mux2_1
X_6193_ _1438_ _1441_ _1439_ VGND VGND VPWR VPWR _1582_ sky130_fd_sc_hd__o21ba_1
X_5213_ _0441_ _0444_ _0429_ VGND VGND VPWR VPWR _0512_ sky130_fd_sc_hd__o21ai_1
XTAP_TAPCELL_ROW_71_1053 VGND VPWR sky130_fd_sc_hd__tapvpwrvgnd_1
X_5144_ _0432_ _0436_ VGND VGND VPWR VPWR _0437_ sky130_fd_sc_hd__xnor2_1
XFILLER_0_19_81 VGND VGND VPWR VPWR sky130_fd_sc_hd__decap_6
X_5075_ _0218_ _0360_ _0361_ VGND VGND VPWR VPWR _0362_ sky130_fd_sc_hd__and3_1
X_4026_ _2025_ VGND VGND VPWR VPWR _2036_ sky130_fd_sc_hd__buf_8
XFILLER_0_29_3 VPWR VGND VPWR VGND sky130_ef_sc_hd__decap_12
XFILLER_0_109_309 VGND VGND VPWR VPWR sky130_fd_sc_hd__fill_2
XFILLER_0_59_281 VPWR VGND VPWR VGND sky130_ef_sc_hd__decap_12
XFILLER_0_59_270 VGND VGND VPWR VPWR sky130_fd_sc_hd__decap_8
X_5977_ _0946_ _0948_ VGND VGND VPWR VPWR _1346_ sky130_fd_sc_hd__or2b_1
X_7716_ _3063_ _3212_ VGND VGND VPWR VPWR _3245_ sky130_fd_sc_hd__or2b_1
XTAP_TAPCELL_ROW_82_1182 VGND VPWR sky130_fd_sc_hd__tapvpwrvgnd_1
XFILLER_0_74_251 VGND VGND VPWR VPWR sky130_fd_sc_hd__fill_1
X_4928_ _0180_ _0186_ _0189_ _0201_ VGND VGND VPWR VPWR _0202_ sky130_fd_sc_hd__and4b_1
XFILLER_0_19_145 VGND VGND VPWR VPWR sky130_fd_sc_hd__decap_6
XFILLER_0_35_605 VGND VGND VPWR VPWR sky130_fd_sc_hd__decap_6
X_7647_ _3167_ _3168_ _3169_ _3170_ VGND VGND VPWR VPWR _3172_ sky130_fd_sc_hd__a22o_1
XFILLER_0_62_413 VGND VGND VPWR VPWR sky130_fd_sc_hd__decap_6
XFILLER_0_35_638 VPWR VGND VPWR VGND sky130_ef_sc_hd__decap_12
XFILLER_0_105_515 VPWR VGND VPWR VGND sky130_ef_sc_hd__decap_12
XFILLER_0_34_126 VGND VGND VPWR VPWR sky130_fd_sc_hd__decap_6
X_4859_ _0120_ _0121_ _0124_ VGND VGND VPWR VPWR _0127_ sky130_fd_sc_hd__and3_1
XFILLER_0_105_559 VGND VGND VPWR VPWR sky130_fd_sc_hd__fill_1
X_7578_ _2892_ VGND VGND VPWR VPWR _3096_ sky130_fd_sc_hd__inv_2
X_6529_ _1884_ _1885_ _1947_ _1948_ VGND VGND VPWR VPWR _1950_ sky130_fd_sc_hd__nor4_2
XFILLER_0_30_321 VGND VGND VPWR VPWR sky130_fd_sc_hd__decap_4
XFILLER_0_30_365 VPWR VGND VPWR VGND sky130_ef_sc_hd__decap_12
XFILLER_0_100_253 VPWR VGND VPWR VGND sky130_ef_sc_hd__decap_12
XFILLER_0_97_365 VGND VGND VPWR VPWR sky130_fd_sc_hd__decap_8
XTAP_TAPCELL_ROW_26_530 VGND VPWR sky130_fd_sc_hd__tapvpwrvgnd_1
XTAP_TAPCELL_ROW_26_541 VGND VPWR sky130_fd_sc_hd__tapvpwrvgnd_1
XFILLER_0_38_421 VGND VGND VPWR VPWR sky130_fd_sc_hd__decap_6
XTAP_TAPCELL_ROW_54_861 VGND VPWR sky130_fd_sc_hd__tapvpwrvgnd_1
XFILLER_0_65_251 VGND VGND VPWR VPWR sky130_fd_sc_hd__decap_8
XFILLER_0_38_465 VGND VGND VPWR VPWR sky130_fd_sc_hd__decap_8
XFILLER_0_38_498 VPWR VGND VPWR VGND sky130_ef_sc_hd__decap_12
XFILLER_0_25_137 VPWR VGND VPWR VGND sky130_ef_sc_hd__decap_12
XFILLER_0_56_57 VPWR VGND VPWR VGND sky130_ef_sc_hd__decap_12
X_5900_ _1248_ _1250_ _1259_ VGND VGND VPWR VPWR _1262_ sky130_fd_sc_hd__and3_1
XTAP_TAPCELL_ROW_105_1447 VGND VPWR sky130_fd_sc_hd__tapvpwrvgnd_1
X_6880_ _3310_ _0094_ _2330_ _2332_ VGND VGND VPWR VPWR _2333_ sky130_fd_sc_hd__nand4_2
XFILLER_0_88_365 VGND VGND VPWR VPWR sky130_fd_sc_hd__fill_2
XFILLER_0_76_516 VPWR VGND VPWR VGND sky130_ef_sc_hd__decap_12
X_5831_ _1049_ _1040_ _1048_ VGND VGND VPWR VPWR _1187_ sky130_fd_sc_hd__a21bo_1
X_5762_ _1109_ _0996_ _1110_ VGND VGND VPWR VPWR _1111_ sky130_fd_sc_hd__o21ba_1
XFILLER_0_84_582 VGND VGND VPWR VPWR sky130_fd_sc_hd__decap_6
XFILLER_0_84_560 VGND VGND VPWR VPWR sky130_fd_sc_hd__fill_2
X_7501_ _2810_ _3011_ VGND VGND VPWR VPWR _3013_ sky130_fd_sc_hd__nand2_1
XFILLER_0_29_498 VGND VGND VPWR VPWR sky130_fd_sc_hd__decap_6
XFILLER_0_44_413 VGND VGND VPWR VPWR sky130_fd_sc_hd__decap_6
X_4713_ _3764_ _3816_ VGND VGND VPWR VPWR _3817_ sky130_fd_sc_hd__xnor2_1
XFILLER_0_71_210 VGND VGND VPWR VPWR sky130_fd_sc_hd__fill_1
X_5693_ _0332_ _1381_ VGND VGND VPWR VPWR _1036_ sky130_fd_sc_hd__nand2_1
XFILLER_0_17_649 VGND VGND VPWR VPWR sky130_fd_sc_hd__decap_3
XTAP_TAPCELL_ROW_32_599 VGND VPWR sky130_fd_sc_hd__tapvpwrvgnd_1
X_7432_ _2935_ _2936_ VGND VGND VPWR VPWR _2937_ sky130_fd_sc_hd__xor2_1
X_4644_ net29 _3748_ VGND VGND VPWR VPWR _3749_ sky130_fd_sc_hd__nand2_4
XFILLER_0_32_608 VPWR VGND VPWR VGND sky130_ef_sc_hd__decap_12
X_7363_ _2858_ _2859_ _2860_ VGND VGND VPWR VPWR _2861_ sky130_fd_sc_hd__o21ai_1
XFILLER_0_97_31 VPWR VGND VPWR VGND sky130_ef_sc_hd__decap_12
X_4575_ _3625_ _3626_ VGND VGND VPWR VPWR _3681_ sky130_fd_sc_hd__nor2_1
XFILLER_0_24_170 VGND VGND VPWR VPWR sky130_fd_sc_hd__decap_4
XFILLER_0_102_529 VGND VGND VPWR VPWR sky130_fd_sc_hd__decap_3
X_7294_ _2778_ _2785_ VGND VGND VPWR VPWR _2786_ sky130_fd_sc_hd__xnor2_1
XFILLER_0_4_587 VGND VGND VPWR VPWR sky130_fd_sc_hd__fill_1
X_6314_ _1712_ _1713_ VGND VGND VPWR VPWR _1714_ sky130_fd_sc_hd__and2b_1
X_6245_ _1637_ _1636_ _1493_ _1495_ VGND VGND VPWR VPWR _1639_ sky130_fd_sc_hd__o211a_1
X_6176_ _1560_ _1561_ _1447_ _1532_ VGND VGND VPWR VPWR _1563_ sky130_fd_sc_hd__o211a_1
XFILLER_0_99_608 VGND VGND VPWR VPWR sky130_fd_sc_hd__decap_8
X_5127_ _3489_ _0412_ _0416_ _0417_ VGND VGND VPWR VPWR _0418_ sky130_fd_sc_hd__o211a_1
XFILLER_0_98_118 VGND VGND VPWR VPWR sky130_fd_sc_hd__fill_1
X_5058_ _0340_ _0341_ _0339_ VGND VGND VPWR VPWR _0343_ sky130_fd_sc_hd__o21ai_1
XPHY_EDGE_ROW_2_Right_2 VGND VGND VPWR VPWR sky130_fd_sc_hd__decap_3
XTAP_TAPCELL_ROW_84_1200 VGND VPWR sky130_fd_sc_hd__tapvpwrvgnd_1
X_4009_ _1839_ VGND VGND VPWR VPWR _1850_ sky130_fd_sc_hd__clkbuf_4
XFILLER_0_1_81 VPWR VGND VPWR VGND sky130_ef_sc_hd__decap_12
XFILLER_0_94_346 VGND VGND VPWR VPWR sky130_fd_sc_hd__decap_3
XTAP_TAPCELL_ROW_23_500 VGND VPWR sky130_fd_sc_hd__tapvpwrvgnd_1
XTAP_TAPCELL_ROW_51_820 VGND VPWR sky130_fd_sc_hd__tapvpwrvgnd_1
XFILLER_0_75_593 VPWR VGND VPWR VGND sky130_ef_sc_hd__decap_12
XFILLER_0_35_457 VGND VGND VPWR VPWR sky130_fd_sc_hd__decap_3
XFILLER_0_90_585 VGND VGND VPWR VPWR sky130_fd_sc_hd__decap_3
XFILLER_0_90_574 VGND VGND VPWR VPWR sky130_fd_sc_hd__fill_2
XFILLER_0_15_181 VPWR VGND VPWR VGND sky130_ef_sc_hd__decap_12
XFILLER_0_50_449 VGND VGND VPWR VPWR sky130_fd_sc_hd__decap_4
XFILLER_0_31_641 VGND VGND VPWR VPWR sky130_fd_sc_hd__decap_8
XFILLER_0_30_184 VGND VGND VPWR VPWR sky130_fd_sc_hd__decap_3
XTAP_TAPCELL_ROW_59_920 VGND VPWR sky130_fd_sc_hd__tapvpwrvgnd_1
XFILLER_0_26_27 VGND VGND VPWR VPWR sky130_fd_sc_hd__fill_1
XFILLER_0_85_335 VGND VGND VPWR VPWR sky130_fd_sc_hd__fill_1
XFILLER_0_42_59 VGND VGND VPWR VPWR sky130_fd_sc_hd__fill_1
XFILLER_0_109_651 VGND VGND VPWR VPWR sky130_fd_sc_hd__fill_1
XFILLER_0_66_571 VPWR VGND VPWR VGND sky130_ef_sc_hd__decap_12
XFILLER_0_26_413 VGND VGND VPWR VPWR sky130_fd_sc_hd__decap_6
XFILLER_0_38_251 VGND VGND VPWR VPWR sky130_fd_sc_hd__fill_1
XFILLER_0_38_262 VGND VGND VPWR VPWR sky130_fd_sc_hd__fill_2
XFILLER_0_93_390 VGND VGND VPWR VPWR sky130_fd_sc_hd__fill_2
XFILLER_0_5_329 VGND VGND VPWR VPWR sky130_fd_sc_hd__decap_6
XFILLER_0_26_446 VPWR VGND VPWR VGND sky130_ef_sc_hd__decap_12
XTAP_TAPCELL_ROW_100_1388 VGND VPWR sky130_fd_sc_hd__tapvpwrvgnd_1
XFILLER_0_81_585 VPWR VGND VPWR VGND sky130_ef_sc_hd__decap_12
XFILLER_0_81_574 VGND VGND VPWR VPWR sky130_fd_sc_hd__fill_1
XFILLER_0_41_405 VPWR VGND VPWR VGND sky130_ef_sc_hd__decap_12
XANTENNA_3 _1752_ VGND VGND VPWR VPWR sky130_fd_sc_hd__diode_2
X_4360_ _3468_ _3469_ _3320_ VGND VGND VPWR VPWR _3470_ sky130_fd_sc_hd__mux2_1
XFILLER_0_6_15 VPWR VGND VPWR VGND sky130_ef_sc_hd__decap_12
XFILLER_0_22_641 VGND VGND VPWR VPWR sky130_fd_sc_hd__decap_3
XFILLER_0_21_162 VGND VGND VPWR VPWR sky130_fd_sc_hd__decap_6
X_4291_ _3289_ _3355_ VGND VGND VPWR VPWR _3402_ sky130_fd_sc_hd__or2_1
XFILLER_0_67_34 VGND VGND VPWR VPWR sky130_fd_sc_hd__decap_8
X_6030_ _3287_ _1075_ VGND VGND VPWR VPWR _1404_ sky130_fd_sc_hd__nand2_1
XFILLER_0_107_51 VGND VGND VPWR VPWR sky130_fd_sc_hd__decap_4
XFILLER_0_89_641 VGND VGND VPWR VPWR sky130_fd_sc_hd__decap_8
XFILLER_0_83_55 VGND VGND VPWR VPWR sky130_fd_sc_hd__fill_1
Xrebuffer15 _0483_ VGND VGND VPWR VPWR net133 sky130_fd_sc_hd__buf_6
XTAP_TAPCELL_ROW_37_658 VGND VPWR sky130_fd_sc_hd__tapvpwrvgnd_1
X_6932_ _2387_ _2388_ _2328_ _2242_ VGND VGND VPWR VPWR _2390_ sky130_fd_sc_hd__o211a_1
X_6863_ _0191_ _2314_ _1088_ VGND VGND VPWR VPWR _2315_ sky130_fd_sc_hd__a21oi_1
XFILLER_0_76_335 VPWR VGND VPWR VGND sky130_ef_sc_hd__decap_12
XFILLER_0_76_302 VGND VGND VPWR VPWR sky130_fd_sc_hd__decap_6
XTAP_TAPCELL_ROW_65_989 VGND VPWR sky130_fd_sc_hd__tapvpwrvgnd_1
XFILLER_0_76_368 VPWR VGND VPWR VGND sky130_ef_sc_hd__decap_12
X_5814_ _1161_ _1167_ VGND VGND VPWR VPWR _1168_ sky130_fd_sc_hd__xnor2_1
XFILLER_0_29_262 VPWR VGND VPWR VGND sky130_ef_sc_hd__decap_12
X_6794_ _2221_ _2223_ _2237_ VGND VGND VPWR VPWR _2239_ sky130_fd_sc_hd__or3_1
XFILLER_0_106_109 VGND VGND VPWR VPWR sky130_fd_sc_hd__fill_2
X_5745_ _0382_ _0196_ _1092_ _0110_ _3475_ VGND VGND VPWR VPWR _1093_ sky130_fd_sc_hd__a221oi_1
XFILLER_0_29_295 VPWR VGND VPWR VGND sky130_ef_sc_hd__decap_12
XFILLER_0_44_221 VGND VGND VPWR VPWR sky130_fd_sc_hd__decap_8
X_5676_ _0862_ _0864_ VGND VGND VPWR VPWR _1017_ sky130_fd_sc_hd__nand2_1
X_7415_ _2915_ _2916_ _2917_ VGND VGND VPWR VPWR _2918_ sky130_fd_sc_hd__nor3_1
X_4627_ _2539_ _3732_ _3651_ VGND VGND VPWR VPWR _3733_ sky130_fd_sc_hd__a21oi_1
XFILLER_0_32_438 VGND VGND VPWR VPWR sky130_fd_sc_hd__fill_2
XFILLER_0_13_641 VGND VGND VPWR VPWR sky130_fd_sc_hd__decap_8
XFILLER_0_102_348 VPWR VGND VPWR VGND sky130_ef_sc_hd__decap_12
X_4558_ _3663_ _3408_ _3358_ _2802_ _3664_ VGND VGND VPWR VPWR _3665_ sky130_fd_sc_hd__o221a_1
X_7346_ _2606_ _2642_ VGND VGND VPWR VPWR _2843_ sky130_fd_sc_hd__nand2_1
XFILLER_0_12_173 VPWR VGND VPWR VGND sky130_ef_sc_hd__decap_12
XTAP_TAPCELL_ROW_9_339 VGND VPWR sky130_fd_sc_hd__tapvpwrvgnd_1
XFILLER_0_4_395 VGND VGND VPWR VPWR sky130_fd_sc_hd__decap_8
X_4489_ _3338_ _3392_ VGND VGND VPWR VPWR _3597_ sky130_fd_sc_hd__and2_2
X_7277_ _1675_ _1031_ VGND VGND VPWR VPWR _2767_ sky130_fd_sc_hd__nand2_1
X_6228_ _1617_ _1618_ _1619_ VGND VGND VPWR VPWR _1620_ sky130_fd_sc_hd__nand3_4
XTAP_TAPCELL_ROW_90_1270 VGND VPWR sky130_fd_sc_hd__tapvpwrvgnd_1
X_6159_ _1536_ _1543_ VGND VGND VPWR VPWR _1545_ sky130_fd_sc_hd__xnor2_1
XFILLER_0_99_449 VGND VGND VPWR VPWR sky130_fd_sc_hd__decap_3
XFILLER_0_67_335 VGND VGND VPWR VPWR sky130_fd_sc_hd__fill_1
XFILLER_0_67_302 VGND VGND VPWR VPWR sky130_fd_sc_hd__fill_2
XFILLER_0_94_165 VGND VGND VPWR VPWR sky130_fd_sc_hd__decap_6
XFILLER_0_12_29 VPWR VGND VPWR VGND sky130_ef_sc_hd__decap_12
XFILLER_0_106_643 VGND VGND VPWR VPWR sky130_fd_sc_hd__fill_1
XFILLER_0_23_449 VPWR VGND VPWR VGND sky130_ef_sc_hd__decap_12
Xoutput73 net73 VGND VGND VPWR VPWR result[13] sky130_fd_sc_hd__buf_2
Xoutput84 net84 VGND VGND VPWR VPWR result[23] sky130_fd_sc_hd__buf_2
Xoutput95 net95 VGND VGND VPWR VPWR result[4] sky130_fd_sc_hd__buf_2
XFILLER_0_53_69 VGND VGND VPWR VPWR sky130_fd_sc_hd__fill_1
XTAP_TAPCELL_ROW_102_1406 VGND VPWR sky130_fd_sc_hd__tapvpwrvgnd_1
XTAP_TAPCELL_ROW_62_948 VGND VPWR sky130_fd_sc_hd__tapvpwrvgnd_1
XTAP_TAPCELL_ROW_34_628 VGND VPWR sky130_fd_sc_hd__tapvpwrvgnd_1
XFILLER_0_85_165 VGND VGND VPWR VPWR sky130_fd_sc_hd__decap_3
X_3860_ _0192_ _0203_ _0213_ VGND VGND VPWR VPWR _0224_ sky130_fd_sc_hd__or3b_1
XFILLER_0_46_519 VGND VGND VPWR VPWR sky130_fd_sc_hd__fill_2
XFILLER_0_26_221 VPWR VGND VPWR VGND sky130_ef_sc_hd__decap_12
XTAP_TAPCELL_ROW_14_396 VGND VPWR sky130_fd_sc_hd__tapvpwrvgnd_1
X_5530_ _0749_ _0812_ _0814_ VGND VGND VPWR VPWR _0858_ sky130_fd_sc_hd__nand3_1
XFILLER_0_81_393 VPWR VGND VPWR VGND sky130_ef_sc_hd__decap_12
X_5461_ _0779_ _0781_ _0668_ _0670_ VGND VGND VPWR VPWR _0783_ sky130_fd_sc_hd__a211o_1
X_7200_ _0322_ _0072_ _1089_ VGND VGND VPWR VPWR _2683_ sky130_fd_sc_hd__mux2_1
XFILLER_0_78_11 VGND VGND VPWR VPWR sky130_fd_sc_hd__fill_1
X_4412_ _3520_ VGND VGND VPWR VPWR _3521_ sky130_fd_sc_hd__buf_4
XFILLER_0_41_235 VPWR VGND VPWR VGND sky130_ef_sc_hd__decap_12
X_5392_ _0705_ _0706_ _0707_ VGND VGND VPWR VPWR _0708_ sky130_fd_sc_hd__a21oi_1
XPHY_EDGE_ROW_99_Right_99 VGND VGND VPWR VPWR sky130_fd_sc_hd__decap_3
X_4343_ _3316_ _1468_ _3308_ VGND VGND VPWR VPWR _3454_ sky130_fd_sc_hd__mux2_2
XFILLER_0_78_77 VGND VGND VPWR VPWR sky130_fd_sc_hd__decap_6
XFILLER_0_10_622 VPWR VGND VPWR VGND sky130_ef_sc_hd__decap_12
X_7131_ _2451_ _2449_ VGND VGND VPWR VPWR _2608_ sky130_fd_sc_hd__or2b_1
X_4274_ _3384_ _3385_ _3311_ VGND VGND VPWR VPWR _3386_ sky130_fd_sc_hd__mux2_4
X_7062_ _2347_ _2499_ _2530_ _2531_ VGND VGND VPWR VPWR _2532_ sky130_fd_sc_hd__a211oi_1
XTAP_TAPCELL_ROW_6_309 VGND VPWR sky130_fd_sc_hd__tapvpwrvgnd_1
X_6013_ _1345_ _1353_ _1384_ VGND VGND VPWR VPWR _1385_ sky130_fd_sc_hd__a21o_1
XFILLER_0_94_98 VGND VGND VPWR VPWR sky130_fd_sc_hd__fill_2
XTAP_TAPCELL_ROW_68_1014 VGND VPWR sky130_fd_sc_hd__tapvpwrvgnd_1
X_6915_ _1501_ _1391_ VGND VGND VPWR VPWR _2371_ sky130_fd_sc_hd__nand2_1
XFILLER_0_11_3 VPWR VGND VPWR VGND sky130_ef_sc_hd__decap_12
XFILLER_0_76_176 VPWR VGND VPWR VGND sky130_ef_sc_hd__decap_12
XFILLER_0_9_421 VGND VGND VPWR VPWR sky130_fd_sc_hd__fill_1
X_6846_ _2293_ _2294_ _2129_ _2131_ VGND VGND VPWR VPWR _2296_ sky130_fd_sc_hd__o211ai_1
XFILLER_0_91_135 VPWR VGND VPWR VGND sky130_ef_sc_hd__decap_12
XFILLER_0_91_113 VGND VGND VPWR VPWR sky130_fd_sc_hd__fill_1
X_6777_ _2104_ _2111_ VGND VGND VPWR VPWR _2220_ sky130_fd_sc_hd__and2_1
X_5728_ _0941_ _1073_ VGND VGND VPWR VPWR _1074_ sky130_fd_sc_hd__xnor2_2
X_3989_ _1621_ VGND VGND VPWR VPWR _1632_ sky130_fd_sc_hd__clkbuf_4
XTAP_TAPCELL_ROW_79_1143 VGND VPWR sky130_fd_sc_hd__tapvpwrvgnd_1
XFILLER_0_60_533 VGND VGND VPWR VPWR sky130_fd_sc_hd__fill_2
X_5659_ _0984_ _0997_ VGND VGND VPWR VPWR _0999_ sky130_fd_sc_hd__xnor2_2
X_7329_ _2818_ _2823_ VGND VGND VPWR VPWR _2825_ sky130_fd_sc_hd__xnor2_1
XFILLER_0_7_91 VGND VGND VPWR VPWR sky130_fd_sc_hd__decap_8
XFILLER_0_95_441 VGND VGND VPWR VPWR sky130_fd_sc_hd__decap_6
XFILLER_0_95_430 VGND VGND VPWR VPWR sky130_fd_sc_hd__fill_1
XFILLER_0_95_485 VPWR VGND VPWR VGND sky130_ef_sc_hd__decap_12
XFILLER_0_23_39 VGND VGND VPWR VPWR sky130_fd_sc_hd__fill_1
XFILLER_0_82_146 VPWR VGND VPWR VGND sky130_ef_sc_hd__decap_12
XFILLER_0_106_473 VGND VGND VPWR VPWR sky130_fd_sc_hd__decap_3
XFILLER_0_63_393 VGND VGND VPWR VPWR sky130_fd_sc_hd__fill_1
XTAP_TAPCELL_ROW_11_366 VGND VPWR sky130_fd_sc_hd__tapvpwrvgnd_1
Xrebuffer6 _2122_ VGND VGND VPWR VPWR net153 sky130_fd_sc_hd__buf_6
XFILLER_0_51_577 VGND VGND VPWR VPWR sky130_fd_sc_hd__decap_8
XFILLER_0_48_36 VPWR VGND VPWR VGND sky130_ef_sc_hd__decap_12
XFILLER_0_3_27 VPWR VGND VPWR VGND sky130_ef_sc_hd__decap_12
XTAP_TAPCELL_ROW_19_455 VGND VPWR sky130_fd_sc_hd__tapvpwrvgnd_1
X_4961_ _0236_ _0237_ VGND VGND VPWR VPWR _0238_ sky130_fd_sc_hd__nor2_1
XTAP_TAPCELL_ROW_47_775 VGND VPWR sky130_fd_sc_hd__tapvpwrvgnd_1
XFILLER_0_86_485 VGND VGND VPWR VPWR sky130_fd_sc_hd__decap_4
XFILLER_0_86_474 VGND VGND VPWR VPWR sky130_fd_sc_hd__fill_2
X_7680_ _3067_ _3055_ _3208_ VGND VGND VPWR VPWR _3209_ sky130_fd_sc_hd__nand3_1
X_3912_ net39 VGND VGND VPWR VPWR _0791_ sky130_fd_sc_hd__buf_2
X_4892_ _0160_ _0161_ _0128_ VGND VGND VPWR VPWR _0163_ sky130_fd_sc_hd__a21o_1
X_6700_ _2133_ _2134_ _1961_ VGND VGND VPWR VPWR _2137_ sky130_fd_sc_hd__a21oi_1
XFILLER_0_104_41 VPWR VGND VPWR VGND sky130_ef_sc_hd__decap_12
X_3843_ net66 VGND VGND VPWR VPWR _0039_ sky130_fd_sc_hd__buf_2
X_6631_ _2023_ _2024_ _2059_ _2060_ VGND VGND VPWR VPWR _2061_ sky130_fd_sc_hd__a211oi_1
XFILLER_0_104_85 VPWR VGND VPWR VGND sky130_ef_sc_hd__decap_12
X_6562_ _0192_ _0933_ _1089_ VGND VGND VPWR VPWR _1986_ sky130_fd_sc_hd__mux2_1
XFILLER_0_89_21 VPWR VGND VPWR VGND sky130_ef_sc_hd__decap_12
XFILLER_0_61_319 VGND VGND VPWR VPWR sky130_fd_sc_hd__fill_2
XFILLER_0_6_457 VPWR VGND VPWR VGND sky130_ef_sc_hd__decap_12
XFILLER_0_42_522 VGND VGND VPWR VPWR sky130_fd_sc_hd__fill_2
X_5513_ _0838_ _3651_ _0839_ VGND VGND VPWR VPWR _0840_ sky130_fd_sc_hd__or3b_1
X_6493_ _1764_ _1782_ _1783_ VGND VGND VPWR VPWR _1910_ sky130_fd_sc_hd__nand3_1
XFILLER_0_89_98 VGND VGND VPWR VPWR sky130_fd_sc_hd__decap_3
X_5444_ _0761_ _0762_ _0760_ VGND VGND VPWR VPWR _0764_ sky130_fd_sc_hd__o21ai_1
XFILLER_0_59_3 VPWR VGND VPWR VGND sky130_ef_sc_hd__decap_12
X_7114_ _2587_ _2588_ VGND VGND VPWR VPWR _2589_ sky130_fd_sc_hd__xnor2_1
X_5375_ _0686_ _0687_ _0667_ VGND VGND VPWR VPWR _0689_ sky130_fd_sc_hd__a21oi_2
X_4326_ _3338_ _3436_ VGND VGND VPWR VPWR _3437_ sky130_fd_sc_hd__and2_1
XTAP_TAPCELL_ROW_74_1084 VGND VPWR sky130_fd_sc_hd__tapvpwrvgnd_1
X_4257_ _3304_ _3344_ _3368_ VGND VGND VPWR VPWR _3369_ sky130_fd_sc_hd__a21o_1
X_7045_ _2512_ VGND VGND VPWR VPWR _2513_ sky130_fd_sc_hd__inv_2
X_4188_ _3297_ _3299_ VGND VGND VPWR VPWR _3300_ sky130_fd_sc_hd__nand2_2
XFILLER_0_92_400 VPWR VGND VPWR VGND sky130_ef_sc_hd__decap_12
XFILLER_0_92_433 VPWR VGND VPWR VGND sky130_ef_sc_hd__decap_12
XFILLER_0_77_496 VGND VGND VPWR VPWR sky130_fd_sc_hd__fill_1
XFILLER_0_64_124 VPWR VGND VPWR VGND sky130_ef_sc_hd__decap_12
XFILLER_0_37_327 VGND VGND VPWR VPWR sky130_fd_sc_hd__decap_8
XFILLER_0_37_349 VPWR VGND VPWR VGND sky130_ef_sc_hd__decap_12
X_6829_ _2263_ _2275_ _2276_ VGND VGND VPWR VPWR _2278_ sky130_fd_sc_hd__nor3_2
XFILLER_0_49_176 VPWR VGND VPWR VGND sky130_ef_sc_hd__decap_12
XFILLER_0_92_477 VPWR VGND VPWR VGND sky130_ef_sc_hd__decap_12
XFILLER_0_9_273 VGND VGND VPWR VPWR sky130_fd_sc_hd__decap_6
XFILLER_0_64_179 VGND VGND VPWR VPWR sky130_fd_sc_hd__decap_8
XFILLER_0_45_371 VPWR VGND VPWR VGND sky130_ef_sc_hd__decap_12
XFILLER_0_20_238 VPWR VGND VPWR VGND sky130_ef_sc_hd__decap_12
XFILLER_0_33_599 VPWR VGND VPWR VGND sky130_ef_sc_hd__decap_12
XFILLER_0_103_498 VGND VGND VPWR VPWR sky130_fd_sc_hd__fill_2
XFILLER_0_0_3 VPWR VGND VPWR VGND sky130_ef_sc_hd__decap_12
XFILLER_0_83_400 VGND VGND VPWR VPWR sky130_fd_sc_hd__fill_2
XTAP_TAPCELL_ROW_16_425 VGND VPWR sky130_fd_sc_hd__tapvpwrvgnd_1
XFILLER_0_28_305 VGND VGND VPWR VPWR sky130_fd_sc_hd__decap_3
XTAP_TAPCELL_ROW_44_745 VGND VPWR sky130_fd_sc_hd__tapvpwrvgnd_1
XFILLER_0_68_485 VGND VGND VPWR VPWR sky130_fd_sc_hd__decap_3
XFILLER_0_55_113 VGND VGND VPWR VPWR sky130_fd_sc_hd__fill_1
XFILLER_0_55_124 VPWR VGND VPWR VGND sky130_ef_sc_hd__decap_12
XFILLER_0_83_455 VGND VGND VPWR VPWR sky130_fd_sc_hd__fill_2
XFILLER_0_83_444 VGND VGND VPWR VPWR sky130_fd_sc_hd__decap_4
XFILLER_0_71_617 VPWR VGND VPWR VGND sky130_ef_sc_hd__decap_12
XFILLER_0_83_488 VGND VGND VPWR VPWR sky130_fd_sc_hd__decap_8
XFILLER_0_24_533 VGND VGND VPWR VPWR sky130_fd_sc_hd__fill_2
XFILLER_0_3_449 VPWR VGND VPWR VGND sky130_ef_sc_hd__decap_12
XFILLER_0_3_438 VGND VGND VPWR VPWR sky130_fd_sc_hd__decap_8
XFILLER_0_59_57 VGND VGND VPWR VPWR sky130_fd_sc_hd__decap_8
X_5160_ _0447_ _0454_ VGND VGND VPWR VPWR _0455_ sky130_fd_sc_hd__xor2_1
XFILLER_0_75_34 VPWR VGND VPWR VGND sky130_ef_sc_hd__decap_12
X_5091_ _1960_ _0376_ _0378_ _3255_ _0379_ VGND VGND VPWR VPWR _0380_ sky130_fd_sc_hd__o221a_1
X_4111_ _2955_ VGND VGND VPWR VPWR _2966_ sky130_fd_sc_hd__buf_6
X_4042_ _2189_ _0715_ _2200_ VGND VGND VPWR VPWR _2211_ sky130_fd_sc_hd__a21oi_1
XTAP_TAPCELL_ROW_108_1478 VGND VPWR sky130_fd_sc_hd__tapvpwrvgnd_1
XFILLER_0_91_55 VGND VGND VPWR VPWR sky130_fd_sc_hd__fill_1
XFILLER_0_91_44 VGND VGND VPWR VPWR sky130_fd_sc_hd__decap_4
X_5993_ _1009_ _3376_ _3360_ VGND VGND VPWR VPWR _1364_ sky130_fd_sc_hd__mux2_1
XFILLER_0_78_249 VGND VGND VPWR VPWR sky130_fd_sc_hd__decap_3
X_4944_ _0207_ _0208_ _0217_ VGND VGND VPWR VPWR _0219_ sky130_fd_sc_hd__and3_1
XFILLER_0_86_282 VGND VGND VPWR VPWR sky130_fd_sc_hd__decap_4
XFILLER_0_59_485 VGND VGND VPWR VPWR sky130_fd_sc_hd__fill_1
X_7663_ _3004_ _3005_ _3008_ VGND VGND VPWR VPWR _3190_ sky130_fd_sc_hd__a21oi_1
X_4875_ _2857_ _2966_ _2375_ _0018_ VGND VGND VPWR VPWR _0144_ sky130_fd_sc_hd__and4_1
XFILLER_0_46_157 VPWR VGND VPWR VGND sky130_ef_sc_hd__decap_12
XFILLER_0_74_499 VGND VGND VPWR VPWR sky130_fd_sc_hd__decap_4
XFILLER_0_74_477 VGND VGND VPWR VPWR sky130_fd_sc_hd__decap_8
X_7594_ _3271_ _0944_ _1031_ _1894_ VGND VGND VPWR VPWR _3114_ sky130_fd_sc_hd__a22oi_1
X_6614_ _1868_ _1869_ VGND VGND VPWR VPWR _2042_ sky130_fd_sc_hd__nand2_1
XFILLER_0_6_265 VGND VGND VPWR VPWR sky130_fd_sc_hd__decap_4
XFILLER_0_15_533 VGND VGND VPWR VPWR sky130_fd_sc_hd__decap_4
XFILLER_0_27_393 VPWR VGND VPWR VGND sky130_ef_sc_hd__decap_12
XFILLER_0_40_70 VPWR VGND VPWR VGND sky130_ef_sc_hd__decap_12
X_6545_ _1809_ _1646_ _1808_ _1645_ VGND VGND VPWR VPWR _1967_ sky130_fd_sc_hd__or4_4
XTAP_TAPCELL_ROW_76_1113 VGND VPWR sky130_fd_sc_hd__tapvpwrvgnd_1
XPHY_EDGE_ROW_18_Left_128 VGND VGND VPWR VPWR sky130_fd_sc_hd__decap_3
XFILLER_0_30_525 VGND VGND VPWR VPWR sky130_fd_sc_hd__decap_6
X_6476_ _1888_ _1889_ _1890_ VGND VGND VPWR VPWR _1891_ sky130_fd_sc_hd__and3_1
X_5427_ _0743_ _0744_ VGND VGND VPWR VPWR _0745_ sky130_fd_sc_hd__nand2_1
XFILLER_0_10_260 VGND VGND VPWR VPWR sky130_fd_sc_hd__decap_8
X_5358_ _0668_ _0669_ _0332_ _0240_ VGND VGND VPWR VPWR _0670_ sky130_fd_sc_hd__and4bb_1
X_4309_ _3290_ _3363_ _3404_ _3419_ VGND VGND VPWR VPWR _3420_ sky130_fd_sc_hd__a31o_1
X_5289_ _3606_ VGND VGND VPWR VPWR _0596_ sky130_fd_sc_hd__clkbuf_4
X_7028_ _2492_ _2493_ VGND VGND VPWR VPWR _2494_ sky130_fd_sc_hd__and2_1
XFILLER_0_97_503 VGND VGND VPWR VPWR sky130_fd_sc_hd__fill_1
XTAP_TAPCELL_ROW_87_1242 VGND VPWR sky130_fd_sc_hd__tapvpwrvgnd_1
XPHY_EDGE_ROW_27_Left_137 VGND VGND VPWR VPWR sky130_fd_sc_hd__decap_3
XFILLER_0_65_400 VPWR VGND VPWR VGND sky130_ef_sc_hd__decap_12
XFILLER_0_37_102 VGND VGND VPWR VPWR sky130_fd_sc_hd__decap_8
XFILLER_0_37_113 VPWR VGND VPWR VGND sky130_ef_sc_hd__decap_12
XTAP_TAPCELL_ROW_41_704 VGND VPWR sky130_fd_sc_hd__tapvpwrvgnd_1
XFILLER_0_108_513 VPWR VGND VPWR VGND sky130_ef_sc_hd__decap_12
XFILLER_0_52_105 VPWR VGND VPWR VGND sky130_ef_sc_hd__decap_12
XFILLER_0_53_617 VPWR VGND VPWR VGND sky130_ef_sc_hd__decap_12
XFILLER_0_80_458 VGND VGND VPWR VPWR sky130_fd_sc_hd__fill_2
XFILLER_0_80_447 VGND VGND VPWR VPWR sky130_fd_sc_hd__fill_1
XFILLER_0_20_29 VGND VGND VPWR VPWR sky130_fd_sc_hd__decap_6
XFILLER_0_52_149 VGND VGND VPWR VPWR sky130_fd_sc_hd__decap_3
XTAP_TAPCELL_ROW_98_1360 VGND VPWR sky130_fd_sc_hd__tapvpwrvgnd_1
XFILLER_0_21_514 VGND VGND VPWR VPWR sky130_fd_sc_hd__decap_4
XTAP_TAPCELL_ROW_21_483 VGND VPWR sky130_fd_sc_hd__tapvpwrvgnd_1
XFILLER_0_33_341 VGND VGND VPWR VPWR sky130_fd_sc_hd__fill_1
XPHY_EDGE_ROW_36_Left_146 VGND VGND VPWR VPWR sky130_fd_sc_hd__decap_3
XFILLER_0_103_251 VGND VGND VPWR VPWR sky130_fd_sc_hd__decap_4
XFILLER_0_29_27 VGND VGND VPWR VPWR sky130_fd_sc_hd__decap_8
XTAP_TAPCELL_ROW_49_804 VGND VPWR sky130_fd_sc_hd__tapvpwrvgnd_1
XPHY_EDGE_ROW_45_Left_155 VGND VGND VPWR VPWR sky130_fd_sc_hd__decap_3
XTAP_TAPCELL_ROW_29_572 VGND VPWR sky130_fd_sc_hd__tapvpwrvgnd_1
XTAP_TAPCELL_ROW_57_892 VGND VPWR sky130_fd_sc_hd__tapvpwrvgnd_1
XFILLER_0_61_69 VGND VGND VPWR VPWR sky130_fd_sc_hd__decap_4
XFILLER_0_9_15 VPWR VGND VPWR VGND sky130_ef_sc_hd__decap_12
XFILLER_0_28_168 VGND VGND VPWR VPWR sky130_fd_sc_hd__decap_3
X_4660_ _3287_ _2353_ _2506_ _3331_ VGND VGND VPWR VPWR _3765_ sky130_fd_sc_hd__a22oi_1
XPHY_EDGE_ROW_54_Left_164 VGND VGND VPWR VPWR sky130_fd_sc_hd__decap_3
XFILLER_0_3_213 VGND VGND VPWR VPWR sky130_fd_sc_hd__fill_2
X_6330_ _1729_ _1731_ VGND VGND VPWR VPWR _1732_ sky130_fd_sc_hd__and2b_1
X_4591_ _3694_ _3695_ _3696_ VGND VGND VPWR VPWR _3697_ sky130_fd_sc_hd__nand3_1
XFILLER_0_101_97 VPWR VGND VPWR VGND sky130_ef_sc_hd__decap_12
X_6261_ _1364_ _1656_ _0842_ VGND VGND VPWR VPWR _1657_ sky130_fd_sc_hd__mux2_1
XFILLER_0_86_11 VGND VGND VPWR VPWR sky130_fd_sc_hd__fill_1
XFILLER_0_3_279 VGND VGND VPWR VPWR sky130_fd_sc_hd__fill_1
X_5212_ _0500_ _0510_ VGND VGND VPWR VPWR _0511_ sky130_fd_sc_hd__nand2_1
X_6192_ _0278_ _1580_ VGND VGND VPWR VPWR _1581_ sky130_fd_sc_hd__xnor2_1
XFILLER_0_50_7 VGND VGND VPWR VPWR sky130_fd_sc_hd__fill_1
XFILLER_0_86_77 VGND VGND VPWR VPWR sky130_fd_sc_hd__decap_6
XTAP_TAPCELL_ROW_71_1054 VGND VPWR sky130_fd_sc_hd__tapvpwrvgnd_1
X_5143_ _0434_ _0435_ VGND VGND VPWR VPWR _0436_ sky130_fd_sc_hd__nor2_1
XPHY_EDGE_ROW_63_Left_173 VGND VGND VPWR VPWR sky130_fd_sc_hd__decap_3
X_5074_ _0358_ _0359_ _0259_ _0307_ VGND VGND VPWR VPWR _0361_ sky130_fd_sc_hd__o211ai_2
X_4025_ net6 VGND VGND VPWR VPWR _2025_ sky130_fd_sc_hd__buf_6
XFILLER_0_79_558 VGND VGND VPWR VPWR sky130_fd_sc_hd__fill_2
XFILLER_0_35_81 VPWR VGND VPWR VGND sky130_ef_sc_hd__decap_12
XFILLER_0_19_113 VPWR VGND VPWR VGND sky130_ef_sc_hd__decap_12
X_5976_ _1208_ _1344_ VGND VGND VPWR VPWR _1345_ sky130_fd_sc_hd__xnor2_2
X_7715_ _3237_ _3242_ _3243_ _3244_ VGND VGND VPWR VPWR net68 sky130_fd_sc_hd__a2bb2o_1
X_4927_ _0191_ _0200_ _3489_ VGND VGND VPWR VPWR _0201_ sky130_fd_sc_hd__mux2_1
XTAP_TAPCELL_ROW_82_1183 VGND VPWR sky130_fd_sc_hd__tapvpwrvgnd_1
XFILLER_0_59_293 VGND VGND VPWR VPWR sky130_fd_sc_hd__decap_4
X_7646_ _3167_ _3168_ _3169_ _3170_ VGND VGND VPWR VPWR _3171_ sky130_fd_sc_hd__and4_1
XPHY_EDGE_ROW_72_Left_182 VGND VGND VPWR VPWR sky130_fd_sc_hd__decap_3
XFILLER_0_35_617 VPWR VGND VPWR VGND sky130_ef_sc_hd__decap_12
X_4858_ _0120_ _0121_ _0124_ VGND VGND VPWR VPWR _0125_ sky130_fd_sc_hd__a21oi_2
XFILLER_0_105_527 VGND VGND VPWR VPWR sky130_fd_sc_hd__decap_4
XFILLER_0_105_505 VGND VGND VPWR VPWR sky130_fd_sc_hd__decap_6
XFILLER_0_7_574 VGND VGND VPWR VPWR sky130_fd_sc_hd__decap_3
XFILLER_0_34_138 VGND VGND VPWR VPWR sky130_fd_sc_hd__fill_2
XFILLER_0_51_91 VGND VGND VPWR VPWR sky130_fd_sc_hd__fill_2
X_7577_ _3087_ _3094_ VGND VGND VPWR VPWR _3095_ sky130_fd_sc_hd__xnor2_1
X_4789_ _0048_ _0049_ VGND VGND VPWR VPWR _0051_ sky130_fd_sc_hd__nor2_1
X_6528_ _1945_ _1946_ _1787_ _1886_ VGND VGND VPWR VPWR _1948_ sky130_fd_sc_hd__a211oi_1
X_6459_ _1869_ _1870_ _1865_ VGND VGND VPWR VPWR _1873_ sky130_fd_sc_hd__a21o_1
XFILLER_0_30_377 VPWR VGND VPWR VGND sky130_ef_sc_hd__decap_12
XFILLER_0_100_265 VGND VGND VPWR VPWR sky130_fd_sc_hd__decap_8
XPHY_EDGE_ROW_81_Left_191 VGND VGND VPWR VPWR sky130_fd_sc_hd__decap_3
XTAP_TAPCELL_ROW_26_531 VGND VPWR sky130_fd_sc_hd__tapvpwrvgnd_1
XTAP_TAPCELL_ROW_54_862 VGND VPWR sky130_fd_sc_hd__tapvpwrvgnd_1
XFILLER_0_38_477 VGND VGND VPWR VPWR sky130_fd_sc_hd__decap_3
XFILLER_0_80_288 VGND VGND VPWR VPWR sky130_fd_sc_hd__decap_4
XFILLER_0_0_205 VGND VGND VPWR VPWR sky130_fd_sc_hd__fill_1
XFILLER_0_0_238 VGND VGND VPWR VPWR sky130_fd_sc_hd__fill_1
XFILLER_0_56_14 VGND VGND VPWR VPWR sky130_fd_sc_hd__fill_2
XFILLER_0_56_25 VGND VGND VPWR VPWR sky130_fd_sc_hd__decap_3
XFILLER_0_56_69 VGND VGND VPWR VPWR sky130_fd_sc_hd__fill_1
XFILLER_0_48_208 VGND VGND VPWR VPWR sky130_fd_sc_hd__fill_1
XTAP_TAPCELL_ROW_105_1448 VGND VPWR sky130_fd_sc_hd__tapvpwrvgnd_1
XFILLER_0_76_528 VGND VGND VPWR VPWR sky130_fd_sc_hd__decap_4
X_5830_ _1183_ _1182_ _1175_ VGND VGND VPWR VPWR _1186_ sky130_fd_sc_hd__a21o_1
X_5761_ _3328_ _1217_ _0997_ VGND VGND VPWR VPWR _1110_ sky130_fd_sc_hd__and3_1
X_7500_ _2810_ _3011_ VGND VGND VPWR VPWR _3012_ sky130_fd_sc_hd__or2_1
XFILLER_0_56_274 VPWR VGND VPWR VGND sky130_ef_sc_hd__decap_12
XFILLER_0_56_263 VGND VGND VPWR VPWR sky130_fd_sc_hd__fill_1
XFILLER_0_16_105 VGND VGND VPWR VPWR sky130_fd_sc_hd__fill_2
XFILLER_0_17_617 VPWR VGND VPWR VGND sky130_ef_sc_hd__decap_12
X_4712_ _3808_ _3815_ VGND VGND VPWR VPWR _3816_ sky130_fd_sc_hd__xor2_1
X_7431_ _1544_ _1173_ _2741_ _2740_ VGND VGND VPWR VPWR _2936_ sky130_fd_sc_hd__a31o_1
X_5692_ _1026_ _1034_ VGND VGND VPWR VPWR _1035_ sky130_fd_sc_hd__xnor2_2
XFILLER_0_44_425 VGND VGND VPWR VPWR sky130_fd_sc_hd__fill_1
X_4643_ net60 VGND VGND VPWR VPWR _3748_ sky130_fd_sc_hd__buf_4
XFILLER_0_4_533 VPWR VGND VPWR VGND sky130_ef_sc_hd__decap_12
X_7362_ _2858_ _2859_ _0953_ VGND VGND VPWR VPWR _2860_ sky130_fd_sc_hd__a21oi_1
X_4574_ _3606_ _3679_ VGND VGND VPWR VPWR _3680_ sky130_fd_sc_hd__nor2_1
XFILLER_0_40_631 VPWR VGND VPWR VGND sky130_ef_sc_hd__decap_12
XFILLER_0_52_480 VPWR VGND VPWR VGND sky130_ef_sc_hd__decap_12
XFILLER_0_97_43 VPWR VGND VPWR VGND sky130_ef_sc_hd__decap_12
X_7293_ _2783_ _2784_ VGND VGND VPWR VPWR _2785_ sky130_fd_sc_hd__nor2_1
X_6313_ _1710_ _1711_ _1705_ VGND VGND VPWR VPWR _1713_ sky130_fd_sc_hd__a21o_1
X_6244_ _1493_ _1495_ _1636_ _1637_ VGND VGND VPWR VPWR _1638_ sky130_fd_sc_hd__a211oi_1
X_6175_ _1447_ _1532_ _1560_ _1561_ VGND VGND VPWR VPWR _1562_ sky130_fd_sc_hd__a211oi_2
XFILLER_0_41_3 VGND VGND VPWR VPWR sky130_fd_sc_hd__decap_4
X_5126_ _3742_ _3667_ _3668_ VGND VGND VPWR VPWR _0417_ sky130_fd_sc_hd__or3b_1
X_5057_ _0339_ _0340_ _0341_ VGND VGND VPWR VPWR _0342_ sky130_fd_sc_hd__or3_4
XTAP_TAPCELL_ROW_84_1201 VGND VPWR sky130_fd_sc_hd__tapvpwrvgnd_1
X_4008_ _1829_ VGND VGND VPWR VPWR _1839_ sky130_fd_sc_hd__buf_4
XFILLER_0_82_509 VPWR VGND VPWR VGND sky130_ef_sc_hd__decap_12
X_5959_ _1323_ _1324_ _1305_ VGND VGND VPWR VPWR _1327_ sky130_fd_sc_hd__a21oi_2
XFILLER_0_1_93 VPWR VGND VPWR VGND sky130_ef_sc_hd__decap_12
XTAP_TAPCELL_ROW_23_501 VGND VPWR sky130_fd_sc_hd__tapvpwrvgnd_1
XFILLER_0_47_241 VGND VGND VPWR VPWR sky130_fd_sc_hd__fill_1
XTAP_TAPCELL_ROW_51_821 VGND VPWR sky130_fd_sc_hd__tapvpwrvgnd_1
XFILLER_0_90_542 VPWR VGND VPWR VGND sky130_ef_sc_hd__decap_12
XFILLER_0_90_531 VGND VGND VPWR VPWR sky130_fd_sc_hd__fill_1
X_7629_ _3139_ _3151_ VGND VGND VPWR VPWR _3153_ sky130_fd_sc_hd__xnor2_1
XFILLER_0_7_393 VPWR VGND VPWR VGND sky130_ef_sc_hd__decap_12
XTAP_TAPCELL_ROW_95_1330 VGND VPWR sky130_fd_sc_hd__tapvpwrvgnd_1
XFILLER_0_62_288 VPWR VGND VPWR VGND sky130_ef_sc_hd__decap_12
XFILLER_0_15_160 VGND VGND VPWR VPWR sky130_fd_sc_hd__fill_1
XFILLER_0_15_193 VPWR VGND VPWR VGND sky130_ef_sc_hd__decap_12
XFILLER_0_30_141 VGND VGND VPWR VPWR sky130_fd_sc_hd__decap_4
XTAP_TAPCELL_ROW_59_910 VGND VPWR sky130_fd_sc_hd__tapvpwrvgnd_1
XFILLER_0_89_119 VGND VGND VPWR VPWR sky130_fd_sc_hd__fill_1
XTAP_TAPCELL_ROW_3_270 VGND VPWR sky130_fd_sc_hd__tapvpwrvgnd_1
XFILLER_0_109_641 VGND VGND VPWR VPWR sky130_fd_sc_hd__decap_3
XFILLER_0_66_583 VGND VGND VPWR VPWR sky130_fd_sc_hd__decap_4
XFILLER_0_108_162 VGND VGND VPWR VPWR sky130_fd_sc_hd__decap_6
XTAP_TAPCELL_ROW_100_1389 VGND VPWR sky130_fd_sc_hd__tapvpwrvgnd_1
XFILLER_0_26_458 VPWR VGND VPWR VGND sky130_ef_sc_hd__decap_12
XFILLER_0_81_597 VPWR VGND VPWR VGND sky130_ef_sc_hd__decap_12
XFILLER_0_41_417 VPWR VGND VPWR VGND sky130_ef_sc_hd__decap_12
XFILLER_0_1_503 VGND VGND VPWR VPWR sky130_fd_sc_hd__fill_1
XFILLER_0_1_525 VGND VGND VPWR VPWR sky130_fd_sc_hd__fill_2
XANTENNA_4 _2036_ VGND VGND VPWR VPWR sky130_fd_sc_hd__diode_2
XFILLER_0_67_13 VPWR VGND VPWR VGND sky130_ef_sc_hd__decap_12
XFILLER_0_6_27 VGND VGND VPWR VPWR sky130_fd_sc_hd__fill_1
X_4290_ _3289_ _3355_ VGND VGND VPWR VPWR _3401_ sky130_fd_sc_hd__nand2_1
XFILLER_0_21_185 VGND VGND VPWR VPWR sky130_fd_sc_hd__decap_4
Xrebuffer16 _1052_ VGND VGND VPWR VPWR net134 sky130_fd_sc_hd__buf_2
XFILLER_0_88_130 VGND VGND VPWR VPWR sky130_fd_sc_hd__decap_4
X_6931_ _2328_ _2242_ _2387_ _2388_ VGND VGND VPWR VPWR _2389_ sky130_fd_sc_hd__a211oi_1
X_6862_ _0382_ _1092_ _2313_ _1369_ VGND VGND VPWR VPWR _2314_ sky130_fd_sc_hd__a22oi_1
XTAP_TAPCELL_ROW_65_979 VGND VPWR sky130_fd_sc_hd__tapvpwrvgnd_1
XTAP_TAPCELL_ROW_37_659 VGND VPWR sky130_fd_sc_hd__tapvpwrvgnd_1
XFILLER_0_49_528 VGND VGND VPWR VPWR sky130_fd_sc_hd__fill_1
XFILLER_0_76_347 VGND VGND VPWR VPWR sky130_fd_sc_hd__decap_8
X_5813_ _1165_ _1166_ VGND VGND VPWR VPWR _1167_ sky130_fd_sc_hd__xnor2_1
XFILLER_0_57_561 VPWR VGND VPWR VGND sky130_ef_sc_hd__decap_12
XFILLER_0_17_414 VGND VGND VPWR VPWR sky130_fd_sc_hd__decap_6
X_6793_ _2221_ _2223_ _2237_ VGND VGND VPWR VPWR _2238_ sky130_fd_sc_hd__o21ai_2
X_5744_ _0607_ _1091_ _0402_ VGND VGND VPWR VPWR _1092_ sky130_fd_sc_hd__mux2_1
XFILLER_0_72_531 VGND VGND VPWR VPWR sky130_fd_sc_hd__fill_1
XFILLER_0_72_520 VGND VGND VPWR VPWR sky130_fd_sc_hd__fill_1
XFILLER_0_17_447 VGND VGND VPWR VPWR sky130_fd_sc_hd__fill_1
XFILLER_0_29_274 VGND VGND VPWR VPWR sky130_fd_sc_hd__decap_6
XFILLER_0_32_82 VGND VGND VPWR VPWR sky130_fd_sc_hd__fill_2
X_5675_ _1012_ _1015_ VGND VGND VPWR VPWR _1016_ sky130_fd_sc_hd__xnor2_1
X_7414_ _2712_ _2727_ VGND VGND VPWR VPWR _2917_ sky130_fd_sc_hd__and2b_1
XFILLER_0_89_3 VGND VGND VPWR VPWR sky130_fd_sc_hd__decap_8
X_4626_ _3663_ _3731_ VGND VGND VPWR VPWR _3732_ sky130_fd_sc_hd__or2_1
XFILLER_0_72_586 VGND VGND VPWR VPWR sky130_fd_sc_hd__fill_2
XFILLER_0_4_352 VPWR VGND VPWR VGND sky130_ef_sc_hd__decap_12
XFILLER_0_4_341 VGND VGND VPWR VPWR sky130_fd_sc_hd__fill_2
XFILLER_0_25_480 VGND VGND VPWR VPWR sky130_fd_sc_hd__decap_3
X_7345_ _2801_ _2841_ VGND VGND VPWR VPWR _2842_ sky130_fd_sc_hd__xnor2_1
XFILLER_0_25_491 VGND VGND VPWR VPWR sky130_fd_sc_hd__fill_2
X_4557_ _2824_ _3405_ VGND VGND VPWR VPWR _3664_ sky130_fd_sc_hd__or2_1
XFILLER_0_12_141 VGND VGND VPWR VPWR sky130_fd_sc_hd__decap_6
XFILLER_0_40_450 VGND VGND VPWR VPWR sky130_fd_sc_hd__decap_4
X_4488_ _3382_ _3386_ _3320_ VGND VGND VPWR VPWR _3596_ sky130_fd_sc_hd__mux2_1
X_7276_ _2764_ _2765_ VGND VGND VPWR VPWR _2766_ sky130_fd_sc_hd__nor2_1
XFILLER_0_12_185 VGND VGND VPWR VPWR sky130_fd_sc_hd__decap_8
X_6227_ _1466_ _1475_ _1474_ VGND VGND VPWR VPWR _1619_ sky130_fd_sc_hd__a21bo_1
XTAP_TAPCELL_ROW_90_1271 VGND VPWR sky130_fd_sc_hd__tapvpwrvgnd_1
X_6158_ _1541_ _1542_ VGND VGND VPWR VPWR _1543_ sky130_fd_sc_hd__xnor2_1
X_5109_ _3651_ _0303_ _0398_ VGND VGND VPWR VPWR net72 sky130_fd_sc_hd__o21ai_1
X_6089_ net9 net148 net10 net56 VGND VGND VPWR VPWR _1469_ sky130_fd_sc_hd__and4_1
XTAP_TAPCELL_ROW_0_240 VGND VPWR sky130_fd_sc_hd__tapvpwrvgnd_1
XFILLER_0_82_306 VGND VGND VPWR VPWR sky130_fd_sc_hd__fill_2
XFILLER_0_48_561 VGND VGND VPWR VPWR sky130_fd_sc_hd__fill_1
XFILLER_0_35_277 VGND VGND VPWR VPWR sky130_fd_sc_hd__decap_3
XFILLER_0_35_288 VPWR VGND VPWR VGND sky130_ef_sc_hd__decap_12
XFILLER_0_16_491 VGND VGND VPWR VPWR sky130_fd_sc_hd__decap_8
XFILLER_0_105_198 VGND VGND VPWR VPWR sky130_fd_sc_hd__decap_3
XFILLER_0_31_472 VPWR VGND VPWR VGND sky130_ef_sc_hd__decap_12
Xoutput85 net85 VGND VGND VPWR VPWR result[24] sky130_fd_sc_hd__clkbuf_4
Xoutput74 net74 VGND VGND VPWR VPWR result[14] sky130_fd_sc_hd__buf_2
Xoutput96 net96 VGND VGND VPWR VPWR result[5] sky130_fd_sc_hd__buf_2
XFILLER_0_86_601 VPWR VGND VPWR VGND sky130_ef_sc_hd__decap_12
XTAP_TAPCELL_ROW_102_1407 VGND VPWR sky130_fd_sc_hd__tapvpwrvgnd_1
XFILLER_0_86_645 VGND VGND VPWR VPWR sky130_fd_sc_hd__decap_6
XTAP_TAPCELL_ROW_62_949 VGND VPWR sky130_fd_sc_hd__tapvpwrvgnd_1
XTAP_TAPCELL_ROW_34_629 VGND VPWR sky130_fd_sc_hd__tapvpwrvgnd_1
XFILLER_0_39_561 VGND VGND VPWR VPWR sky130_fd_sc_hd__fill_1
XFILLER_0_39_572 VPWR VGND VPWR VGND sky130_ef_sc_hd__decap_12
XFILLER_0_66_380 VGND VGND VPWR VPWR sky130_fd_sc_hd__fill_2
XFILLER_0_54_531 VGND VGND VPWR VPWR sky130_fd_sc_hd__fill_1
XTAP_TAPCELL_ROW_14_397 VGND VPWR sky130_fd_sc_hd__tapvpwrvgnd_1
XFILLER_0_5_105 VGND VGND VPWR VPWR sky130_fd_sc_hd__decap_6
XFILLER_0_26_233 VPWR VGND VPWR VGND sky130_ef_sc_hd__decap_12
XFILLER_0_81_361 VPWR VGND VPWR VGND sky130_ef_sc_hd__decap_12
X_5460_ _0668_ _0670_ _0779_ _0781_ VGND VGND VPWR VPWR _0782_ sky130_fd_sc_hd__o211a_1
XFILLER_0_78_23 VGND VGND VPWR VPWR sky130_fd_sc_hd__decap_4
X_4411_ net53 VGND VGND VPWR VPWR _3520_ sky130_fd_sc_hd__buf_8
XFILLER_0_41_225 VGND VGND VPWR VPWR sky130_fd_sc_hd__fill_2
XFILLER_0_41_247 VGND VGND VPWR VPWR sky130_fd_sc_hd__decap_4
X_5391_ _0492_ _0585_ _0583_ VGND VGND VPWR VPWR _0707_ sky130_fd_sc_hd__a21o_1
X_4342_ _3333_ _3336_ _3335_ _3324_ _3312_ _3317_ VGND VGND VPWR VPWR _3453_ sky130_fd_sc_hd__mux4_1
XFILLER_0_10_645 VGND VGND VPWR VPWR sky130_fd_sc_hd__decap_6
XFILLER_0_10_634 VGND VGND VPWR VPWR sky130_fd_sc_hd__decap_8
XFILLER_0_1_344 VGND VGND VPWR VPWR sky130_fd_sc_hd__fill_1
XFILLER_0_22_494 VPWR VGND VPWR VGND sky130_ef_sc_hd__decap_12
X_7130_ _2602_ _2603_ _2604_ VGND VGND VPWR VPWR _2607_ sky130_fd_sc_hd__a21o_1
X_4273_ _0094_ net19 _3307_ VGND VGND VPWR VPWR _3385_ sky130_fd_sc_hd__mux2_2
X_7061_ _2515_ _2516_ _2529_ VGND VGND VPWR VPWR _2531_ sky130_fd_sc_hd__o21a_1
X_6012_ _1071_ _1205_ _1207_ _1343_ VGND VGND VPWR VPWR _1384_ sky130_fd_sc_hd__and4_1
.ends

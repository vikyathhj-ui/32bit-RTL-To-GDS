* NGSPICE file created from alu32.ext - technology: sky130A

* Black-box entry subcircuit for sky130_fd_sc_hd__a21oi_1 abstract view
.subckt sky130_fd_sc_hd__a21oi_1 A1 A2 B1 VGND VNB VPB VPWR Y
.ends

* Black-box entry subcircuit for sky130_fd_sc_hd__o32a_1 abstract view
.subckt sky130_fd_sc_hd__o32a_1 A1 A2 A3 B1 B2 VGND VNB VPB VPWR X
.ends

* Black-box entry subcircuit for sky130_fd_sc_hd__or2b_1 abstract view
.subckt sky130_fd_sc_hd__or2b_1 A B_N VGND VNB VPB VPWR X
.ends

* Black-box entry subcircuit for sky130_fd_sc_hd__tapvpwrvgnd_1 abstract view
.subckt sky130_fd_sc_hd__tapvpwrvgnd_1 VGND VPWR
.ends

* Black-box entry subcircuit for sky130_fd_sc_hd__a21o_1 abstract view
.subckt sky130_fd_sc_hd__a21o_1 A1 A2 B1 VGND VNB VPB VPWR X
.ends

* Black-box entry subcircuit for sky130_fd_sc_hd__decap_4 abstract view
.subckt sky130_fd_sc_hd__decap_4 VGND VNB VPB VPWR
.ends

* Black-box entry subcircuit for sky130_fd_sc_hd__a221o_1 abstract view
.subckt sky130_fd_sc_hd__a221o_1 A1 A2 B1 B2 C1 VGND VNB VPB VPWR X
.ends

* Black-box entry subcircuit for sky130_ef_sc_hd__decap_12 abstract view
.subckt sky130_ef_sc_hd__decap_12 VPWR VGND VPB VNB
.ends

* Black-box entry subcircuit for sky130_fd_sc_hd__fill_1 abstract view
.subckt sky130_fd_sc_hd__fill_1 VGND VNB VPB VPWR
.ends

* Black-box entry subcircuit for sky130_fd_sc_hd__decap_3 abstract view
.subckt sky130_fd_sc_hd__decap_3 VGND VNB VPB VPWR
.ends

* Black-box entry subcircuit for sky130_fd_sc_hd__fill_2 abstract view
.subckt sky130_fd_sc_hd__fill_2 VGND VNB VPB VPWR
.ends

* Black-box entry subcircuit for sky130_fd_sc_hd__decap_8 abstract view
.subckt sky130_fd_sc_hd__decap_8 VGND VNB VPB VPWR
.ends

* Black-box entry subcircuit for sky130_fd_sc_hd__o221a_1 abstract view
.subckt sky130_fd_sc_hd__o221a_1 A1 A2 B1 B2 C1 VGND VNB VPB VPWR X
.ends

* Black-box entry subcircuit for sky130_fd_sc_hd__o311a_1 abstract view
.subckt sky130_fd_sc_hd__o311a_1 A1 A2 A3 B1 C1 VGND VNB VPB VPWR X
.ends

* Black-box entry subcircuit for sky130_fd_sc_hd__o2111ai_1 abstract view
.subckt sky130_fd_sc_hd__o2111ai_1 A1 A2 B1 C1 D1 VGND VNB VPB VPWR Y
.ends

* Black-box entry subcircuit for sky130_fd_sc_hd__a311o_1 abstract view
.subckt sky130_fd_sc_hd__a311o_1 A1 A2 A3 B1 C1 VGND VNB VPB VPWR X
.ends

* Black-box entry subcircuit for sky130_fd_sc_hd__o21ai_1 abstract view
.subckt sky130_fd_sc_hd__o21ai_1 A1 A2 B1 VGND VNB VPB VPWR Y
.ends

* Black-box entry subcircuit for sky130_fd_sc_hd__clkbuf_4 abstract view
.subckt sky130_fd_sc_hd__clkbuf_4 A VGND VNB VPB VPWR X
.ends

* Black-box entry subcircuit for sky130_fd_sc_hd__nand2_1 abstract view
.subckt sky130_fd_sc_hd__nand2_1 A B VGND VNB VPB VPWR Y
.ends

* Black-box entry subcircuit for sky130_fd_sc_hd__dfrtp_1 abstract view
.subckt sky130_fd_sc_hd__dfrtp_1 CLK D RESET_B VGND VNB VPB VPWR Q
.ends

* Black-box entry subcircuit for sky130_fd_sc_hd__nor4_1 abstract view
.subckt sky130_fd_sc_hd__nor4_1 A B C D VGND VNB VPB VPWR Y
.ends

* Black-box entry subcircuit for sky130_fd_sc_hd__mux4_1 abstract view
.subckt sky130_fd_sc_hd__mux4_1 A0 A1 A2 A3 S0 S1 VGND VNB VPB VPWR X
.ends

* Black-box entry subcircuit for sky130_fd_sc_hd__decap_6 abstract view
.subckt sky130_fd_sc_hd__decap_6 VGND VNB VPB VPWR
.ends

* Black-box entry subcircuit for sky130_fd_sc_hd__o22a_1 abstract view
.subckt sky130_fd_sc_hd__o22a_1 A1 A2 B1 B2 VGND VNB VPB VPWR X
.ends

* Black-box entry subcircuit for sky130_fd_sc_hd__nand4_1 abstract view
.subckt sky130_fd_sc_hd__nand4_1 A B C D VGND VNB VPB VPWR Y
.ends

* Black-box entry subcircuit for sky130_fd_sc_hd__nand4_4 abstract view
.subckt sky130_fd_sc_hd__nand4_4 A B C D VGND VNB VPB VPWR Y
.ends

* Black-box entry subcircuit for sky130_fd_sc_hd__o21ai_2 abstract view
.subckt sky130_fd_sc_hd__o21ai_2 A1 A2 B1 VGND VNB VPB VPWR Y
.ends

* Black-box entry subcircuit for sky130_fd_sc_hd__or3_1 abstract view
.subckt sky130_fd_sc_hd__or3_1 A B C VGND VNB VPB VPWR X
.ends

* Black-box entry subcircuit for sky130_fd_sc_hd__buf_2 abstract view
.subckt sky130_fd_sc_hd__buf_2 A VGND VNB VPB VPWR X
.ends

* Black-box entry subcircuit for sky130_fd_sc_hd__nand2_4 abstract view
.subckt sky130_fd_sc_hd__nand2_4 A B VGND VNB VPB VPWR Y
.ends

* Black-box entry subcircuit for sky130_fd_sc_hd__and4b_1 abstract view
.subckt sky130_fd_sc_hd__and4b_1 A_N B C D VGND VNB VPB VPWR X
.ends

* Black-box entry subcircuit for sky130_fd_sc_hd__nor2_1 abstract view
.subckt sky130_fd_sc_hd__nor2_1 A B VGND VNB VPB VPWR Y
.ends

* Black-box entry subcircuit for sky130_fd_sc_hd__and2_2 abstract view
.subckt sky130_fd_sc_hd__and2_2 A B VGND VNB VPB VPWR X
.ends

* Black-box entry subcircuit for sky130_fd_sc_hd__a31o_1 abstract view
.subckt sky130_fd_sc_hd__a31o_1 A1 A2 A3 B1 VGND VNB VPB VPWR X
.ends

* Black-box entry subcircuit for sky130_fd_sc_hd__clkbuf_1 abstract view
.subckt sky130_fd_sc_hd__clkbuf_1 A VGND VNB VPB VPWR X
.ends

* Black-box entry subcircuit for sky130_fd_sc_hd__and2_1 abstract view
.subckt sky130_fd_sc_hd__and2_1 A B VGND VNB VPB VPWR X
.ends

* Black-box entry subcircuit for sky130_fd_sc_hd__a2bb2oi_4 abstract view
.subckt sky130_fd_sc_hd__a2bb2oi_4 A1_N A2_N B1 B2 VGND VNB VPB VPWR Y
.ends

* Black-box entry subcircuit for sky130_fd_sc_hd__inv_2 abstract view
.subckt sky130_fd_sc_hd__inv_2 A VGND VNB VPB VPWR Y
.ends

* Black-box entry subcircuit for sky130_fd_sc_hd__diode_2 abstract view
.subckt sky130_fd_sc_hd__diode_2 DIODE VGND VNB VPB VPWR
.ends

* Black-box entry subcircuit for sky130_fd_sc_hd__nand2_2 abstract view
.subckt sky130_fd_sc_hd__nand2_2 A B VGND VNB VPB VPWR Y
.ends

* Black-box entry subcircuit for sky130_fd_sc_hd__o211a_1 abstract view
.subckt sky130_fd_sc_hd__o211a_1 A1 A2 B1 C1 VGND VNB VPB VPWR X
.ends

* Black-box entry subcircuit for sky130_fd_sc_hd__a211o_1 abstract view
.subckt sky130_fd_sc_hd__a211o_1 A1 A2 B1 C1 VGND VNB VPB VPWR X
.ends

* Black-box entry subcircuit for sky130_fd_sc_hd__o21a_1 abstract view
.subckt sky130_fd_sc_hd__o21a_1 A1 A2 B1 VGND VNB VPB VPWR X
.ends

* Black-box entry subcircuit for sky130_fd_sc_hd__a221oi_1 abstract view
.subckt sky130_fd_sc_hd__a221oi_1 A1 A2 B1 B2 C1 VGND VNB VPB VPWR Y
.ends

* Black-box entry subcircuit for sky130_fd_sc_hd__nand2b_1 abstract view
.subckt sky130_fd_sc_hd__nand2b_1 A_N B VGND VNB VPB VPWR Y
.ends

* Black-box entry subcircuit for sky130_fd_sc_hd__and2b_1 abstract view
.subckt sky130_fd_sc_hd__and2b_1 A_N B VGND VNB VPB VPWR X
.ends

* Black-box entry subcircuit for sky130_fd_sc_hd__and3_1 abstract view
.subckt sky130_fd_sc_hd__and3_1 A B C VGND VNB VPB VPWR X
.ends

* Black-box entry subcircuit for sky130_fd_sc_hd__a31o_4 abstract view
.subckt sky130_fd_sc_hd__a31o_4 A1 A2 A3 B1 VGND VNB VPB VPWR X
.ends

* Black-box entry subcircuit for sky130_fd_sc_hd__mux4_2 abstract view
.subckt sky130_fd_sc_hd__mux4_2 A0 A1 A2 A3 S0 S1 VGND VNB VPB VPWR X
.ends

* Black-box entry subcircuit for sky130_fd_sc_hd__a21bo_1 abstract view
.subckt sky130_fd_sc_hd__a21bo_1 A1 A2 B1_N VGND VNB VPB VPWR X
.ends

* Black-box entry subcircuit for sky130_fd_sc_hd__o2111ai_2 abstract view
.subckt sky130_fd_sc_hd__o2111ai_2 A1 A2 B1 C1 D1 VGND VNB VPB VPWR Y
.ends

* Black-box entry subcircuit for sky130_fd_sc_hd__o311ai_2 abstract view
.subckt sky130_fd_sc_hd__o311ai_2 A1 A2 A3 B1 C1 VGND VNB VPB VPWR Y
.ends

* Black-box entry subcircuit for sky130_fd_sc_hd__buf_4 abstract view
.subckt sky130_fd_sc_hd__buf_4 A VGND VNB VPB VPWR X
.ends

* Black-box entry subcircuit for sky130_fd_sc_hd__a21boi_1 abstract view
.subckt sky130_fd_sc_hd__a21boi_1 A1 A2 B1_N VGND VNB VPB VPWR Y
.ends

* Black-box entry subcircuit for sky130_fd_sc_hd__a2bb2o_1 abstract view
.subckt sky130_fd_sc_hd__a2bb2o_1 A1_N A2_N B1 B2 VGND VNB VPB VPWR X
.ends

* Black-box entry subcircuit for sky130_fd_sc_hd__mux2_1 abstract view
.subckt sky130_fd_sc_hd__mux2_1 A0 A1 S VGND VNB VPB VPWR X
.ends

* Black-box entry subcircuit for sky130_fd_sc_hd__or2_1 abstract view
.subckt sky130_fd_sc_hd__or2_1 A B VGND VNB VPB VPWR X
.ends

* Black-box entry subcircuit for sky130_fd_sc_hd__a22oi_2 abstract view
.subckt sky130_fd_sc_hd__a22oi_2 A1 A2 B1 B2 VGND VNB VPB VPWR Y
.ends

* Black-box entry subcircuit for sky130_fd_sc_hd__nor2_2 abstract view
.subckt sky130_fd_sc_hd__nor2_2 A B VGND VNB VPB VPWR Y
.ends

* Black-box entry subcircuit for sky130_fd_sc_hd__o21ai_4 abstract view
.subckt sky130_fd_sc_hd__o21ai_4 A1 A2 B1 VGND VNB VPB VPWR Y
.ends

* Black-box entry subcircuit for sky130_fd_sc_hd__or3_4 abstract view
.subckt sky130_fd_sc_hd__or3_4 A B C VGND VNB VPB VPWR X
.ends

* Black-box entry subcircuit for sky130_fd_sc_hd__a311oi_1 abstract view
.subckt sky130_fd_sc_hd__a311oi_1 A1 A2 A3 B1 C1 VGND VNB VPB VPWR Y
.ends

* Black-box entry subcircuit for sky130_fd_sc_hd__nand3_1 abstract view
.subckt sky130_fd_sc_hd__nand3_1 A B C VGND VNB VPB VPWR Y
.ends

* Black-box entry subcircuit for sky130_fd_sc_hd__o31a_1 abstract view
.subckt sky130_fd_sc_hd__o31a_1 A1 A2 A3 B1 VGND VNB VPB VPWR X
.ends

* Black-box entry subcircuit for sky130_fd_sc_hd__o211ai_1 abstract view
.subckt sky130_fd_sc_hd__o211ai_1 A1 A2 B1 C1 VGND VNB VPB VPWR Y
.ends

* Black-box entry subcircuit for sky130_fd_sc_hd__o221ai_1 abstract view
.subckt sky130_fd_sc_hd__o221ai_1 A1 A2 B1 B2 C1 VGND VNB VPB VPWR Y
.ends

* Black-box entry subcircuit for sky130_fd_sc_hd__o221ai_2 abstract view
.subckt sky130_fd_sc_hd__o221ai_2 A1 A2 B1 B2 C1 VGND VNB VPB VPWR Y
.ends

* Black-box entry subcircuit for sky130_fd_sc_hd__mux2_2 abstract view
.subckt sky130_fd_sc_hd__mux2_2 A0 A1 S VGND VNB VPB VPWR X
.ends

* Black-box entry subcircuit for sky130_fd_sc_hd__and4b_2 abstract view
.subckt sky130_fd_sc_hd__and4b_2 A_N B C D VGND VNB VPB VPWR X
.ends

* Black-box entry subcircuit for sky130_fd_sc_hd__nand4_2 abstract view
.subckt sky130_fd_sc_hd__nand4_2 A B C D VGND VNB VPB VPWR Y
.ends

* Black-box entry subcircuit for sky130_fd_sc_hd__o2111a_1 abstract view
.subckt sky130_fd_sc_hd__o2111a_1 A1 A2 B1 C1 D1 VGND VNB VPB VPWR X
.ends

* Black-box entry subcircuit for sky130_fd_sc_hd__a22o_1 abstract view
.subckt sky130_fd_sc_hd__a22o_1 A1 A2 B1 B2 VGND VNB VPB VPWR X
.ends

* Black-box entry subcircuit for sky130_fd_sc_hd__o22ai_1 abstract view
.subckt sky130_fd_sc_hd__o22ai_1 A1 A2 B1 B2 VGND VNB VPB VPWR Y
.ends

* Black-box entry subcircuit for sky130_fd_sc_hd__or4_2 abstract view
.subckt sky130_fd_sc_hd__or4_2 A B C D VGND VNB VPB VPWR X
.ends

* Black-box entry subcircuit for sky130_fd_sc_hd__nand3b_1 abstract view
.subckt sky130_fd_sc_hd__nand3b_1 A_N B C VGND VNB VPB VPWR Y
.ends

* Black-box entry subcircuit for sky130_fd_sc_hd__a21oi_2 abstract view
.subckt sky130_fd_sc_hd__a21oi_2 A1 A2 B1 VGND VNB VPB VPWR Y
.ends

* Black-box entry subcircuit for sky130_fd_sc_hd__or4_1 abstract view
.subckt sky130_fd_sc_hd__or4_1 A B C D VGND VNB VPB VPWR X
.ends

* Black-box entry subcircuit for sky130_fd_sc_hd__and3_4 abstract view
.subckt sky130_fd_sc_hd__and3_4 A B C VGND VNB VPB VPWR X
.ends

* Black-box entry subcircuit for sky130_fd_sc_hd__o31ai_4 abstract view
.subckt sky130_fd_sc_hd__o31ai_4 A1 A2 A3 B1 VGND VNB VPB VPWR Y
.ends

* Black-box entry subcircuit for sky130_fd_sc_hd__o211ai_2 abstract view
.subckt sky130_fd_sc_hd__o211ai_2 A1 A2 B1 C1 VGND VNB VPB VPWR Y
.ends

* Black-box entry subcircuit for sky130_fd_sc_hd__o21bai_4 abstract view
.subckt sky130_fd_sc_hd__o21bai_4 A1 A2 B1_N VGND VNB VPB VPWR Y
.ends

* Black-box entry subcircuit for sky130_fd_sc_hd__clkbuf_2 abstract view
.subckt sky130_fd_sc_hd__clkbuf_2 A VGND VNB VPB VPWR X
.ends

* Black-box entry subcircuit for sky130_fd_sc_hd__or2b_2 abstract view
.subckt sky130_fd_sc_hd__or2b_2 A B_N VGND VNB VPB VPWR X
.ends

* Black-box entry subcircuit for sky130_fd_sc_hd__or3_2 abstract view
.subckt sky130_fd_sc_hd__or3_2 A B C VGND VNB VPB VPWR X
.ends

* Black-box entry subcircuit for sky130_fd_sc_hd__a21oi_4 abstract view
.subckt sky130_fd_sc_hd__a21oi_4 A1 A2 B1 VGND VNB VPB VPWR Y
.ends

* Black-box entry subcircuit for sky130_fd_sc_hd__bufinv_16 abstract view
.subckt sky130_fd_sc_hd__bufinv_16 A VGND VNB VPB VPWR Y
.ends

* Black-box entry subcircuit for sky130_fd_sc_hd__o211ai_4 abstract view
.subckt sky130_fd_sc_hd__o211ai_4 A1 A2 B1 C1 VGND VNB VPB VPWR Y
.ends

* Black-box entry subcircuit for sky130_fd_sc_hd__o2bb2a_1 abstract view
.subckt sky130_fd_sc_hd__o2bb2a_1 A1_N A2_N B1 B2 VGND VNB VPB VPWR X
.ends

* Black-box entry subcircuit for sky130_fd_sc_hd__nor2_4 abstract view
.subckt sky130_fd_sc_hd__nor2_4 A B VGND VNB VPB VPWR Y
.ends

* Black-box entry subcircuit for sky130_fd_sc_hd__nand4b_4 abstract view
.subckt sky130_fd_sc_hd__nand4b_4 A_N B C D VGND VNB VPB VPWR Y
.ends

* Black-box entry subcircuit for sky130_fd_sc_hd__a211oi_2 abstract view
.subckt sky130_fd_sc_hd__a211oi_2 A1 A2 B1 C1 VGND VNB VPB VPWR Y
.ends

* Black-box entry subcircuit for sky130_fd_sc_hd__o21bai_2 abstract view
.subckt sky130_fd_sc_hd__o21bai_2 A1 A2 B1_N VGND VNB VPB VPWR Y
.ends

* Black-box entry subcircuit for sky130_fd_sc_hd__clkinv_4 abstract view
.subckt sky130_fd_sc_hd__clkinv_4 A VGND VNB VPB VPWR Y
.ends

* Black-box entry subcircuit for sky130_fd_sc_hd__or4b_2 abstract view
.subckt sky130_fd_sc_hd__or4b_2 A B C D_N VGND VNB VPB VPWR X
.ends

* Black-box entry subcircuit for sky130_fd_sc_hd__and3b_1 abstract view
.subckt sky130_fd_sc_hd__and3b_1 A_N B C VGND VNB VPB VPWR X
.ends

* Black-box entry subcircuit for sky130_fd_sc_hd__o22a_2 abstract view
.subckt sky130_fd_sc_hd__o22a_2 A1 A2 B1 B2 VGND VNB VPB VPWR X
.ends

* Black-box entry subcircuit for sky130_fd_sc_hd__and2b_2 abstract view
.subckt sky130_fd_sc_hd__and2b_2 A_N B VGND VNB VPB VPWR X
.ends

* Black-box entry subcircuit for sky130_fd_sc_hd__a31oi_2 abstract view
.subckt sky130_fd_sc_hd__a31oi_2 A1 A2 A3 B1 VGND VNB VPB VPWR Y
.ends

* Black-box entry subcircuit for sky130_fd_sc_hd__xnor2_1 abstract view
.subckt sky130_fd_sc_hd__xnor2_1 A B VGND VNB VPB VPWR Y
.ends

* Black-box entry subcircuit for sky130_fd_sc_hd__a22oi_1 abstract view
.subckt sky130_fd_sc_hd__a22oi_1 A1 A2 B1 B2 VGND VNB VPB VPWR Y
.ends

* Black-box entry subcircuit for sky130_fd_sc_hd__clkinvlp_4 abstract view
.subckt sky130_fd_sc_hd__clkinvlp_4 A VGND VNB VPB VPWR Y
.ends

* Black-box entry subcircuit for sky130_fd_sc_hd__o31ai_2 abstract view
.subckt sky130_fd_sc_hd__o31ai_2 A1 A2 A3 B1 VGND VNB VPB VPWR Y
.ends

* Black-box entry subcircuit for sky130_fd_sc_hd__a311oi_2 abstract view
.subckt sky130_fd_sc_hd__a311oi_2 A1 A2 A3 B1 C1 VGND VNB VPB VPWR Y
.ends

* Black-box entry subcircuit for sky130_fd_sc_hd__o21ba_1 abstract view
.subckt sky130_fd_sc_hd__o21ba_1 A1 A2 B1_N VGND VNB VPB VPWR X
.ends

* Black-box entry subcircuit for sky130_fd_sc_hd__and4_1 abstract view
.subckt sky130_fd_sc_hd__and4_1 A B C D VGND VNB VPB VPWR X
.ends

* Black-box entry subcircuit for sky130_fd_sc_hd__o31ai_1 abstract view
.subckt sky130_fd_sc_hd__o31ai_1 A1 A2 A3 B1 VGND VNB VPB VPWR Y
.ends

* Black-box entry subcircuit for sky130_fd_sc_hd__nor3_2 abstract view
.subckt sky130_fd_sc_hd__nor3_2 A B C VGND VNB VPB VPWR Y
.ends

* Black-box entry subcircuit for sky130_fd_sc_hd__a41o_1 abstract view
.subckt sky130_fd_sc_hd__a41o_1 A1 A2 A3 A4 B1 VGND VNB VPB VPWR X
.ends

* Black-box entry subcircuit for sky130_fd_sc_hd__and3_2 abstract view
.subckt sky130_fd_sc_hd__and3_2 A B C VGND VNB VPB VPWR X
.ends

* Black-box entry subcircuit for sky130_fd_sc_hd__o41a_1 abstract view
.subckt sky130_fd_sc_hd__o41a_1 A1 A2 A3 A4 B1 VGND VNB VPB VPWR X
.ends

* Black-box entry subcircuit for sky130_fd_sc_hd__o2111ai_4 abstract view
.subckt sky130_fd_sc_hd__o2111ai_4 A1 A2 B1 C1 D1 VGND VNB VPB VPWR Y
.ends

* Black-box entry subcircuit for sky130_fd_sc_hd__a2111o_1 abstract view
.subckt sky130_fd_sc_hd__a2111o_1 A1 A2 B1 C1 D1 VGND VNB VPB VPWR X
.ends

* Black-box entry subcircuit for sky130_fd_sc_hd__o22ai_4 abstract view
.subckt sky130_fd_sc_hd__o22ai_4 A1 A2 B1 B2 VGND VNB VPB VPWR Y
.ends

* Black-box entry subcircuit for sky130_fd_sc_hd__a32o_1 abstract view
.subckt sky130_fd_sc_hd__a32o_1 A1 A2 A3 B1 B2 VGND VNB VPB VPWR X
.ends

* Black-box entry subcircuit for sky130_fd_sc_hd__clkbuf_16 abstract view
.subckt sky130_fd_sc_hd__clkbuf_16 A VGND VNB VPB VPWR X
.ends

* Black-box entry subcircuit for sky130_fd_sc_hd__xnor2_4 abstract view
.subckt sky130_fd_sc_hd__xnor2_4 A B VGND VNB VPB VPWR Y
.ends

* Black-box entry subcircuit for sky130_fd_sc_hd__or4b_1 abstract view
.subckt sky130_fd_sc_hd__or4b_1 A B C D_N VGND VNB VPB VPWR X
.ends

* Black-box entry subcircuit for sky130_fd_sc_hd__a31oi_4 abstract view
.subckt sky130_fd_sc_hd__a31oi_4 A1 A2 A3 B1 VGND VNB VPB VPWR Y
.ends

* Black-box entry subcircuit for sky130_fd_sc_hd__xnor2_2 abstract view
.subckt sky130_fd_sc_hd__xnor2_2 A B VGND VNB VPB VPWR Y
.ends

* Black-box entry subcircuit for sky130_fd_sc_hd__buf_1 abstract view
.subckt sky130_fd_sc_hd__buf_1 A VGND VNB VPB VPWR X
.ends

* Black-box entry subcircuit for sky130_fd_sc_hd__and4_2 abstract view
.subckt sky130_fd_sc_hd__and4_2 A B C D VGND VNB VPB VPWR X
.ends

* Black-box entry subcircuit for sky130_fd_sc_hd__nand4b_2 abstract view
.subckt sky130_fd_sc_hd__nand4b_2 A_N B C D VGND VNB VPB VPWR Y
.ends

* Black-box entry subcircuit for sky130_fd_sc_hd__nand2b_2 abstract view
.subckt sky130_fd_sc_hd__nand2b_2 A_N B VGND VNB VPB VPWR Y
.ends

* Black-box entry subcircuit for sky130_fd_sc_hd__clkbuf_8 abstract view
.subckt sky130_fd_sc_hd__clkbuf_8 A VGND VNB VPB VPWR X
.ends

* Black-box entry subcircuit for sky130_fd_sc_hd__a2111oi_1 abstract view
.subckt sky130_fd_sc_hd__a2111oi_1 A1 A2 B1 C1 D1 VGND VNB VPB VPWR Y
.ends

* Black-box entry subcircuit for sky130_fd_sc_hd__a211oi_1 abstract view
.subckt sky130_fd_sc_hd__a211oi_1 A1 A2 B1 C1 VGND VNB VPB VPWR Y
.ends

* Black-box entry subcircuit for sky130_fd_sc_hd__o41a_4 abstract view
.subckt sky130_fd_sc_hd__o41a_4 A1 A2 A3 A4 B1 VGND VNB VPB VPWR X
.ends

* Black-box entry subcircuit for sky130_fd_sc_hd__o21bai_1 abstract view
.subckt sky130_fd_sc_hd__o21bai_1 A1 A2 B1_N VGND VNB VPB VPWR Y
.ends

* Black-box entry subcircuit for sky130_fd_sc_hd__a31o_2 abstract view
.subckt sky130_fd_sc_hd__a31o_2 A1 A2 A3 B1 VGND VNB VPB VPWR X
.ends

* Black-box entry subcircuit for sky130_fd_sc_hd__a21boi_4 abstract view
.subckt sky130_fd_sc_hd__a21boi_4 A1 A2 B1_N VGND VNB VPB VPWR Y
.ends

* Black-box entry subcircuit for sky130_fd_sc_hd__a221oi_2 abstract view
.subckt sky130_fd_sc_hd__a221oi_2 A1 A2 B1 B2 C1 VGND VNB VPB VPWR Y
.ends

* Black-box entry subcircuit for sky130_fd_sc_hd__nor3b_4 abstract view
.subckt sky130_fd_sc_hd__nor3b_4 A B C_N VGND VNB VPB VPWR Y
.ends

* Black-box entry subcircuit for sky130_fd_sc_hd__o2111a_2 abstract view
.subckt sky130_fd_sc_hd__o2111a_2 A1 A2 B1 C1 D1 VGND VNB VPB VPWR X
.ends

* Black-box entry subcircuit for sky130_fd_sc_hd__or3b_2 abstract view
.subckt sky130_fd_sc_hd__or3b_2 A B C_N VGND VNB VPB VPWR X
.ends

* Black-box entry subcircuit for sky130_fd_sc_hd__nor3_1 abstract view
.subckt sky130_fd_sc_hd__nor3_1 A B C VGND VNB VPB VPWR Y
.ends

* Black-box entry subcircuit for sky130_fd_sc_hd__a22oi_4 abstract view
.subckt sky130_fd_sc_hd__a22oi_4 A1 A2 B1 B2 VGND VNB VPB VPWR Y
.ends

* Black-box entry subcircuit for sky130_fd_sc_hd__a21boi_2 abstract view
.subckt sky130_fd_sc_hd__a21boi_2 A1 A2 B1_N VGND VNB VPB VPWR Y
.ends

* Black-box entry subcircuit for sky130_fd_sc_hd__nand3b_4 abstract view
.subckt sky130_fd_sc_hd__nand3b_4 A_N B C VGND VNB VPB VPWR Y
.ends

* Black-box entry subcircuit for sky130_fd_sc_hd__and4bb_1 abstract view
.subckt sky130_fd_sc_hd__and4bb_1 A_N B_N C D VGND VNB VPB VPWR X
.ends

* Black-box entry subcircuit for sky130_fd_sc_hd__nor4_2 abstract view
.subckt sky130_fd_sc_hd__nor4_2 A B C D VGND VNB VPB VPWR Y
.ends

* Black-box entry subcircuit for sky130_fd_sc_hd__or4bb_1 abstract view
.subckt sky130_fd_sc_hd__or4bb_1 A B C_N D_N VGND VNB VPB VPWR X
.ends

* Black-box entry subcircuit for sky130_fd_sc_hd__a31oi_1 abstract view
.subckt sky130_fd_sc_hd__a31oi_1 A1 A2 A3 B1 VGND VNB VPB VPWR Y
.ends

* Black-box entry subcircuit for sky130_fd_sc_hd__a32oi_1 abstract view
.subckt sky130_fd_sc_hd__a32oi_1 A1 A2 A3 B1 B2 VGND VNB VPB VPWR Y
.ends

* Black-box entry subcircuit for sky130_fd_sc_hd__dlymetal6s2s_1 abstract view
.subckt sky130_fd_sc_hd__dlymetal6s2s_1 A VGND VNB VPB VPWR X
.ends

* Black-box entry subcircuit for sky130_fd_sc_hd__and3b_4 abstract view
.subckt sky130_fd_sc_hd__and3b_4 A_N B C VGND VNB VPB VPWR X
.ends

* Black-box entry subcircuit for sky130_fd_sc_hd__dlygate4sd3_1 abstract view
.subckt sky130_fd_sc_hd__dlygate4sd3_1 A VGND VNB VPB VPWR X
.ends

* Black-box entry subcircuit for sky130_fd_sc_hd__a2bb2oi_2 abstract view
.subckt sky130_fd_sc_hd__a2bb2oi_2 A1_N A2_N B1 B2 VGND VNB VPB VPWR Y
.ends

* Black-box entry subcircuit for sky130_fd_sc_hd__a2bb2oi_1 abstract view
.subckt sky130_fd_sc_hd__a2bb2oi_1 A1_N A2_N B1 B2 VGND VNB VPB VPWR Y
.ends

* Black-box entry subcircuit for sky130_fd_sc_hd__o2bb2ai_4 abstract view
.subckt sky130_fd_sc_hd__o2bb2ai_4 A1_N A2_N B1 B2 VGND VNB VPB VPWR Y
.ends

* Black-box entry subcircuit for sky130_fd_sc_hd__a32oi_2 abstract view
.subckt sky130_fd_sc_hd__a32oi_2 A1 A2 A3 B1 B2 VGND VNB VPB VPWR Y
.ends

* Black-box entry subcircuit for sky130_fd_sc_hd__nand4b_1 abstract view
.subckt sky130_fd_sc_hd__nand4b_1 A_N B C D VGND VNB VPB VPWR Y
.ends

* Black-box entry subcircuit for sky130_fd_sc_hd__o31a_4 abstract view
.subckt sky130_fd_sc_hd__o31a_4 A1 A2 A3 B1 VGND VNB VPB VPWR X
.ends

* Black-box entry subcircuit for sky130_fd_sc_hd__or4_4 abstract view
.subckt sky130_fd_sc_hd__or4_4 A B C D VGND VNB VPB VPWR X
.ends

* Black-box entry subcircuit for sky130_fd_sc_hd__nor3b_1 abstract view
.subckt sky130_fd_sc_hd__nor3b_1 A B C_N VGND VNB VPB VPWR Y
.ends

* Black-box entry subcircuit for sky130_fd_sc_hd__o2bb2ai_1 abstract view
.subckt sky130_fd_sc_hd__o2bb2ai_1 A1_N A2_N B1 B2 VGND VNB VPB VPWR Y
.ends

* Black-box entry subcircuit for sky130_fd_sc_hd__o21ba_4 abstract view
.subckt sky130_fd_sc_hd__o21ba_4 A1 A2 B1_N VGND VNB VPB VPWR X
.ends

* Black-box entry subcircuit for sky130_fd_sc_hd__o32ai_2 abstract view
.subckt sky130_fd_sc_hd__o32ai_2 A1 A2 A3 B1 B2 VGND VNB VPB VPWR Y
.ends

* Black-box entry subcircuit for sky130_fd_sc_hd__and4bb_4 abstract view
.subckt sky130_fd_sc_hd__and4bb_4 A_N B_N C D VGND VNB VPB VPWR X
.ends

* Black-box entry subcircuit for sky130_fd_sc_hd__or3b_1 abstract view
.subckt sky130_fd_sc_hd__or3b_1 A B C_N VGND VNB VPB VPWR X
.ends

* Black-box entry subcircuit for sky130_fd_sc_hd__o221ai_4 abstract view
.subckt sky130_fd_sc_hd__o221ai_4 A1 A2 B1 B2 C1 VGND VNB VPB VPWR Y
.ends

* Black-box entry subcircuit for sky130_fd_sc_hd__nor2b_2 abstract view
.subckt sky130_fd_sc_hd__nor2b_2 A B_N VGND VNB VPB VPWR Y
.ends

* Black-box entry subcircuit for sky130_fd_sc_hd__or2_2 abstract view
.subckt sky130_fd_sc_hd__or2_2 A B VGND VNB VPB VPWR X
.ends

* Black-box entry subcircuit for sky130_fd_sc_hd__mux2_4 abstract view
.subckt sky130_fd_sc_hd__mux2_4 A0 A1 S VGND VNB VPB VPWR X
.ends

* Black-box entry subcircuit for sky130_fd_sc_hd__o221a_2 abstract view
.subckt sky130_fd_sc_hd__o221a_2 A1 A2 B1 B2 C1 VGND VNB VPB VPWR X
.ends

* Black-box entry subcircuit for sky130_fd_sc_hd__and4bb_2 abstract view
.subckt sky130_fd_sc_hd__and4bb_2 A_N B_N C D VGND VNB VPB VPWR X
.ends

* Black-box entry subcircuit for sky130_fd_sc_hd__or2_4 abstract view
.subckt sky130_fd_sc_hd__or2_4 A B VGND VNB VPB VPWR X
.ends

* Black-box entry subcircuit for sky130_fd_sc_hd__nand2b_4 abstract view
.subckt sky130_fd_sc_hd__nand2b_4 A_N B VGND VNB VPB VPWR Y
.ends

* Black-box entry subcircuit for sky130_fd_sc_hd__o311ai_1 abstract view
.subckt sky130_fd_sc_hd__o311ai_1 A1 A2 A3 B1 C1 VGND VNB VPB VPWR Y
.ends

* Black-box entry subcircuit for sky130_fd_sc_hd__a311o_4 abstract view
.subckt sky130_fd_sc_hd__a311o_4 A1 A2 A3 B1 C1 VGND VNB VPB VPWR X
.ends

.subckt alu32 A[0] A[10] A[11] A[12] A[13] A[14] A[15] A[16] A[17] A[18] A[19] A[1]
+ A[20] A[21] A[22] A[23] A[24] A[25] A[26] A[27] A[28] A[29] A[2] A[30] A[31] A[3]
+ A[4] A[5] A[6] A[7] A[8] A[9] B[0] B[10] B[11] B[12] B[13] B[14] B[15] B[16] B[17]
+ B[18] B[19] B[1] B[20] B[21] B[22] B[23] B[24] B[25] B[26] B[27] B[28] B[29] B[2]
+ B[30] B[31] B[3] B[4] B[5] B[6] B[7] B[8] B[9] VGND VPWR carry clk negative opcode[0]
+ opcode[1] opcode[2] opcode[3] opcode[4] overflow result[0] result[10] result[11]
+ result[12] result[13] result[14] result[15] result[16] result[17] result[18] result[19]
+ result[1] result[20] result[21] result[22] result[23] result[24] result[25] result[26]
+ result[27] result[28] result[29] result[2] result[30] result[31] result[3] result[4]
+ result[5] result[6] result[7] result[8] result[9] rst_n valid_in valid_out zero
X_3086_ _1313_ _1421_ net54 VGND VGND VPWR VPWR _0130_ sky130_fd_sc_hd__a21oi_1
X_3155_ _1354_ _1665_ _1490_ _0197_ _0001_ VGND VGND VPWR VPWR _0198_ sky130_fd_sc_hd__o32a_1
X_2106_ net43 net11 VGND VGND VPWR VPWR _0514_ sky130_fd_sc_hd__or2b_1
XTAP_TAPCELL_ROW_37_434 VGND VPWR sky130_fd_sc_hd__tapvpwrvgnd_1
X_2939_ net51 _1946_ _2041_ VGND VGND VPWR VPWR _2042_ sky130_fd_sc_hd__a21o_1
XFILLER_0_49_358 VGND VGND VPWR VPWR sky130_fd_sc_hd__decap_4
X_3988_ _2004_ _0402_ _1979_ _2053_ _1074_ VGND VGND VPWR VPWR _1075_ sky130_fd_sc_hd__a221o_1
XTAP_TAPCELL_ROW_20_312 VGND VPWR sky130_fd_sc_hd__tapvpwrvgnd_1
XFILLER_0_72_394 VPWR VGND VPWR VGND sky130_ef_sc_hd__decap_12
XFILLER_0_7_70 VGND VGND VPWR VPWR sky130_fd_sc_hd__fill_1
XFILLER_0_67_133 VGND VGND VPWR VPWR sky130_fd_sc_hd__decap_3
XFILLER_0_23_225 VGND VGND VPWR VPWR sky130_fd_sc_hd__decap_4
XFILLER_0_73_169 VGND VGND VPWR VPWR sky130_fd_sc_hd__fill_2
XFILLER_0_73_125 VGND VGND VPWR VPWR sky130_fd_sc_hd__decap_8
XTAP_TAPCELL_ROW_42_470 VGND VPWR sky130_fd_sc_hd__tapvpwrvgnd_1
X_3842_ _0731_ _0588_ _0591_ _0865_ _0918_ VGND VGND VPWR VPWR _0919_ sky130_fd_sc_hd__o221a_1
XTAP_TAPCELL_ROW_34_415 VGND VPWR sky130_fd_sc_hd__tapvpwrvgnd_1
X_3911_ _0106_ _1611_ _0987_ _0989_ _0992_ VGND VGND VPWR VPWR _0993_ sky130_fd_sc_hd__o311a_1
X_2724_ _1681_ _1323_ _1826_ _1827_ _1828_ VGND VGND VPWR VPWR _1829_ sky130_fd_sc_hd__o2111ai_1
X_3773_ _1746_ _1768_ _0843_ _0844_ _1823_ VGND VGND VPWR VPWR _0845_ sky130_fd_sc_hd__a311o_1
X_2655_ _1286_ _1264_ _1760_ VGND VGND VPWR VPWR _1761_ sky130_fd_sc_hd__o21ai_1
XFILLER_0_14_247 VGND VGND VPWR VPWR sky130_fd_sc_hd__decap_4
X_2586_ _1608_ VGND VGND VPWR VPWR _1692_ sky130_fd_sc_hd__clkbuf_4
X_3207_ _0032_ _0248_ VGND VGND VPWR VPWR _0249_ sky130_fd_sc_hd__nand2_1
X_4187_ clknet_2_1__leaf_clk _2083_ net121 VGND VGND VPWR VPWR net100 sky130_fd_sc_hd__dfrtp_1
X_3138_ _0740_ _0762_ _0772_ _0794_ VGND VGND VPWR VPWR _0182_ sky130_fd_sc_hd__nor4_1
X_3069_ _1315_ net22 _1968_ net24 _1632_ _1562_ VGND VGND VPWR VPWR _0114_ sky130_fd_sc_hd__mux4_1
XFILLER_0_64_147 VPWR VGND VPWR VGND sky130_ef_sc_hd__decap_12
XFILLER_0_9_296 VGND VGND VPWR VPWR sky130_fd_sc_hd__decap_6
XTAP_TAPCELL_ROW_48_518 VGND VPWR sky130_fd_sc_hd__tapvpwrvgnd_1
XFILLER_0_34_17 VGND VGND VPWR VPWR sky130_fd_sc_hd__decap_8
XTAP_TAPCELL_ROW_5_195 VGND VPWR sky130_fd_sc_hd__tapvpwrvgnd_1
X_2440_ _1508_ _1536_ _1496_ VGND VGND VPWR VPWR _1546_ sky130_fd_sc_hd__o21ai_1
XFILLER_0_36_383 VGND VGND VPWR VPWR sky130_fd_sc_hd__decap_6
X_4110_ _1202_ _1203_ _1204_ _1205_ VGND VGND VPWR VPWR _1206_ sky130_fd_sc_hd__o22a_1
X_4041_ _1120_ _1122_ _1128_ _1131_ VGND VGND VPWR VPWR _1132_ sky130_fd_sc_hd__nand4_1
X_2371_ net114 _1470_ _1473_ _1476_ VGND VGND VPWR VPWR _1477_ sky130_fd_sc_hd__nand4_4
XPHY_EDGE_ROW_20_Left_94 VGND VGND VPWR VPWR sky130_fd_sc_hd__decap_3
XFILLER_0_46_125 VGND VGND VPWR VPWR sky130_fd_sc_hd__decap_6
XFILLER_0_34_309 VPWR VGND VPWR VGND sky130_ef_sc_hd__decap_12
XFILLER_0_27_383 VGND VGND VPWR VPWR sky130_fd_sc_hd__decap_8
X_3756_ _1469_ _0825_ _0827_ VGND VGND VPWR VPWR _0828_ sky130_fd_sc_hd__o21ai_2
XFILLER_0_6_233 VGND VGND VPWR VPWR sky130_fd_sc_hd__fill_1
XFILLER_0_6_244 VGND VGND VPWR VPWR sky130_fd_sc_hd__decap_8
X_3825_ _1221_ _1178_ _0806_ VGND VGND VPWR VPWR _0902_ sky130_fd_sc_hd__or3_1
XFILLER_0_71_3 VPWR VGND VPWR VGND sky130_ef_sc_hd__decap_12
X_2707_ _1806_ _1807_ _1811_ VGND VGND VPWR VPWR _1812_ sky130_fd_sc_hd__a21oi_1
X_2569_ _1612_ _1670_ VGND VGND VPWR VPWR _1675_ sky130_fd_sc_hd__nand2_1
XFILLER_0_42_342 VGND VGND VPWR VPWR sky130_fd_sc_hd__decap_8
X_2638_ _1743_ _1410_ VGND VGND VPWR VPWR _1744_ sky130_fd_sc_hd__nand2_1
X_3687_ _1397_ _0245_ VGND VGND VPWR VPWR _0754_ sky130_fd_sc_hd__nand2_1
XTAP_TAPCELL_ROW_53_554 VGND VPWR sky130_fd_sc_hd__tapvpwrvgnd_1
XTAP_TAPCELL_ROW_2_176 VGND VPWR sky130_fd_sc_hd__tapvpwrvgnd_1
XFILLER_0_33_364 VPWR VGND VPWR VGND sky130_ef_sc_hd__decap_12
XFILLER_0_29_39 VGND VGND VPWR VPWR sky130_fd_sc_hd__decap_3
XFILLER_0_0_29 VGND VGND VPWR VPWR sky130_fd_sc_hd__decap_8
XFILLER_0_28_158 VGND VGND VPWR VPWR sky130_fd_sc_hd__fill_1
X_3610_ _0213_ _0662_ _0663_ _0664_ net111 VGND VGND VPWR VPWR _0671_ sky130_fd_sc_hd__o221a_1
XTAP_TAPCELL_ROW_16_278 VGND VPWR sky130_fd_sc_hd__tapvpwrvgnd_1
XFILLER_0_16_309 VGND VGND VPWR VPWR sky130_fd_sc_hd__decap_8
X_3541_ _0142_ VGND VGND VPWR VPWR _0596_ sky130_fd_sc_hd__buf_2
XFILLER_0_24_331 VGND VGND VPWR VPWR sky130_fd_sc_hd__fill_1
XFILLER_0_3_258 VGND VGND VPWR VPWR sky130_fd_sc_hd__fill_2
XFILLER_0_3_225 VGND VGND VPWR VPWR sky130_fd_sc_hd__decap_6
XFILLER_0_10_85 VGND VGND VPWR VPWR sky130_fd_sc_hd__decap_3
X_2423_ _1528_ _1406_ VGND VGND VPWR VPWR _1529_ sky130_fd_sc_hd__nand2_4
X_3472_ _0517_ _0518_ _0519_ _0521_ VGND VGND VPWR VPWR _0522_ sky130_fd_sc_hd__and4b_1
X_4024_ _1497_ _1327_ _1112_ VGND VGND VPWR VPWR _1113_ sky130_fd_sc_hd__o21ai_1
X_2354_ _1308_ _1302_ VGND VGND VPWR VPWR _1460_ sky130_fd_sc_hd__nor2_1
X_2285_ net35 _1200_ VGND VGND VPWR VPWR _1391_ sky130_fd_sc_hd__and2_2
XTAP_TAPCELL_ROW_50_535 VGND VPWR sky130_fd_sc_hd__tapvpwrvgnd_1
XFILLER_0_42_172 VGND VGND VPWR VPWR sky130_fd_sc_hd__fill_1
X_3739_ _1799_ _1801_ _0807_ _1769_ _0808_ VGND VGND VPWR VPWR _0809_ sky130_fd_sc_hd__o221a_1
X_3808_ _1772_ _2009_ _2010_ _0882_ VGND VGND VPWR VPWR _0883_ sky130_fd_sc_hd__a31o_1
XFILLER_0_15_397 VGND VGND VPWR VPWR sky130_fd_sc_hd__fill_1
XFILLER_0_30_356 VGND VGND VPWR VPWR sky130_fd_sc_hd__decap_8
XTAP_TAPCELL_ROW_7_213 VGND VPWR sky130_fd_sc_hd__tapvpwrvgnd_1
Xwire111 net112 VGND VGND VPWR VPWR net111 sky130_fd_sc_hd__clkbuf_1
XTAP_TAPCELL_ROW_13_259 VGND VPWR sky130_fd_sc_hd__tapvpwrvgnd_1
XFILLER_0_21_389 VGND VGND VPWR VPWR sky130_fd_sc_hd__decap_3
XFILLER_0_56_59 VGND VGND VPWR VPWR sky130_fd_sc_hd__fill_1
XFILLER_0_56_15 VGND VGND VPWR VPWR sky130_fd_sc_hd__decap_6
XTAP_TAPCELL_ROW_64_638 VGND VPWR sky130_fd_sc_hd__tapvpwrvgnd_1
XFILLER_0_48_209 VGND VGND VPWR VPWR sky130_fd_sc_hd__fill_1
X_2972_ _1648_ _1649_ _1721_ _0017_ _1910_ VGND VGND VPWR VPWR _0018_ sky130_fd_sc_hd__a221o_1
XFILLER_0_8_306 VGND VGND VPWR VPWR sky130_fd_sc_hd__fill_2
XFILLER_0_56_253 VGND VGND VPWR VPWR sky130_fd_sc_hd__decap_3
XFILLER_0_24_172 VGND VGND VPWR VPWR sky130_fd_sc_hd__decap_4
XFILLER_0_21_40 VGND VGND VPWR VPWR sky130_fd_sc_hd__decap_8
X_3524_ _1876_ _0114_ VGND VGND VPWR VPWR _0578_ sky130_fd_sc_hd__and2_1
X_3386_ _1941_ VGND VGND VPWR VPWR _0429_ sky130_fd_sc_hd__buf_2
X_3455_ _1955_ _0500_ _0502_ VGND VGND VPWR VPWR _0504_ sky130_fd_sc_hd__a21o_1
X_2406_ net55 _1463_ VGND VGND VPWR VPWR _1512_ sky130_fd_sc_hd__nand2_1
XFILLER_0_12_389 VPWR VGND VPWR VGND sky130_ef_sc_hd__decap_12
X_2337_ _1417_ _1429_ _1428_ _1419_ VGND VGND VPWR VPWR _1443_ sky130_fd_sc_hd__a2bb2oi_4
X_4007_ _1787_ _1094_ _1090_ _2038_ _1095_ VGND VGND VPWR VPWR _1096_ sky130_fd_sc_hd__a311o_1
X_2268_ net58 VGND VGND VPWR VPWR _1374_ sky130_fd_sc_hd__inv_2
X_2199_ net33 VGND VGND VPWR VPWR _1305_ sky130_fd_sc_hd__clkbuf_4
XPHY_EDGE_ROW_33_Left_107 VGND VGND VPWR VPWR sky130_fd_sc_hd__decap_3
XFILLER_0_30_153 VGND VGND VPWR VPWR sky130_fd_sc_hd__decap_6
XFILLER_0_30_131 VGND VGND VPWR VPWR sky130_fd_sc_hd__decap_4
XFILLER_0_7_361 VGND VGND VPWR VPWR sky130_fd_sc_hd__fill_2
XPHY_EDGE_ROW_42_Left_116 VGND VGND VPWR VPWR sky130_fd_sc_hd__decap_3
XFILLER_0_30_197 VGND VGND VPWR VPWR sky130_fd_sc_hd__decap_3
XTAP_TAPCELL_ROW_61_619 VGND VPWR sky130_fd_sc_hd__tapvpwrvgnd_1
XPHY_EDGE_ROW_51_Left_125 VGND VGND VPWR VPWR sky130_fd_sc_hd__decap_3
XTAP_TAPCELL_ROW_26_351 VGND VPWR sky130_fd_sc_hd__tapvpwrvgnd_1
XFILLER_0_53_223 VGND VGND VPWR VPWR sky130_fd_sc_hd__fill_1
XFILLER_0_38_297 VGND VGND VPWR VPWR sky130_fd_sc_hd__fill_1
XFILLER_0_38_275 VGND VGND VPWR VPWR sky130_fd_sc_hd__decap_3
XFILLER_0_38_253 VGND VGND VPWR VPWR sky130_fd_sc_hd__decap_3
X_3240_ _1318_ _0281_ _0686_ VGND VGND VPWR VPWR _0282_ sky130_fd_sc_hd__o21ai_1
XFILLER_0_67_69 VGND VGND VPWR VPWR sky130_fd_sc_hd__decap_3
XPHY_EDGE_ROW_60_Left_134 VGND VGND VPWR VPWR sky130_fd_sc_hd__decap_3
XANTENNA_5 _0194_ VGND VGND VPWR VPWR sky130_fd_sc_hd__diode_2
XFILLER_0_21_142 VGND VGND VPWR VPWR sky130_fd_sc_hd__decap_6
X_2122_ _0676_ net24 VGND VGND VPWR VPWR _0686_ sky130_fd_sc_hd__nand2_2
X_3171_ _1724_ _1730_ _1876_ _1992_ VGND VGND VPWR VPWR _0214_ sky130_fd_sc_hd__o211a_1
X_2955_ _1884_ VGND VGND VPWR VPWR _0001_ sky130_fd_sc_hd__clkbuf_4
XFILLER_0_8_114 VGND VGND VPWR VPWR sky130_fd_sc_hd__decap_4
XFILLER_0_16_73 VGND VGND VPWR VPWR sky130_fd_sc_hd__decap_8
XFILLER_0_44_245 VGND VGND VPWR VPWR sky130_fd_sc_hd__decap_6
X_2886_ _1890_ _1874_ _1583_ _1560_ _1989_ VGND VGND VPWR VPWR _1990_ sky130_fd_sc_hd__o311a_1
XTAP_TAPCELL_ROW_32_398 VGND VPWR sky130_fd_sc_hd__tapvpwrvgnd_1
X_3507_ _1556_ _0337_ VGND VGND VPWR VPWR _0560_ sky130_fd_sc_hd__nor2_1
X_3438_ _0433_ _0426_ _2030_ _0484_ VGND VGND VPWR VPWR _0485_ sky130_fd_sc_hd__a211o_1
X_3369_ _1304_ _0004_ _0409_ _0410_ VGND VGND VPWR VPWR _0411_ sky130_fd_sc_hd__a211o_1
XFILLER_0_12_197 VGND VGND VPWR VPWR sky130_fd_sc_hd__decap_3
XFILLER_0_67_337 VPWR VGND VPWR VGND sky130_ef_sc_hd__decap_12
XTAP_TAPCELL_ROW_23_332 VGND VPWR sky130_fd_sc_hd__tapvpwrvgnd_1
XFILLER_0_50_259 VGND VGND VPWR VPWR sky130_fd_sc_hd__fill_1
Xoutput75 net75 VGND VGND VPWR VPWR result[0] sky130_fd_sc_hd__buf_2
XFILLER_0_53_27 VPWR VGND VPWR VGND sky130_ef_sc_hd__decap_12
Xoutput97 net97 VGND VGND VPWR VPWR result[2] sky130_fd_sc_hd__buf_2
Xoutput86 net86 VGND VGND VPWR VPWR result[1] sky130_fd_sc_hd__buf_2
XFILLER_0_66_370 VGND VGND VPWR VPWR sky130_fd_sc_hd__decap_3
XFILLER_0_58_315 VGND VGND VPWR VPWR sky130_fd_sc_hd__fill_2
XFILLER_0_58_304 VGND VGND VPWR VPWR sky130_fd_sc_hd__decap_4
X_2740_ _1591_ _1841_ _1844_ VGND VGND VPWR VPWR _1845_ sky130_fd_sc_hd__o21a_1
XFILLER_0_26_267 VPWR VGND VPWR VGND sky130_ef_sc_hd__decap_12
X_2671_ _1745_ _1771_ _1776_ VGND VGND VPWR VPWR _1777_ sky130_fd_sc_hd__o21ai_1
X_3223_ _0242_ _0250_ _0253_ _0255_ _0264_ VGND VGND VPWR VPWR _0265_ sky130_fd_sc_hd__a221oi_1
X_3085_ _0118_ _0120_ _0122_ _0129_ VGND VGND VPWR VPWR _2078_ sky130_fd_sc_hd__nand4_1
X_3154_ _0676_ _0087_ VGND VGND VPWR VPWR _0197_ sky130_fd_sc_hd__nor2_1
XFILLER_0_49_326 VGND VGND VPWR VPWR sky130_fd_sc_hd__fill_1
X_2105_ net11 net43 VGND VGND VPWR VPWR _0503_ sky130_fd_sc_hd__nand2b_1
XTAP_TAPCELL_ROW_37_435 VGND VPWR sky130_fd_sc_hd__tapvpwrvgnd_1
X_2938_ _0890_ _0901_ VGND VGND VPWR VPWR _2041_ sky130_fd_sc_hd__and2b_1
XFILLER_0_64_329 VGND VGND VPWR VPWR sky130_fd_sc_hd__fill_2
XFILLER_0_57_381 VGND VGND VPWR VPWR sky130_fd_sc_hd__decap_8
XFILLER_0_32_215 VPWR VGND VPWR VGND sky130_ef_sc_hd__decap_12
X_3987_ _1964_ _1559_ _1962_ VGND VGND VPWR VPWR _1074_ sky130_fd_sc_hd__and3_1
XFILLER_0_17_223 VGND VGND VPWR VPWR sky130_fd_sc_hd__fill_1
XFILLER_0_17_245 VGND VGND VPWR VPWR sky130_fd_sc_hd__decap_4
X_2869_ _1972_ _1598_ _1583_ VGND VGND VPWR VPWR _1973_ sky130_fd_sc_hd__o21ai_1
XFILLER_0_40_270 VGND VGND VPWR VPWR sky130_fd_sc_hd__fill_2
XFILLER_0_4_183 VPWR VGND VPWR VGND sky130_ef_sc_hd__decap_12
XFILLER_0_55_318 VGND VGND VPWR VPWR sky130_fd_sc_hd__decap_8
XFILLER_0_63_373 VPWR VGND VPWR VGND sky130_ef_sc_hd__decap_12
XFILLER_0_23_215 VGND VGND VPWR VPWR sky130_fd_sc_hd__decap_3
XFILLER_0_48_27 VGND VGND VPWR VPWR sky130_fd_sc_hd__fill_1
XFILLER_0_31_281 VGND VGND VPWR VPWR sky130_fd_sc_hd__decap_4
XTAP_TAPCELL_ROW_34_416 VGND VPWR sky130_fd_sc_hd__tapvpwrvgnd_1
XTAP_TAPCELL_ROW_42_471 VGND VPWR sky130_fd_sc_hd__tapvpwrvgnd_1
X_2723_ _1664_ _1553_ _1539_ _1801_ VGND VGND VPWR VPWR _1828_ sky130_fd_sc_hd__a31o_4
XFILLER_0_39_381 VGND VGND VPWR VPWR sky130_fd_sc_hd__fill_1
X_3841_ _1879_ _1721_ _2002_ _1704_ VGND VGND VPWR VPWR _0918_ sky130_fd_sc_hd__nand4_1
X_3910_ _1403_ _1930_ _1672_ _1018_ _0991_ VGND VGND VPWR VPWR _0992_ sky130_fd_sc_hd__o221a_1
X_3772_ _1768_ _0843_ _1746_ VGND VGND VPWR VPWR _0844_ sky130_fd_sc_hd__a21oi_1
XFILLER_0_6_415 VGND VGND VPWR VPWR sky130_fd_sc_hd__decap_4
XFILLER_0_13_30 VGND VGND VPWR VPWR sky130_fd_sc_hd__decap_8
X_2585_ _1558_ _1590_ _1640_ _1690_ VGND VGND VPWR VPWR _1691_ sky130_fd_sc_hd__o211a_1
X_2654_ net60 _1253_ VGND VGND VPWR VPWR _1760_ sky130_fd_sc_hd__nand2_1
XFILLER_0_10_421 VPWR VGND VPWR VGND sky130_ef_sc_hd__decap_12
XFILLER_0_14_259 VGND VGND VPWR VPWR sky130_fd_sc_hd__fill_1
X_3137_ _0154_ _0178_ _1543_ _1821_ VGND VGND VPWR VPWR _0181_ sky130_fd_sc_hd__o22a_1
XFILLER_0_38_93 VGND VGND VPWR VPWR sky130_fd_sc_hd__fill_2
XFILLER_0_38_60 VPWR VGND VPWR VGND sky130_ef_sc_hd__decap_12
X_4186_ clknet_2_1__leaf_clk _2080_ net121 VGND VGND VPWR VPWR net97 sky130_fd_sc_hd__dfrtp_1
X_3206_ _1833_ _1843_ _1837_ _1835_ _1972_ _0022_ VGND VGND VPWR VPWR _0248_ sky130_fd_sc_hd__mux4_2
XFILLER_0_54_81 VGND VGND VPWR VPWR sky130_fd_sc_hd__decap_3
X_3068_ _1592_ _0110_ _0112_ VGND VGND VPWR VPWR _0113_ sky130_fd_sc_hd__a21bo_1
XFILLER_0_49_178 VGND VGND VPWR VPWR sky130_fd_sc_hd__decap_4
XFILLER_0_60_365 VGND VGND VPWR VPWR sky130_fd_sc_hd__decap_6
XFILLER_0_60_321 VPWR VGND VPWR VGND sky130_ef_sc_hd__decap_12
XFILLER_0_68_421 VPWR VGND VPWR VGND sky130_ef_sc_hd__decap_12
XTAP_TAPCELL_ROW_48_519 VGND VPWR sky130_fd_sc_hd__tapvpwrvgnd_1
XFILLER_0_34_29 VPWR VGND VPWR VGND sky130_ef_sc_hd__decap_12
XTAP_TAPCELL_ROW_5_196 VGND VPWR sky130_fd_sc_hd__tapvpwrvgnd_1
XFILLER_0_28_307 VGND VGND VPWR VPWR sky130_fd_sc_hd__fill_1
XFILLER_0_63_181 VPWR VGND VPWR VGND sky130_ef_sc_hd__decap_12
XFILLER_0_59_48 VGND VGND VPWR VPWR sky130_fd_sc_hd__decap_8
XFILLER_0_51_376 VGND VGND VPWR VPWR sky130_fd_sc_hd__decap_3
X_4040_ _0865_ _0016_ _1914_ _1129_ _1130_ VGND VGND VPWR VPWR _1131_ sky130_fd_sc_hd__o2111ai_2
X_2370_ _1474_ _1475_ VGND VGND VPWR VPWR _1476_ sky130_fd_sc_hd__nor2_1
XFILLER_0_46_104 VPWR VGND VPWR VGND sky130_ef_sc_hd__decap_12
XFILLER_0_24_51 VGND VGND VPWR VPWR sky130_fd_sc_hd__decap_6
XTAP_TAPCELL_ROW_19_298 VGND VPWR sky130_fd_sc_hd__tapvpwrvgnd_1
X_2706_ _1806_ _1807_ _1810_ VGND VGND VPWR VPWR _1811_ sky130_fd_sc_hd__o21ai_1
XFILLER_0_46_137 VGND VGND VPWR VPWR sky130_fd_sc_hd__decap_3
XFILLER_0_42_354 VGND VGND VPWR VPWR sky130_fd_sc_hd__fill_1
X_3755_ _1469_ _0825_ _1492_ VGND VGND VPWR VPWR _0827_ sky130_fd_sc_hd__a21oi_1
X_3824_ _1071_ _0898_ net113 _1545_ _0899_ VGND VGND VPWR VPWR _0900_ sky130_fd_sc_hd__o311ai_2
X_3686_ _0256_ _1923_ _1397_ VGND VGND VPWR VPWR _0753_ sky130_fd_sc_hd__o21a_1
XFILLER_0_64_3 VGND VGND VPWR VPWR sky130_fd_sc_hd__decap_8
X_2499_ _1595_ _1598_ _1601_ _1603_ _1582_ _1604_ VGND VGND VPWR VPWR _1605_ sky130_fd_sc_hd__mux4_2
X_2568_ _1673_ VGND VGND VPWR VPWR _1674_ sky130_fd_sc_hd__buf_4
X_2637_ _1530_ net4 VGND VGND VPWR VPWR _1743_ sky130_fd_sc_hd__nand2_1
XPHY_EDGE_ROW_12_Right_12 VGND VGND VPWR VPWR sky130_fd_sc_hd__decap_3
X_4169_ _0449_ _1679_ _1268_ VGND VGND VPWR VPWR _1269_ sky130_fd_sc_hd__a21oi_1
XPHY_EDGE_ROW_21_Right_21 VGND VGND VPWR VPWR sky130_fd_sc_hd__decap_3
XTAP_TAPCELL_ROW_2_177 VGND VPWR sky130_fd_sc_hd__tapvpwrvgnd_1
XTAP_TAPCELL_ROW_53_555 VGND VPWR sky130_fd_sc_hd__tapvpwrvgnd_1
XFILLER_0_37_159 VGND VGND VPWR VPWR sky130_fd_sc_hd__fill_1
XFILLER_0_18_340 VGND VGND VPWR VPWR sky130_fd_sc_hd__decap_8
XFILLER_0_52_118 VPWR VGND VPWR VGND sky130_ef_sc_hd__decap_12
XFILLER_0_33_387 VGND VGND VPWR VPWR sky130_fd_sc_hd__decap_4
XFILLER_0_33_376 VGND VGND VPWR VPWR sky130_fd_sc_hd__decap_3
XPHY_EDGE_ROW_30_Right_30 VGND VGND VPWR VPWR sky130_fd_sc_hd__decap_3
XFILLER_0_68_262 VPWR VGND VPWR VGND sky130_ef_sc_hd__decap_12
XFILLER_0_68_251 VGND VGND VPWR VPWR sky130_fd_sc_hd__fill_1
XFILLER_0_68_240 VGND VGND VPWR VPWR sky130_fd_sc_hd__fill_1
XFILLER_0_71_405 VPWR VGND VPWR VGND sky130_ef_sc_hd__decap_12
X_3540_ _0083_ _0590_ _0593_ _0594_ VGND VGND VPWR VPWR _0595_ sky130_fd_sc_hd__o211a_1
XTAP_TAPCELL_ROW_16_279 VGND VPWR sky130_fd_sc_hd__tapvpwrvgnd_1
XFILLER_0_51_162 VGND VGND VPWR VPWR sky130_fd_sc_hd__decap_6
X_2353_ net26 VGND VGND VPWR VPWR _1459_ sky130_fd_sc_hd__buf_2
XFILLER_0_10_42 VGND VGND VPWR VPWR sky130_fd_sc_hd__fill_2
X_2422_ net38 net6 VGND VGND VPWR VPWR _1528_ sky130_fd_sc_hd__or2b_1
X_3471_ _1297_ _1926_ _1923_ _1591_ _0520_ VGND VGND VPWR VPWR _0521_ sky130_fd_sc_hd__a221oi_1
XTAP_TAPCELL_ROW_67_658 VGND VPWR sky130_fd_sc_hd__tapvpwrvgnd_1
X_4023_ _1089_ _1090_ _0546_ VGND VGND VPWR VPWR _1112_ sky130_fd_sc_hd__a21boi_1
X_2284_ net2 net34 VGND VGND VPWR VPWR _1390_ sky130_fd_sc_hd__or2b_1
XFILLER_0_62_405 VPWR VGND VPWR VGND sky130_ef_sc_hd__decap_12
XFILLER_0_51_71 VGND VGND VPWR VPWR sky130_fd_sc_hd__fill_1
XTAP_TAPCELL_ROW_50_536 VGND VPWR sky130_fd_sc_hd__tapvpwrvgnd_1
XFILLER_0_47_402 VGND VGND VPWR VPWR sky130_fd_sc_hd__decap_8
X_3669_ _0732_ _0733_ _0311_ VGND VGND VPWR VPWR _0734_ sky130_fd_sc_hd__a21o_1
X_3738_ _1769_ _0807_ VGND VGND VPWR VPWR _0808_ sky130_fd_sc_hd__nand2_1
X_3807_ _1772_ _1682_ _1744_ _0349_ VGND VGND VPWR VPWR _0882_ sky130_fd_sc_hd__a2bb2o_1
XTAP_TAPCELL_ROW_7_214 VGND VPWR sky130_fd_sc_hd__tapvpwrvgnd_1
Xwire112 _0670_ VGND VGND VPWR VPWR net112 sky130_fd_sc_hd__clkbuf_1
XFILLER_0_18_181 VGND VGND VPWR VPWR sky130_fd_sc_hd__decap_4
XFILLER_0_72_15 VPWR VGND VPWR VGND sky130_ef_sc_hd__decap_12
XTAP_TAPCELL_ROW_64_639 VGND VPWR sky130_fd_sc_hd__tapvpwrvgnd_1
XFILLER_0_56_210 VPWR VGND VPWR VGND sky130_ef_sc_hd__decap_12
X_2971_ _1302_ _1463_ net26 _1308_ _1566_ _1580_ VGND VGND VPWR VPWR _0017_ sky130_fd_sc_hd__mux4_2
XFILLER_0_8_318 VPWR VGND VPWR VGND sky130_ef_sc_hd__decap_12
XFILLER_0_71_257 VGND VGND VPWR VPWR sky130_fd_sc_hd__fill_1
X_3523_ _0575_ _0576_ _1876_ VGND VGND VPWR VPWR _0577_ sky130_fd_sc_hd__mux2_1
XFILLER_0_21_85 VGND VGND VPWR VPWR sky130_fd_sc_hd__fill_1
XFILLER_0_12_302 VGND VGND VPWR VPWR sky130_fd_sc_hd__decap_6
XFILLER_0_12_335 VGND VGND VPWR VPWR sky130_fd_sc_hd__fill_2
X_2336_ _1424_ _1441_ VGND VGND VPWR VPWR _1442_ sky130_fd_sc_hd__nor2_1
X_3385_ _1940_ VGND VGND VPWR VPWR _0428_ sky130_fd_sc_hd__buf_2
X_3454_ _1967_ _0501_ _0142_ VGND VGND VPWR VPWR _0502_ sky130_fd_sc_hd__a21o_1
X_2405_ _1510_ _1463_ VGND VGND VPWR VPWR _1511_ sky130_fd_sc_hd__or2_1
XFILLER_0_46_71 VGND VGND VPWR VPWR sky130_fd_sc_hd__fill_1
X_4006_ _0535_ _0546_ _1094_ _1787_ VGND VGND VPWR VPWR _1095_ sky130_fd_sc_hd__a22oi_2
XFILLER_0_27_3 VGND VGND VPWR VPWR sky130_fd_sc_hd__decap_6
X_2198_ net44 net12 VGND VGND VPWR VPWR _1304_ sky130_fd_sc_hd__nor2_2
XFILLER_0_1_51 VGND VGND VPWR VPWR sky130_fd_sc_hd__decap_4
X_2267_ _1295_ _1297_ _1372_ VGND VGND VPWR VPWR _1373_ sky130_fd_sc_hd__o21ai_2
XFILLER_0_50_408 VPWR VGND VPWR VGND sky130_ef_sc_hd__decap_12
XFILLER_0_15_140 VGND VGND VPWR VPWR sky130_fd_sc_hd__fill_1
XFILLER_0_15_162 VGND VGND VPWR VPWR sky130_fd_sc_hd__decap_6
XFILLER_0_42_29 VGND VGND VPWR VPWR sky130_fd_sc_hd__decap_6
XFILLER_0_38_221 VGND VGND VPWR VPWR sky130_fd_sc_hd__fill_1
XTAP_TAPCELL_ROW_26_352 VGND VPWR sky130_fd_sc_hd__tapvpwrvgnd_1
XANTENNA_6 _0251_ VGND VGND VPWR VPWR sky130_fd_sc_hd__diode_2
XFILLER_0_21_121 VGND VGND VPWR VPWR sky130_fd_sc_hd__fill_2
XFILLER_0_67_37 VGND VGND VPWR VPWR sky130_fd_sc_hd__fill_1
XFILLER_0_67_26 VGND VGND VPWR VPWR sky130_fd_sc_hd__fill_2
XFILLER_0_21_198 VPWR VGND VPWR VGND sky130_ef_sc_hd__decap_12
X_3170_ _1662_ _1995_ _0212_ VGND VGND VPWR VPWR _0213_ sky130_fd_sc_hd__o21ai_4
X_2121_ net56 VGND VGND VPWR VPWR _0676_ sky130_fd_sc_hd__buf_2
XFILLER_0_16_85 VGND VGND VPWR VPWR sky130_fd_sc_hd__fill_2
XFILLER_0_69_390 VGND VGND VPWR VPWR sky130_fd_sc_hd__fill_2
X_2885_ _1711_ _1601_ _1713_ _1715_ _1586_ _1628_ VGND VGND VPWR VPWR _1989_ sky130_fd_sc_hd__mux4_2
XFILLER_0_44_257 VGND VGND VPWR VPWR sky130_fd_sc_hd__fill_1
XFILLER_0_44_213 VGND VGND VPWR VPWR sky130_fd_sc_hd__decap_3
XTAP_TAPCELL_ROW_32_399 VGND VPWR sky130_fd_sc_hd__tapvpwrvgnd_1
XFILLER_0_29_298 VGND VGND VPWR VPWR sky130_fd_sc_hd__decap_3
X_2954_ _2053_ _2054_ _2056_ VGND VGND VPWR VPWR _2057_ sky130_fd_sc_hd__a21o_1
X_3506_ _1316_ _1635_ _1610_ VGND VGND VPWR VPWR _0559_ sky130_fd_sc_hd__or3_4
XFILLER_0_4_365 VGND VGND VPWR VPWR sky130_fd_sc_hd__decap_3
XPHY_EDGE_ROW_6_Right_6 VGND VGND VPWR VPWR sky130_fd_sc_hd__decap_3
X_2319_ _1314_ _1422_ _1424_ VGND VGND VPWR VPWR _1425_ sky130_fd_sc_hd__a21oi_1
XFILLER_0_57_81 VGND VGND VPWR VPWR sky130_fd_sc_hd__fill_1
X_3437_ _0333_ _1441_ VGND VGND VPWR VPWR _0484_ sky130_fd_sc_hd__nor2_1
X_3368_ _0001_ _1304_ _0404_ _0094_ VGND VGND VPWR VPWR _0410_ sky130_fd_sc_hd__a2bb2o_1
X_3299_ _1461_ VGND VGND VPWR VPWR _0337_ sky130_fd_sc_hd__buf_2
XFILLER_0_67_349 VGND VGND VPWR VPWR sky130_fd_sc_hd__fill_1
XFILLER_0_50_216 VPWR VGND VPWR VGND sky130_ef_sc_hd__decap_12
XFILLER_0_50_205 VGND VGND VPWR VPWR sky130_fd_sc_hd__fill_1
XFILLER_0_35_279 VGND VGND VPWR VPWR sky130_fd_sc_hd__fill_1
XTAP_TAPCELL_ROW_23_333 VGND VPWR sky130_fd_sc_hd__tapvpwrvgnd_1
Xoutput98 net98 VGND VGND VPWR VPWR result[30] sky130_fd_sc_hd__clkbuf_4
Xoutput87 net87 VGND VGND VPWR VPWR result[20] sky130_fd_sc_hd__buf_2
Xoutput76 net76 VGND VGND VPWR VPWR result[10] sky130_fd_sc_hd__buf_2
XFILLER_0_53_39 VPWR VGND VPWR VGND sky130_ef_sc_hd__decap_12
XPHY_EDGE_ROW_59_Right_59 VGND VGND VPWR VPWR sky130_fd_sc_hd__decap_3
XFILLER_0_58_327 VPWR VGND VPWR VGND sky130_ef_sc_hd__decap_12
XFILLER_0_26_279 VGND VGND VPWR VPWR sky130_fd_sc_hd__decap_6
XFILLER_0_1_313 VPWR VGND VPWR VGND sky130_ef_sc_hd__decap_12
XFILLER_0_1_302 VGND VGND VPWR VPWR sky130_fd_sc_hd__fill_1
X_2670_ _1527_ _1529_ _1774_ _1775_ _1403_ VGND VGND VPWR VPWR _1776_ sky130_fd_sc_hd__a311oi_1
XPHY_EDGE_ROW_68_Right_68 VGND VGND VPWR VPWR sky130_fd_sc_hd__decap_3
X_2104_ _0363_ _0373_ _0406_ _0481_ VGND VGND VPWR VPWR _0492_ sky130_fd_sc_hd__o211a_1
X_3222_ _1926_ _0719_ _0260_ _0263_ VGND VGND VPWR VPWR _0264_ sky130_fd_sc_hd__a211o_1
X_3153_ _1676_ VGND VGND VPWR VPWR _0196_ sky130_fd_sc_hd__clkbuf_4
X_3084_ _0127_ _0128_ VGND VGND VPWR VPWR _0129_ sky130_fd_sc_hd__or2_1
XFILLER_0_43_61 VGND VGND VPWR VPWR sky130_fd_sc_hd__decap_3
XTAP_TAPCELL_ROW_37_436 VGND VPWR sky130_fd_sc_hd__tapvpwrvgnd_1
XFILLER_0_27_84 VGND VGND VPWR VPWR sky130_fd_sc_hd__decap_8
XFILLER_0_72_385 VGND VGND VPWR VPWR sky130_fd_sc_hd__fill_1
X_2937_ _2023_ _2029_ _2040_ VGND VGND VPWR VPWR _2076_ sky130_fd_sc_hd__nand3_1
X_2868_ _1697_ VGND VGND VPWR VPWR _1972_ sky130_fd_sc_hd__buf_4
X_3986_ _0032_ _1830_ _1959_ _1072_ VGND VGND VPWR VPWR _1073_ sky130_fd_sc_hd__o31a_1
XFILLER_0_17_202 VGND VGND VPWR VPWR sky130_fd_sc_hd__fill_1
X_2799_ _1900_ _1901_ _1645_ _1903_ VGND VGND VPWR VPWR _1904_ sky130_fd_sc_hd__o211ai_1
XFILLER_0_4_195 VGND VGND VPWR VPWR sky130_fd_sc_hd__fill_1
XFILLER_0_67_113 VPWR VGND VPWR VGND sky130_ef_sc_hd__decap_12
XFILLER_0_55_308 VGND VGND VPWR VPWR sky130_fd_sc_hd__decap_6
XFILLER_0_63_385 VGND VGND VPWR VPWR sky130_fd_sc_hd__decap_6
XFILLER_0_64_27 VGND VGND VPWR VPWR sky130_fd_sc_hd__fill_1
XTAP_TAPCELL_ROW_34_417 VGND VPWR sky130_fd_sc_hd__tapvpwrvgnd_1
XFILLER_0_73_149 VGND VGND VPWR VPWR sky130_fd_sc_hd__fill_1
X_2722_ _1496_ _1797_ _0826_ _0847_ _1681_ VGND VGND VPWR VPWR _1827_ sky130_fd_sc_hd__o221ai_1
XTAP_TAPCELL_ROW_42_472 VGND VPWR sky130_fd_sc_hd__tapvpwrvgnd_1
X_3771_ _1395_ _0764_ _0801_ _0790_ _1178_ VGND VGND VPWR VPWR _0843_ sky130_fd_sc_hd__o221ai_2
X_3840_ _1823_ _0915_ _0916_ VGND VGND VPWR VPWR _0917_ sky130_fd_sc_hd__or3_1
X_2584_ _1646_ _1652_ _1663_ _1689_ VGND VGND VPWR VPWR _1690_ sky130_fd_sc_hd__o31a_1
XFILLER_0_22_271 VPWR VGND VPWR VGND sky130_ef_sc_hd__decap_12
XFILLER_0_10_433 VGND VGND VPWR VPWR sky130_fd_sc_hd__fill_1
X_2653_ _1288_ _1290_ VGND VGND VPWR VPWR _1759_ sky130_fd_sc_hd__nor2_1
X_3136_ _0055_ _0054_ _0804_ VGND VGND VPWR VPWR _0180_ sky130_fd_sc_hd__a21o_1
X_3067_ _1985_ _0111_ _1634_ _1631_ _0037_ VGND VGND VPWR VPWR _0112_ sky130_fd_sc_hd__o221a_1
XFILLER_0_38_72 VPWR VGND VPWR VGND sky130_ef_sc_hd__decap_12
X_4185_ clknet_2_0__leaf_clk _2069_ net121 VGND VGND VPWR VPWR net86 sky130_fd_sc_hd__dfrtp_1
X_3205_ _0244_ _0246_ _1967_ VGND VGND VPWR VPWR _0247_ sky130_fd_sc_hd__mux2_2
XFILLER_0_70_70 VGND VGND VPWR VPWR sky130_fd_sc_hd__fill_2
XFILLER_0_57_190 VPWR VGND VPWR VGND sky130_ef_sc_hd__decap_12
XFILLER_0_49_113 VPWR VGND VPWR VGND sky130_ef_sc_hd__decap_12
XFILLER_0_9_221 VGND VGND VPWR VPWR sky130_fd_sc_hd__decap_3
XFILLER_0_60_333 VGND VGND VPWR VPWR sky130_fd_sc_hd__decap_4
X_3969_ _1704_ _0369_ _1652_ _0370_ VGND VGND VPWR VPWR _1055_ sky130_fd_sc_hd__a211o_1
XFILLER_0_68_433 VGND VGND VPWR VPWR sky130_fd_sc_hd__decap_4
XTAP_TAPCELL_ROW_56_575 VGND VPWR sky130_fd_sc_hd__tapvpwrvgnd_1
XTAP_TAPCELL_ROW_5_197 VGND VPWR sky130_fd_sc_hd__tapvpwrvgnd_1
XFILLER_0_63_160 VGND VGND VPWR VPWR sky130_fd_sc_hd__fill_1
XFILLER_0_63_193 VPWR VGND VPWR VGND sky130_ef_sc_hd__decap_12
XFILLER_0_11_208 VPWR VGND VPWR VGND sky130_ef_sc_hd__decap_12
XFILLER_0_24_63 VGND VGND VPWR VPWR sky130_fd_sc_hd__decap_3
X_3823_ net113 _0898_ _1071_ VGND VGND VPWR VPWR _0899_ sky130_fd_sc_hd__o21ai_1
XTAP_TAPCELL_ROW_19_299 VGND VPWR sky130_fd_sc_hd__tapvpwrvgnd_1
XFILLER_0_54_160 VGND VGND VPWR VPWR sky130_fd_sc_hd__decap_8
X_2705_ _1808_ _1553_ _1537_ _1809_ VGND VGND VPWR VPWR _1810_ sky130_fd_sc_hd__and4b_2
X_3754_ _0764_ _0245_ _0745_ _1485_ VGND VGND VPWR VPWR _0825_ sky130_fd_sc_hd__o31a_1
X_2636_ _1740_ _1741_ VGND VGND VPWR VPWR _1742_ sky130_fd_sc_hd__nor2_1
X_3685_ _1397_ _0196_ _0092_ VGND VGND VPWR VPWR _0752_ sky130_fd_sc_hd__o21ai_1
XFILLER_0_57_3 VPWR VGND VPWR VGND sky130_ef_sc_hd__decap_12
XFILLER_0_49_82 VGND VGND VPWR VPWR sky130_fd_sc_hd__fill_1
XFILLER_0_49_71 VGND VGND VPWR VPWR sky130_fd_sc_hd__fill_1
X_2567_ _1436_ _1432_ _1670_ _1549_ VGND VGND VPWR VPWR _1673_ sky130_fd_sc_hd__nand4_2
X_2498_ _1580_ VGND VGND VPWR VPWR _1604_ sky130_fd_sc_hd__clkbuf_4
XFILLER_0_65_92 VGND VGND VPWR VPWR sky130_fd_sc_hd__fill_2
X_4168_ _1449_ _0449_ _1539_ _1664_ _1541_ VGND VGND VPWR VPWR _1268_ sky130_fd_sc_hd__o2111a_1
X_4099_ _0384_ _0395_ _1192_ _1193_ VGND VGND VPWR VPWR _1194_ sky130_fd_sc_hd__a22o_1
X_3119_ _0162_ _1645_ VGND VGND VPWR VPWR _0163_ sky130_fd_sc_hd__nand2_1
XFILLER_0_4_95 VGND VGND VPWR VPWR sky130_fd_sc_hd__fill_1
XTAP_TAPCELL_ROW_53_556 VGND VPWR sky130_fd_sc_hd__tapvpwrvgnd_1
XFILLER_0_45_160 VGND VGND VPWR VPWR sky130_fd_sc_hd__decap_8
XFILLER_0_45_193 VGND VGND VPWR VPWR sky130_fd_sc_hd__decap_8
XFILLER_0_68_274 VGND VGND VPWR VPWR sky130_fd_sc_hd__decap_8
XFILLER_0_71_417 VPWR VGND VPWR VGND sky130_ef_sc_hd__decap_12
XFILLER_0_43_108 VGND VGND VPWR VPWR sky130_fd_sc_hd__decap_4
XFILLER_0_36_193 VGND VGND VPWR VPWR sky130_fd_sc_hd__decap_3
XFILLER_0_36_171 VGND VGND VPWR VPWR sky130_fd_sc_hd__fill_2
XFILLER_0_24_377 VPWR VGND VPWR VGND sky130_ef_sc_hd__decap_12
X_2283_ net35 _1200_ VGND VGND VPWR VPWR _1389_ sky130_fd_sc_hd__and2b_1
X_2352_ _1289_ VGND VGND VPWR VPWR _1458_ sky130_fd_sc_hd__buf_2
X_2421_ _1403_ _1404_ VGND VGND VPWR VPWR _1527_ sky130_fd_sc_hd__nor2_2
X_3470_ _1929_ _1297_ _1295_ _0004_ VGND VGND VPWR VPWR _0520_ sky130_fd_sc_hd__a2bb2o_1
XTAP_TAPCELL_ROW_67_659 VGND VPWR sky130_fd_sc_hd__tapvpwrvgnd_1
X_4022_ net43 _1441_ _1439_ VGND VGND VPWR VPWR _1111_ sky130_fd_sc_hd__o21ai_1
XFILLER_0_62_417 VGND VGND VPWR VPWR sky130_fd_sc_hd__decap_3
XFILLER_0_59_285 VGND VGND VPWR VPWR sky130_fd_sc_hd__fill_1
XTAP_TAPCELL_ROW_50_537 VGND VPWR sky130_fd_sc_hd__tapvpwrvgnd_1
X_3806_ _0064_ _0578_ _0065_ _0877_ _0880_ VGND VGND VPWR VPWR _0881_ sky130_fd_sc_hd__a311o_1
XFILLER_0_27_160 VGND VGND VPWR VPWR sky130_fd_sc_hd__decap_8
X_3599_ _1842_ _0209_ VGND VGND VPWR VPWR _0659_ sky130_fd_sc_hd__or2_1
XFILLER_0_42_141 VGND VGND VPWR VPWR sky130_fd_sc_hd__decap_4
XFILLER_0_30_369 VGND VGND VPWR VPWR sky130_fd_sc_hd__fill_1
XFILLER_0_30_325 VGND VGND VPWR VPWR sky130_fd_sc_hd__decap_8
X_3668_ _1707_ _1663_ _1646_ _0107_ _1590_ VGND VGND VPWR VPWR _0733_ sky130_fd_sc_hd__o32a_1
X_3737_ _1516_ _1766_ _0806_ _1765_ VGND VGND VPWR VPWR _0807_ sky130_fd_sc_hd__o22ai_1
X_2619_ _1722_ _1723_ _1724_ VGND VGND VPWR VPWR _1725_ sky130_fd_sc_hd__mux2_1
XFILLER_0_15_344 VPWR VGND VPWR VGND sky130_ef_sc_hd__decap_12
XFILLER_0_15_366 VPWR VGND VPWR VGND sky130_ef_sc_hd__decap_12
XFILLER_0_53_406 VGND VGND VPWR VPWR sky130_fd_sc_hd__fill_2
XFILLER_0_21_303 VGND VGND VPWR VPWR sky130_fd_sc_hd__fill_1
XFILLER_0_18_193 VGND VGND VPWR VPWR sky130_fd_sc_hd__decap_3
XFILLER_0_33_196 VGND VGND VPWR VPWR sky130_fd_sc_hd__decap_3
XFILLER_0_21_325 VGND VGND VPWR VPWR sky130_fd_sc_hd__decap_8
XFILLER_0_72_27 VGND VGND VPWR VPWR sky130_fd_sc_hd__fill_1
XTAP_TAPCELL_ROW_72_695 VGND VPWR sky130_fd_sc_hd__tapvpwrvgnd_1
XFILLER_0_71_225 VGND VGND VPWR VPWR sky130_fd_sc_hd__fill_1
XFILLER_0_56_222 VGND VGND VPWR VPWR sky130_fd_sc_hd__decap_6
X_2970_ _1662_ _0012_ _0015_ VGND VGND VPWR VPWR _0016_ sky130_fd_sc_hd__a21o_1
X_3522_ _1449_ _1478_ _1479_ _1451_ _1632_ _1562_ VGND VGND VPWR VPWR _0576_ sky130_fd_sc_hd__mux4_1
XFILLER_0_24_141 VGND VGND VPWR VPWR sky130_fd_sc_hd__decap_6
X_3453_ _1453_ _1455_ _0245_ _1468_ _1894_ _1983_ VGND VGND VPWR VPWR _0501_ sky130_fd_sc_hd__mux4_1
XTAP_TAPCELL_ROW_12_250 VGND VPWR sky130_fd_sc_hd__tapvpwrvgnd_1
X_2335_ _1430_ VGND VGND VPWR VPWR _1441_ sky130_fd_sc_hd__clkbuf_4
X_3384_ _1430_ VGND VGND VPWR VPWR _0426_ sky130_fd_sc_hd__buf_2
X_2266_ net55 net23 VGND VGND VPWR VPWR _1372_ sky130_fd_sc_hd__and2b_1
X_2404_ net55 VGND VGND VPWR VPWR _1510_ sky130_fd_sc_hd__buf_4
XFILLER_0_62_60 VGND VGND VPWR VPWR sky130_fd_sc_hd__decap_3
XFILLER_0_46_83 VGND VGND VPWR VPWR sky130_fd_sc_hd__fill_1
X_4005_ _1778_ _0600_ _0632_ VGND VGND VPWR VPWR _1094_ sky130_fd_sc_hd__nand3_1
X_2197_ _1301_ _1302_ VGND VGND VPWR VPWR _1303_ sky130_fd_sc_hd__and2_1
XFILLER_0_62_203 VGND VGND VPWR VPWR sky130_fd_sc_hd__decap_6
XFILLER_0_47_244 VGND VGND VPWR VPWR sky130_fd_sc_hd__decap_3
XFILLER_0_35_406 VGND VGND VPWR VPWR sky130_fd_sc_hd__decap_3
XFILLER_0_7_385 VGND VGND VPWR VPWR sky130_fd_sc_hd__fill_1
XFILLER_0_30_188 VGND VGND VPWR VPWR sky130_fd_sc_hd__decap_3
XFILLER_0_11_380 VGND VGND VPWR VPWR sky130_fd_sc_hd__fill_2
XFILLER_0_38_244 VGND VGND VPWR VPWR sky130_fd_sc_hd__fill_2
XTAP_TAPCELL_ROW_26_353 VGND VPWR sky130_fd_sc_hd__tapvpwrvgnd_1
XANTENNA_7 _0251_ VGND VGND VPWR VPWR sky130_fd_sc_hd__diode_2
XFILLER_0_21_100 VPWR VGND VPWR VGND sky130_ef_sc_hd__decap_12
X_2120_ net56 net24 VGND VGND VPWR VPWR _0665_ sky130_fd_sc_hd__or2_1
XFILLER_0_21_188 VGND VGND VPWR VPWR sky130_fd_sc_hd__fill_2
XTAP_TAPCELL_ROW_60_610 VGND VPWR sky130_fd_sc_hd__tapvpwrvgnd_1
X_2884_ _1954_ _1979_ _1987_ _1865_ VGND VGND VPWR VPWR _1988_ sky130_fd_sc_hd__a211o_1
XFILLER_0_32_41 VGND VGND VPWR VPWR sky130_fd_sc_hd__fill_2
XFILLER_0_29_233 VPWR VGND VPWR VGND sky130_ef_sc_hd__decap_12
X_2953_ _1967_ _2055_ _1560_ VGND VGND VPWR VPWR _2056_ sky130_fd_sc_hd__o21a_1
XFILLER_0_4_322 VGND VGND VPWR VPWR sky130_fd_sc_hd__decap_4
X_3436_ _0333_ _1938_ _1439_ VGND VGND VPWR VPWR _0483_ sky130_fd_sc_hd__o21ai_1
X_3505_ _0337_ _0555_ _0556_ VGND VGND VPWR VPWR _0558_ sky130_fd_sc_hd__a21o_1
XFILLER_0_4_344 VGND VGND VPWR VPWR sky130_fd_sc_hd__decap_3
XFILLER_0_12_177 VPWR VGND VPWR VGND sky130_ef_sc_hd__decap_12
X_2249_ net57 VGND VGND VPWR VPWR _1355_ sky130_fd_sc_hd__inv_2
X_2318_ _1423_ VGND VGND VPWR VPWR _1424_ sky130_fd_sc_hd__buf_2
X_3298_ _1604_ _1309_ _1573_ _1583_ VGND VGND VPWR VPWR _0336_ sky130_fd_sc_hd__a31o_1
X_3367_ _0407_ _0408_ _1553_ _1435_ VGND VGND VPWR VPWR _0409_ sky130_fd_sc_hd__and4b_1
XFILLER_0_73_81 VGND VGND VPWR VPWR sky130_fd_sc_hd__decap_3
XTAP_TAPCELL_ROW_23_334 VGND VPWR sky130_fd_sc_hd__tapvpwrvgnd_1
XFILLER_0_50_239 VGND VGND VPWR VPWR sky130_fd_sc_hd__fill_2
XFILLER_0_50_228 VGND VGND VPWR VPWR sky130_fd_sc_hd__decap_8
XFILLER_0_35_247 VPWR VGND VPWR VGND sky130_ef_sc_hd__decap_12
Xoutput99 net99 VGND VGND VPWR VPWR result[31] sky130_fd_sc_hd__clkbuf_4
Xoutput88 net88 VGND VGND VPWR VPWR result[21] sky130_fd_sc_hd__buf_2
XFILLER_0_37_19 VGND VGND VPWR VPWR sky130_fd_sc_hd__fill_2
XFILLER_0_9_3 VGND VGND VPWR VPWR sky130_fd_sc_hd__decap_6
Xoutput77 net77 VGND VGND VPWR VPWR result[11] sky130_fd_sc_hd__buf_2
XFILLER_0_58_339 VGND VGND VPWR VPWR sky130_fd_sc_hd__fill_1
XFILLER_0_73_309 VGND VGND VPWR VPWR sky130_fd_sc_hd__fill_2
XFILLER_0_66_394 VGND VGND VPWR VPWR sky130_fd_sc_hd__fill_1
XFILLER_0_26_225 VGND VGND VPWR VPWR sky130_fd_sc_hd__decap_6
XFILLER_0_41_228 VPWR VGND VPWR VGND sky130_ef_sc_hd__decap_12
XFILLER_0_1_325 VGND VGND VPWR VPWR sky130_fd_sc_hd__decap_8
X_3083_ _0126_ _0091_ _1487_ _2026_ VGND VGND VPWR VPWR _0128_ sky130_fd_sc_hd__a31o_1
X_2103_ _0417_ _0438_ _0460_ _0471_ VGND VGND VPWR VPWR _0481_ sky130_fd_sc_hd__o211a_1
X_3221_ _1485_ _1651_ _0036_ _0261_ _0262_ VGND VGND VPWR VPWR _0263_ sky130_fd_sc_hd__a311o_1
X_3152_ _1874_ _1556_ _1985_ _1598_ VGND VGND VPWR VPWR _0195_ sky130_fd_sc_hd__or4_2
XFILLER_0_27_30 VPWR VGND VPWR VGND sky130_ef_sc_hd__decap_12
XFILLER_0_64_309 VPWR VGND VPWR VGND sky130_ef_sc_hd__decap_12
XFILLER_0_57_350 VPWR VGND VPWR VGND sky130_ef_sc_hd__decap_12
XFILLER_0_43_73 VPWR VGND VPWR VGND sky130_ef_sc_hd__decap_12
X_3985_ _1704_ _0453_ _0454_ _1652_ VGND VGND VPWR VPWR _1072_ sky130_fd_sc_hd__a211o_1
XTAP_TAPCELL_ROW_37_437 VGND VPWR sky130_fd_sc_hd__tapvpwrvgnd_1
X_2867_ _1945_ _1347_ _1968_ _1969_ _1567_ _1970_ VGND VGND VPWR VPWR _1971_ sky130_fd_sc_hd__mux4_2
X_2936_ _2030_ _2031_ _2034_ _2036_ _2039_ VGND VGND VPWR VPWR _2040_ sky130_fd_sc_hd__o32a_1
X_2798_ _1654_ _1656_ _1853_ _1731_ _1902_ VGND VGND VPWR VPWR _1903_ sky130_fd_sc_hd__a311o_1
XFILLER_0_32_239 VGND VGND VPWR VPWR sky130_fd_sc_hd__decap_4
XFILLER_0_4_141 VGND VGND VPWR VPWR sky130_fd_sc_hd__fill_2
XFILLER_0_4_130 VGND VGND VPWR VPWR sky130_fd_sc_hd__decap_8
XFILLER_0_0_391 VGND VGND VPWR VPWR sky130_fd_sc_hd__fill_1
X_3419_ _0459_ _0461_ _0413_ _0462_ _0464_ VGND VGND VPWR VPWR _0465_ sky130_fd_sc_hd__o221a_1
XFILLER_0_67_125 VGND VGND VPWR VPWR sky130_fd_sc_hd__decap_8
XFILLER_0_67_169 VGND VGND VPWR VPWR sky130_fd_sc_hd__fill_2
XFILLER_0_48_29 VPWR VGND VPWR VGND sky130_ef_sc_hd__decap_12
XPHY_EDGE_ROW_39_Left_113 VGND VGND VPWR VPWR sky130_fd_sc_hd__decap_3
XFILLER_0_31_250 VPWR VGND VPWR VGND sky130_ef_sc_hd__decap_12
XPHY_EDGE_ROW_48_Left_122 VGND VGND VPWR VPWR sky130_fd_sc_hd__decap_3
XFILLER_0_58_103 VPWR VGND VPWR VGND sky130_ef_sc_hd__decap_12
XFILLER_0_46_309 VGND VGND VPWR VPWR sky130_fd_sc_hd__decap_3
XFILLER_0_39_361 VPWR VGND VPWR VGND sky130_ef_sc_hd__decap_12
XFILLER_0_73_139 VGND VGND VPWR VPWR sky130_fd_sc_hd__fill_1
X_2721_ _1496_ _1825_ _1813_ VGND VGND VPWR VPWR _1826_ sky130_fd_sc_hd__nand3b_1
XPHY_EDGE_ROW_57_Left_131 VGND VGND VPWR VPWR sky130_fd_sc_hd__decap_3
XTAP_TAPCELL_ROW_42_473 VGND VPWR sky130_fd_sc_hd__tapvpwrvgnd_1
X_2652_ _1385_ _1365_ _1364_ VGND VGND VPWR VPWR _1758_ sky130_fd_sc_hd__and3_1
X_3770_ _2038_ _0840_ _0841_ VGND VGND VPWR VPWR _0842_ sky130_fd_sc_hd__or3_1
XFILLER_0_13_43 VPWR VGND VPWR VGND sky130_ef_sc_hd__decap_12
XFILLER_0_14_217 VGND VGND VPWR VPWR sky130_fd_sc_hd__decap_3
XFILLER_0_14_239 VGND VGND VPWR VPWR sky130_fd_sc_hd__fill_1
X_2583_ _1424_ _1667_ _1688_ VGND VGND VPWR VPWR _1689_ sky130_fd_sc_hd__a21oi_1
XFILLER_0_22_283 VPWR VGND VPWR VGND sky130_ef_sc_hd__decap_12
X_3204_ _1467_ _1468_ _1455_ _0245_ _1877_ _1970_ VGND VGND VPWR VPWR _0246_ sky130_fd_sc_hd__mux4_1
X_3135_ _0056_ _0178_ _0154_ VGND VGND VPWR VPWR _0179_ sky130_fd_sc_hd__nand3_1
X_3066_ _1968_ _2048_ _1945_ _1805_ _1983_ _1587_ VGND VGND VPWR VPWR _0111_ sky130_fd_sc_hd__mux4_1
XPHY_EDGE_ROW_66_Left_140 VGND VGND VPWR VPWR sky130_fd_sc_hd__decap_3
X_4184_ clknet_2_1__leaf_clk _2058_ net121 VGND VGND VPWR VPWR net75 sky130_fd_sc_hd__dfrtp_1
XFILLER_0_70_82 VGND VGND VPWR VPWR sky130_fd_sc_hd__fill_2
X_2919_ _1944_ _1947_ _1949_ _1953_ _2022_ VGND VGND VPWR VPWR _2023_ sky130_fd_sc_hd__o311a_1
XFILLER_0_49_169 VGND VGND VPWR VPWR sky130_fd_sc_hd__fill_2
XFILLER_0_49_125 VPWR VGND VPWR VGND sky130_ef_sc_hd__decap_12
XFILLER_0_45_353 VGND VGND VPWR VPWR sky130_fd_sc_hd__fill_2
XFILLER_0_37_309 VGND VGND VPWR VPWR sky130_fd_sc_hd__decap_3
X_3968_ _1916_ _0399_ _0397_ _1032_ _1053_ VGND VGND VPWR VPWR _1054_ sky130_fd_sc_hd__a221oi_1
XFILLER_0_9_244 VGND VGND VPWR VPWR sky130_fd_sc_hd__decap_3
XFILLER_0_60_301 VGND VGND VPWR VPWR sky130_fd_sc_hd__decap_6
XFILLER_0_45_397 VGND VGND VPWR VPWR sky130_fd_sc_hd__fill_1
X_3899_ _0978_ _2024_ _1474_ VGND VGND VPWR VPWR _0980_ sky130_fd_sc_hd__a21oi_1
XFILLER_0_13_272 VGND VGND VPWR VPWR sky130_fd_sc_hd__fill_1
XFILLER_0_68_401 VPWR VGND VPWR VGND sky130_ef_sc_hd__decap_12
XTAP_TAPCELL_ROW_56_576 VGND VPWR sky130_fd_sc_hd__tapvpwrvgnd_1
XFILLER_0_28_309 VGND VGND VPWR VPWR sky130_fd_sc_hd__decap_6
XTAP_TAPCELL_ROW_5_198 VGND VPWR sky130_fd_sc_hd__tapvpwrvgnd_1
XFILLER_0_51_334 VGND VGND VPWR VPWR sky130_fd_sc_hd__fill_2
XFILLER_0_36_331 VGND VGND VPWR VPWR sky130_fd_sc_hd__fill_1
XTAP_TAPCELL_ROW_47_510 VGND VPWR sky130_fd_sc_hd__tapvpwrvgnd_1
XFILLER_0_39_180 VGND VGND VPWR VPWR sky130_fd_sc_hd__fill_2
XFILLER_0_19_309 VPWR VGND VPWR VGND sky130_ef_sc_hd__decap_12
X_3822_ _0748_ _1387_ _1232_ VGND VGND VPWR VPWR _0898_ sky130_fd_sc_hd__a21oi_2
XFILLER_0_54_183 VPWR VGND VPWR VGND sky130_ef_sc_hd__decap_12
XFILLER_0_42_323 VGND VGND VPWR VPWR sky130_fd_sc_hd__fill_1
X_2704_ net67 VGND VGND VPWR VPWR _1809_ sky130_fd_sc_hd__buf_2
XFILLER_0_40_85 VGND VGND VPWR VPWR sky130_fd_sc_hd__decap_6
X_3753_ _0211_ _0816_ _0817_ _0822_ _0823_ VGND VGND VPWR VPWR _0824_ sky130_fd_sc_hd__o2111a_1
X_3684_ _1093_ _1104_ _1815_ _0749_ VGND VGND VPWR VPWR _0750_ sky130_fd_sc_hd__a31o_1
X_2635_ _1050_ _1411_ VGND VGND VPWR VPWR _1741_ sky130_fd_sc_hd__nor2_2
X_2497_ _1357_ _1593_ _1602_ VGND VGND VPWR VPWR _1603_ sky130_fd_sc_hd__a21o_1
X_2566_ _1671_ VGND VGND VPWR VPWR _1672_ sky130_fd_sc_hd__buf_4
X_4167_ _0596_ _0106_ _1611_ _0266_ VGND VGND VPWR VPWR _1267_ sky130_fd_sc_hd__or4_1
XTAP_TAPCELL_ROW_53_557 VGND VPWR sky130_fd_sc_hd__tapvpwrvgnd_1
X_4098_ _0363_ _0373_ _1500_ _1142_ VGND VGND VPWR VPWR _1193_ sky130_fd_sc_hd__a2bb2o_1
X_3049_ _1670_ _1664_ _1553_ VGND VGND VPWR VPWR _0094_ sky130_fd_sc_hd__and3_4
X_3118_ _1700_ _0078_ _1843_ _0161_ VGND VGND VPWR VPWR _0162_ sky130_fd_sc_hd__o31a_1
XFILLER_0_65_426 VGND VGND VPWR VPWR sky130_fd_sc_hd__decap_6
XFILLER_0_45_183 VGND VGND VPWR VPWR sky130_fd_sc_hd__decap_3
XFILLER_0_45_150 VGND VGND VPWR VPWR sky130_fd_sc_hd__decap_4
XFILLER_0_37_139 VGND VGND VPWR VPWR sky130_fd_sc_hd__decap_4
XFILLER_0_33_301 VPWR VGND VPWR VGND sky130_ef_sc_hd__decap_12
XFILLER_0_68_253 VGND VGND VPWR VPWR sky130_fd_sc_hd__decap_4
XFILLER_0_71_429 VGND VGND VPWR VPWR sky130_fd_sc_hd__decap_8
XFILLER_0_24_389 VPWR VGND VPWR VGND sky130_ef_sc_hd__decap_12
XFILLER_0_24_301 VGND VGND VPWR VPWR sky130_fd_sc_hd__fill_1
XPHY_EDGE_ROW_24_Left_98 VGND VGND VPWR VPWR sky130_fd_sc_hd__decap_3
X_2420_ _1125_ _1523_ _1394_ _1525_ VGND VGND VPWR VPWR _1526_ sky130_fd_sc_hd__o31ai_4
XFILLER_0_10_77 VGND VGND VPWR VPWR sky130_fd_sc_hd__decap_6
X_4021_ _2032_ _2033_ _1789_ VGND VGND VPWR VPWR _1110_ sky130_fd_sc_hd__a21oi_1
X_2282_ _1367_ _1377_ _1243_ _1387_ VGND VGND VPWR VPWR _1388_ sky130_fd_sc_hd__o211ai_2
X_2351_ _1455_ _1456_ VGND VGND VPWR VPWR _1457_ sky130_fd_sc_hd__or2_1
X_3805_ _0024_ _1651_ _0070_ _0577_ _0878_ VGND VGND VPWR VPWR _0880_ sky130_fd_sc_hd__o221a_1
X_3736_ _1125_ _1136_ _1114_ VGND VGND VPWR VPWR _0806_ sky130_fd_sc_hd__o21ai_1
XTAP_TAPCELL_ROW_15_270 VGND VPWR sky130_fd_sc_hd__tapvpwrvgnd_1
X_3598_ _0142_ _0218_ _0657_ VGND VGND VPWR VPWR _0658_ sky130_fd_sc_hd__o21ai_1
X_2618_ _1657_ VGND VGND VPWR VPWR _1724_ sky130_fd_sc_hd__buf_4
XFILLER_0_42_197 VGND VGND VPWR VPWR sky130_fd_sc_hd__fill_1
XFILLER_0_30_304 VGND VGND VPWR VPWR sky130_fd_sc_hd__decap_4
X_3667_ _1709_ _1910_ _0312_ _0323_ _0731_ VGND VGND VPWR VPWR _0732_ sky130_fd_sc_hd__o32a_1
X_2549_ net44 _1305_ VGND VGND VPWR VPWR _1655_ sky130_fd_sc_hd__or2b_1
XFILLER_0_15_356 VGND VGND VPWR VPWR sky130_fd_sc_hd__decap_4
XFILLER_0_15_378 VPWR VGND VPWR VGND sky130_ef_sc_hd__decap_12
X_4219_ clknet_2_2__leaf_clk net125 net123 VGND VGND VPWR VPWR net73 sky130_fd_sc_hd__dfrtp_1
XFILLER_0_65_234 VGND VGND VPWR VPWR sky130_fd_sc_hd__fill_2
XFILLER_0_65_223 VGND VGND VPWR VPWR sky130_fd_sc_hd__fill_1
XFILLER_0_65_212 VGND VGND VPWR VPWR sky130_fd_sc_hd__decap_6
XFILLER_0_21_337 VGND VGND VPWR VPWR sky130_fd_sc_hd__decap_8
XFILLER_0_18_172 VGND VGND VPWR VPWR sky130_fd_sc_hd__fill_1
XFILLER_0_56_29 VGND VGND VPWR VPWR sky130_fd_sc_hd__decap_3
XTAP_TAPCELL_ROW_29_373 VGND VPWR sky130_fd_sc_hd__tapvpwrvgnd_1
XTAP_TAPCELL_ROW_72_696 VGND VPWR sky130_fd_sc_hd__tapvpwrvgnd_1
XFILLER_0_44_407 VPWR VGND VPWR VGND sky130_ef_sc_hd__decap_12
XTAP_TAPCELL_ROW_12_251 VGND VPWR sky130_fd_sc_hd__tapvpwrvgnd_1
X_3521_ net17 net19 _1347_ _1805_ _1632_ _1570_ VGND VGND VPWR VPWR _0575_ sky130_fd_sc_hd__mux4_1
XFILLER_0_24_197 VGND VGND VPWR VPWR sky130_fd_sc_hd__decap_6
X_3383_ _1314_ _1422_ _0383_ VGND VGND VPWR VPWR _0425_ sky130_fd_sc_hd__a21o_1
X_2403_ _1381_ _1293_ _1386_ VGND VGND VPWR VPWR _1509_ sky130_fd_sc_hd__a21o_1
XFILLER_0_12_315 VGND VGND VPWR VPWR sky130_fd_sc_hd__fill_1
X_3452_ _0333_ _1696_ _0337_ _1458_ _1587_ _1890_ VGND VGND VPWR VPWR _0500_ sky130_fd_sc_hd__mux4_1
X_2334_ net49 _1431_ _1439_ VGND VGND VPWR VPWR _1440_ sky130_fd_sc_hd__o21ai_1
X_4004_ _0535_ _0546_ _1089_ _1091_ VGND VGND VPWR VPWR _1092_ sky130_fd_sc_hd__a31o_1
X_2265_ _1368_ _1369_ _1370_ VGND VGND VPWR VPWR _1371_ sky130_fd_sc_hd__o21bai_4
X_2196_ net12 VGND VGND VPWR VPWR _1302_ sky130_fd_sc_hd__clkbuf_2
XTAP_TAPCELL_ROW_63_630 VGND VPWR sky130_fd_sc_hd__tapvpwrvgnd_1
XFILLER_0_47_223 VGND VGND VPWR VPWR sky130_fd_sc_hd__fill_1
XFILLER_0_62_248 VGND VGND VPWR VPWR sky130_fd_sc_hd__decap_4
XFILLER_0_47_278 VGND VGND VPWR VPWR sky130_fd_sc_hd__fill_2
XFILLER_0_7_342 VGND VGND VPWR VPWR sky130_fd_sc_hd__decap_4
XFILLER_0_7_353 VGND VGND VPWR VPWR sky130_fd_sc_hd__decap_8
X_3719_ _0754_ _1146_ _0736_ _2037_ VGND VGND VPWR VPWR _0788_ sky130_fd_sc_hd__a31o_1
XFILLER_0_15_120 VGND VGND VPWR VPWR sky130_fd_sc_hd__fill_1
XFILLER_0_53_204 VGND VGND VPWR VPWR sky130_fd_sc_hd__decap_6
XFILLER_0_38_289 VGND VGND VPWR VPWR sky130_fd_sc_hd__fill_1
XFILLER_0_38_234 VGND VGND VPWR VPWR sky130_fd_sc_hd__decap_6
XFILLER_0_26_418 VGND VGND VPWR VPWR sky130_fd_sc_hd__fill_2
XTAP_TAPCELL_ROW_26_354 VGND VPWR sky130_fd_sc_hd__tapvpwrvgnd_1
XFILLER_0_61_281 VGND VGND VPWR VPWR sky130_fd_sc_hd__decap_3
XANTENNA_8 _0324_ VGND VGND VPWR VPWR sky130_fd_sc_hd__diode_2
XFILLER_0_21_167 VGND VGND VPWR VPWR sky130_fd_sc_hd__fill_1
XTAP_TAPCELL_ROW_60_611 VGND VPWR sky130_fd_sc_hd__tapvpwrvgnd_1
XFILLER_0_29_245 VGND VGND VPWR VPWR sky130_fd_sc_hd__decap_8
X_2952_ _1833_ _1843_ _1697_ VGND VGND VPWR VPWR _2055_ sky130_fd_sc_hd__mux2_2
XFILLER_0_16_54 VGND VGND VPWR VPWR sky130_fd_sc_hd__fill_1
X_2883_ _1634_ _1982_ _1984_ _1986_ VGND VGND VPWR VPWR _1987_ sky130_fd_sc_hd__o22ai_1
XFILLER_0_44_237 VGND VGND VPWR VPWR sky130_fd_sc_hd__fill_2
XFILLER_0_40_421 VPWR VGND VPWR VGND sky130_ef_sc_hd__decap_12
XFILLER_0_29_289 VGND VGND VPWR VPWR sky130_fd_sc_hd__fill_1
X_3435_ _1417_ _1429_ _1353_ _1948_ _0433_ VGND VGND VPWR VPWR _0482_ sky130_fd_sc_hd__o221a_1
X_3504_ _0337_ _0555_ _1810_ VGND VGND VPWR VPWR _0556_ sky130_fd_sc_hd__o21ai_1
XFILLER_0_12_145 VGND VGND VPWR VPWR sky130_fd_sc_hd__fill_1
XFILLER_0_12_167 VGND VGND VPWR VPWR sky130_fd_sc_hd__decap_3
XFILLER_0_12_189 VGND VGND VPWR VPWR sky130_fd_sc_hd__decap_6
X_3366_ _1426_ _1308_ _1693_ VGND VGND VPWR VPWR _0408_ sky130_fd_sc_hd__a21o_1
X_2248_ net24 VGND VGND VPWR VPWR _1354_ sky130_fd_sc_hd__inv_2
XFILLER_0_67_307 VGND VGND VPWR VPWR sky130_fd_sc_hd__decap_6
X_2317_ net17 VGND VGND VPWR VPWR _1423_ sky130_fd_sc_hd__clkbuf_4
XFILLER_0_32_3 VGND VGND VPWR VPWR sky130_fd_sc_hd__decap_4
X_2179_ net59 net27 VGND VGND VPWR VPWR _1285_ sky130_fd_sc_hd__or2_1
X_3297_ _1890_ _1464_ _0334_ _1972_ VGND VGND VPWR VPWR _0335_ sky130_fd_sc_hd__o211a_1
XFILLER_0_67_318 VGND VGND VPWR VPWR sky130_fd_sc_hd__decap_6
XPHY_EDGE_ROW_11_Left_85 VGND VGND VPWR VPWR sky130_fd_sc_hd__decap_3
XFILLER_0_43_281 VPWR VGND VPWR VGND sky130_ef_sc_hd__decap_12
XFILLER_0_35_259 VGND VGND VPWR VPWR sky130_fd_sc_hd__decap_6
XTAP_TAPCELL_ROW_31_390 VGND VPWR sky130_fd_sc_hd__tapvpwrvgnd_1
Xoutput89 net89 VGND VGND VPWR VPWR result[22] sky130_fd_sc_hd__buf_2
Xoutput78 net78 VGND VGND VPWR VPWR result[12] sky130_fd_sc_hd__buf_2
XFILLER_0_66_351 VGND VGND VPWR VPWR sky130_fd_sc_hd__decap_8
X_3220_ _1930_ _0719_ _0729_ _0094_ VGND VGND VPWR VPWR _0262_ sky130_fd_sc_hd__a2bb2o_1
XFILLER_0_34_281 VGND VGND VPWR VPWR sky130_fd_sc_hd__decap_4
XFILLER_0_22_421 VGND VGND VPWR VPWR sky130_fd_sc_hd__decap_8
XFILLER_0_1_359 VPWR VGND VPWR VGND sky130_ef_sc_hd__decap_12
XFILLER_0_1_337 VGND VGND VPWR VPWR sky130_fd_sc_hd__decap_4
X_3082_ _0126_ _2024_ _0091_ VGND VGND VPWR VPWR _0127_ sky130_fd_sc_hd__a21oi_1
X_2102_ net48 net16 VGND VGND VPWR VPWR _0471_ sky130_fd_sc_hd__or2b_2
XTAP_TAPCELL_ROW_37_438 VGND VPWR sky130_fd_sc_hd__tapvpwrvgnd_1
X_3151_ _1659_ _1892_ _1726_ VGND VGND VPWR VPWR _0194_ sky130_fd_sc_hd__or3_2
XFILLER_0_27_53 VGND VGND VPWR VPWR sky130_fd_sc_hd__decap_3
XFILLER_0_72_321 VGND VGND VPWR VPWR sky130_fd_sc_hd__decap_6
X_2935_ _1826_ _2035_ _0965_ _2038_ VGND VGND VPWR VPWR _2039_ sky130_fd_sc_hd__a31o_1
XFILLER_0_57_362 VGND VGND VPWR VPWR sky130_fd_sc_hd__fill_1
XTAP_TAPCELL_ROW_45_493 VGND VPWR sky130_fd_sc_hd__tapvpwrvgnd_1
XFILLER_0_43_96 VPWR VGND VPWR VGND sky130_ef_sc_hd__decap_12
XFILLER_0_43_85 VGND VGND VPWR VPWR sky130_fd_sc_hd__decap_3
X_3984_ _1062_ _1066_ _1068_ _1070_ VGND VGND VPWR VPWR _2066_ sky130_fd_sc_hd__nand4_1
XTAP_TAPCELL_ROW_20_305 VGND VPWR sky130_fd_sc_hd__tapvpwrvgnd_1
X_2866_ _1586_ VGND VGND VPWR VPWR _1970_ sky130_fd_sc_hd__buf_4
X_2797_ _1728_ _1729_ _1851_ VGND VGND VPWR VPWR _1902_ sky130_fd_sc_hd__and3_1
XFILLER_0_40_251 VGND VGND VPWR VPWR sky130_fd_sc_hd__fill_1
XFILLER_0_25_281 VPWR VGND VPWR VGND sky130_ef_sc_hd__decap_12
XFILLER_0_4_197 VGND VGND VPWR VPWR sky130_fd_sc_hd__fill_2
XFILLER_0_4_153 VPWR VGND VPWR VGND sky130_ef_sc_hd__decap_12
X_3418_ _1753_ _1750_ _0463_ VGND VGND VPWR VPWR _0464_ sky130_fd_sc_hd__o21ai_1
X_3349_ _1577_ _1411_ _1850_ VGND VGND VPWR VPWR _0389_ sky130_fd_sc_hd__o21a_1
XFILLER_0_48_340 VPWR VGND VPWR VGND sky130_ef_sc_hd__decap_12
XFILLER_0_23_229 VGND VGND VPWR VPWR sky130_fd_sc_hd__fill_1
XFILLER_0_48_19 VGND VGND VPWR VPWR sky130_fd_sc_hd__decap_8
XFILLER_0_31_262 VPWR VGND VPWR VGND sky130_ef_sc_hd__decap_12
XFILLER_0_58_137 VGND VGND VPWR VPWR sky130_fd_sc_hd__decap_3
XFILLER_0_58_115 VGND VGND VPWR VPWR sky130_fd_sc_hd__decap_6
XFILLER_0_39_373 VGND VGND VPWR VPWR sky130_fd_sc_hd__decap_8
XFILLER_0_13_55 VGND VGND VPWR VPWR sky130_fd_sc_hd__fill_1
X_2582_ _1496_ _1672_ _1674_ _1424_ _1687_ VGND VGND VPWR VPWR _1688_ sky130_fd_sc_hd__o221ai_1
X_2720_ _1778_ _1782_ _1796_ VGND VGND VPWR VPWR _1825_ sky130_fd_sc_hd__a21o_1
XFILLER_0_54_365 VGND VGND VPWR VPWR sky130_fd_sc_hd__decap_3
XFILLER_0_54_332 VGND VGND VPWR VPWR sky130_fd_sc_hd__fill_1
XTAP_TAPCELL_ROW_42_474 VGND VPWR sky130_fd_sc_hd__tapvpwrvgnd_1
XFILLER_0_22_251 VGND VGND VPWR VPWR sky130_fd_sc_hd__fill_1
X_2651_ _1756_ _1285_ _1286_ VGND VGND VPWR VPWR _1757_ sky130_fd_sc_hd__and3_1
XFILLER_0_13_99 VPWR VGND VPWR VGND sky130_ef_sc_hd__decap_12
X_4183_ _1251_ _1255_ _1257_ _1283_ VGND VGND VPWR VPWR _2073_ sky130_fd_sc_hd__nand4_1
XFILLER_0_38_85 VGND VGND VPWR VPWR sky130_fd_sc_hd__decap_8
XFILLER_0_22_295 VPWR VGND VPWR VGND sky130_ef_sc_hd__decap_12
X_3203_ _1456_ VGND VGND VPWR VPWR _0245_ sky130_fd_sc_hd__clkbuf_4
X_3134_ net53 _1968_ VGND VGND VPWR VPWR _0178_ sky130_fd_sc_hd__or2b_1
XFILLER_0_54_95 VPWR VGND VPWR VGND sky130_ef_sc_hd__decap_12
X_3065_ _1978_ _1624_ _0109_ _1626_ _1510_ _1581_ VGND VGND VPWR VPWR _0110_ sky130_fd_sc_hd__mux4_1
XFILLER_0_49_148 VPWR VGND VPWR VGND sky130_ef_sc_hd__decap_12
XFILLER_0_49_137 VGND VGND VPWR VPWR sky130_fd_sc_hd__decap_4
X_2918_ _1558_ _1966_ _1977_ _1988_ _2021_ VGND VGND VPWR VPWR _2022_ sky130_fd_sc_hd__o2111a_1
XFILLER_0_45_376 VPWR VGND VPWR VGND sky130_ef_sc_hd__decap_12
X_3967_ _1716_ _1048_ _1051_ _1052_ VGND VGND VPWR VPWR _1053_ sky130_fd_sc_hd__a211o_1
X_3898_ _0978_ _1474_ _1487_ VGND VGND VPWR VPWR _0979_ sky130_fd_sc_hd__and3_1
XFILLER_0_9_278 VGND VGND VPWR VPWR sky130_fd_sc_hd__fill_2
XFILLER_0_72_195 VGND VGND VPWR VPWR sky130_fd_sc_hd__fill_1
X_2849_ _0965_ _1951_ _1952_ VGND VGND VPWR VPWR _1953_ sky130_fd_sc_hd__o21ai_1
XFILLER_0_60_379 VGND VGND VPWR VPWR sky130_fd_sc_hd__fill_2
XTAP_TAPCELL_ROW_5_199 VGND VPWR sky130_fd_sc_hd__tapvpwrvgnd_1
XFILLER_0_68_413 VGND VGND VPWR VPWR sky130_fd_sc_hd__decap_6
XTAP_TAPCELL_ROW_56_577 VGND VPWR sky130_fd_sc_hd__tapvpwrvgnd_1
XFILLER_0_55_129 VGND VGND VPWR VPWR sky130_fd_sc_hd__decap_4
XFILLER_0_36_398 VPWR VGND VPWR VGND sky130_ef_sc_hd__decap_12
XFILLER_0_36_343 VGND VGND VPWR VPWR sky130_fd_sc_hd__decap_3
XTAP_TAPCELL_ROW_47_511 VGND VPWR sky130_fd_sc_hd__tapvpwrvgnd_1
XFILLER_0_54_173 VGND VGND VPWR VPWR sky130_fd_sc_hd__decap_4
X_3821_ _0893_ _0896_ _0072_ _0781_ VGND VGND VPWR VPWR _0897_ sky130_fd_sc_hd__a22oi_2
X_3752_ _0064_ _0080_ _2004_ _0450_ VGND VGND VPWR VPWR _0823_ sky130_fd_sc_hd__or4_1
XFILLER_0_27_343 VGND VGND VPWR VPWR sky130_fd_sc_hd__fill_1
XFILLER_0_54_195 VGND VGND VPWR VPWR sky130_fd_sc_hd__fill_1
X_2703_ net68 VGND VGND VPWR VPWR _1808_ sky130_fd_sc_hd__buf_2
X_2634_ _1739_ VGND VGND VPWR VPWR _1740_ sky130_fd_sc_hd__buf_2
X_3683_ _1114_ _0748_ _1387_ _1822_ VGND VGND VPWR VPWR _0749_ sky130_fd_sc_hd__a31o_1
XFILLER_0_2_421 VPWR VGND VPWR VGND sky130_ef_sc_hd__decap_12
XFILLER_0_10_210 VPWR VGND VPWR VGND sky130_ef_sc_hd__decap_12
X_2565_ net117 _1670_ VGND VGND VPWR VPWR _1671_ sky130_fd_sc_hd__nand2_2
X_2496_ _1563_ net21 VGND VGND VPWR VPWR _1602_ sky130_fd_sc_hd__nor2_1
X_4166_ _1652_ _0683_ _1263_ _1265_ VGND VGND VPWR VPWR _1266_ sky130_fd_sc_hd__a2bb2o_1
X_3117_ _1700_ _1896_ VGND VGND VPWR VPWR _0161_ sky130_fd_sc_hd__nand2_1
X_4097_ _1336_ _1337_ VGND VGND VPWR VPWR _1192_ sky130_fd_sc_hd__or2_1
XTAP_TAPCELL_ROW_53_558 VGND VPWR sky130_fd_sc_hd__tapvpwrvgnd_1
X_3048_ _1612_ _1548_ _1913_ VGND VGND VPWR VPWR _0093_ sky130_fd_sc_hd__a21oi_1
XTAP_TAPCELL_ROW_18_290 VGND VPWR sky130_fd_sc_hd__tapvpwrvgnd_1
XFILLER_0_33_346 VPWR VGND VPWR VGND sky130_ef_sc_hd__decap_12
XFILLER_0_33_335 VGND VGND VPWR VPWR sky130_fd_sc_hd__fill_1
XFILLER_0_33_313 VGND VGND VPWR VPWR sky130_fd_sc_hd__fill_2
XFILLER_0_5_281 VPWR VGND VPWR VGND sky130_ef_sc_hd__decap_12
XFILLER_0_18_365 VPWR VGND VPWR VGND sky130_ef_sc_hd__decap_12
XFILLER_0_18_398 VGND VGND VPWR VPWR sky130_fd_sc_hd__fill_2
XFILLER_0_61_19 VPWR VGND VPWR VGND sky130_ef_sc_hd__decap_12
XFILLER_0_28_118 VGND VGND VPWR VPWR sky130_fd_sc_hd__decap_3
XFILLER_0_51_176 VPWR VGND VPWR VGND sky130_ef_sc_hd__decap_12
XFILLER_0_51_143 VGND VGND VPWR VPWR sky130_fd_sc_hd__decap_8
XFILLER_0_24_313 VPWR VGND VPWR VGND sky130_ef_sc_hd__decap_12
X_4020_ _1828_ _1107_ _1108_ VGND VGND VPWR VPWR _1109_ sky130_fd_sc_hd__and3_1
X_2350_ net31 VGND VGND VPWR VPWR _1456_ sky130_fd_sc_hd__buf_2
X_2281_ _1381_ _1293_ _1386_ VGND VGND VPWR VPWR _1387_ sky130_fd_sc_hd__a21oi_4
XFILLER_0_19_43 VPWR VGND VPWR VGND sky130_ef_sc_hd__decap_12
XFILLER_0_19_98 VGND VGND VPWR VPWR sky130_fd_sc_hd__fill_1
XFILLER_0_59_298 VPWR VGND VPWR VGND sky130_ef_sc_hd__decap_12
XFILLER_0_35_53 VGND VGND VPWR VPWR sky130_fd_sc_hd__decap_3
XFILLER_0_35_20 VPWR VGND VPWR VGND sky130_ef_sc_hd__decap_12
XFILLER_0_19_107 VGND VGND VPWR VPWR sky130_fd_sc_hd__decap_4
XFILLER_0_51_63 VGND VGND VPWR VPWR sky130_fd_sc_hd__fill_1
X_3804_ _0571_ _0070_ VGND VGND VPWR VPWR _0878_ sky130_fd_sc_hd__nand2_1
XFILLER_0_27_195 VGND VGND VPWR VPWR sky130_fd_sc_hd__decap_6
X_3735_ _1769_ _1125_ _0802_ _0803_ _1545_ VGND VGND VPWR VPWR _0805_ sky130_fd_sc_hd__o311a_1
XTAP_TAPCELL_ROW_15_271 VGND VPWR sky130_fd_sc_hd__tapvpwrvgnd_1
XFILLER_0_15_335 VGND VGND VPWR VPWR sky130_fd_sc_hd__fill_1
XFILLER_0_62_3 VGND VGND VPWR VPWR sky130_fd_sc_hd__decap_6
X_3597_ _1970_ _1582_ _1374_ _1597_ VGND VGND VPWR VPWR _0657_ sky130_fd_sc_hd__or4_1
X_3666_ _0024_ _1651_ _1703_ VGND VGND VPWR VPWR _0731_ sky130_fd_sc_hd__o21ai_4
XFILLER_0_23_390 VGND VGND VPWR VPWR sky130_fd_sc_hd__fill_2
X_2617_ _1562_ _1468_ _1616_ VGND VGND VPWR VPWR _1723_ sky130_fd_sc_hd__a21o_1
X_2548_ _1653_ VGND VGND VPWR VPWR _1654_ sky130_fd_sc_hd__clkbuf_4
X_4218_ clknet_2_2__leaf_clk _2090_ net122 VGND VGND VPWR VPWR net74 sky130_fd_sc_hd__dfrtp_1
XTAP_TAPCELL_ROW_66_650 VGND VPWR sky130_fd_sc_hd__tapvpwrvgnd_1
X_4149_ _1237_ _1239_ _1241_ _1247_ VGND VGND VPWR VPWR _2072_ sky130_fd_sc_hd__nand4_1
X_2479_ _1301_ VGND VGND VPWR VPWR _1585_ sky130_fd_sc_hd__buf_4
XFILLER_0_18_162 VGND VGND VPWR VPWR sky130_fd_sc_hd__decap_4
Xclkload0 clknet_2_1__leaf_clk VGND VGND VPWR VPWR clkload0/Y sky130_fd_sc_hd__bufinv_16
XFILLER_0_33_154 VPWR VGND VPWR VGND sky130_ef_sc_hd__decap_12
XFILLER_0_14_390 VGND VGND VPWR VPWR sky130_fd_sc_hd__decap_4
XFILLER_0_72_29 VPWR VGND VPWR VGND sky130_ef_sc_hd__decap_12
XFILLER_0_29_405 VGND VGND VPWR VPWR sky130_fd_sc_hd__decap_3
XTAP_TAPCELL_ROW_29_374 VGND VPWR sky130_fd_sc_hd__tapvpwrvgnd_1
XTAP_TAPCELL_ROW_72_697 VGND VPWR sky130_fd_sc_hd__tapvpwrvgnd_1
XFILLER_0_44_419 VGND VGND VPWR VPWR sky130_fd_sc_hd__fill_1
X_3520_ _1559_ _0553_ VGND VGND VPWR VPWR _0574_ sky130_fd_sc_hd__or2_1
XFILLER_0_21_55 VGND VGND VPWR VPWR sky130_fd_sc_hd__fill_1
XFILLER_0_21_11 VGND VGND VPWR VPWR sky130_fd_sc_hd__fill_2
XTAP_TAPCELL_ROW_12_252 VGND VPWR sky130_fd_sc_hd__tapvpwrvgnd_1
X_2402_ _1500_ _1504_ _1505_ _1507_ VGND VGND VPWR VPWR _1508_ sky130_fd_sc_hd__o211ai_4
X_2333_ _1438_ VGND VGND VPWR VPWR _1439_ sky130_fd_sc_hd__clkbuf_4
X_3382_ _0365_ _0366_ _0424_ VGND VGND VPWR VPWR _2069_ sky130_fd_sc_hd__o21ai_1
X_3451_ _0496_ _1967_ _0498_ VGND VGND VPWR VPWR _0499_ sky130_fd_sc_hd__a21oi_1
XFILLER_0_46_85 VGND VGND VPWR VPWR sky130_fd_sc_hd__fill_2
X_4003_ _1090_ _1089_ _1545_ VGND VGND VPWR VPWR _1091_ sky130_fd_sc_hd__o21ai_1
XFILLER_0_34_7 VGND VGND VPWR VPWR sky130_fd_sc_hd__decap_3
X_2195_ net44 VGND VGND VPWR VPWR _1301_ sky130_fd_sc_hd__buf_4
X_2264_ net44 _1302_ VGND VGND VPWR VPWR _1370_ sky130_fd_sc_hd__and2b_1
XTAP_TAPCELL_ROW_63_631 VGND VPWR sky130_fd_sc_hd__tapvpwrvgnd_1
XFILLER_0_47_235 VGND VGND VPWR VPWR sky130_fd_sc_hd__fill_1
XFILLER_0_47_213 VGND VGND VPWR VPWR sky130_fd_sc_hd__decap_3
XFILLER_0_62_227 VGND VGND VPWR VPWR sky130_fd_sc_hd__decap_4
XFILLER_0_30_135 VGND VGND VPWR VPWR sky130_fd_sc_hd__fill_1
X_3649_ _0707_ _0147_ _0132_ _0712_ VGND VGND VPWR VPWR _0713_ sky130_fd_sc_hd__o2bb2a_1
XFILLER_0_7_376 VGND VGND VPWR VPWR sky130_fd_sc_hd__decap_6
X_3718_ _0754_ _0736_ _1146_ VGND VGND VPWR VPWR _0787_ sky130_fd_sc_hd__a21oi_1
XFILLER_0_11_393 VGND VGND VPWR VPWR sky130_fd_sc_hd__decap_4
XFILLER_0_38_213 VGND VGND VPWR VPWR sky130_fd_sc_hd__decap_8
XTAP_TAPCELL_ROW_26_355 VGND VPWR sky130_fd_sc_hd__tapvpwrvgnd_1
XANTENNA_9 _0324_ VGND VGND VPWR VPWR sky130_fd_sc_hd__diode_2
XFILLER_0_21_113 VGND VGND VPWR VPWR sky130_fd_sc_hd__decap_8
XFILLER_0_69_382 VGND VGND VPWR VPWR sky130_fd_sc_hd__decap_8
XTAP_TAPCELL_ROW_60_612 VGND VPWR sky130_fd_sc_hd__tapvpwrvgnd_1
XFILLER_0_44_205 VGND VGND VPWR VPWR sky130_fd_sc_hd__decap_8
XFILLER_0_29_279 VGND VGND VPWR VPWR sky130_fd_sc_hd__fill_1
XFILLER_0_8_118 VGND VGND VPWR VPWR sky130_fd_sc_hd__fill_1
X_2951_ _1837_ _1847_ _1835_ _1839_ _1629_ _1972_ VGND VGND VPWR VPWR _2054_ sky130_fd_sc_hd__mux4_2
X_2882_ _1985_ VGND VGND VPWR VPWR _1986_ sky130_fd_sc_hd__clkbuf_4
XFILLER_0_52_271 VGND VGND VPWR VPWR sky130_fd_sc_hd__fill_1
XFILLER_0_4_357 VGND VGND VPWR VPWR sky130_fd_sc_hd__fill_1
X_3503_ _0333_ _0383_ _0470_ _1426_ VGND VGND VPWR VPWR _0555_ sky130_fd_sc_hd__o31a_1
X_3434_ _0425_ _0430_ _0477_ _0480_ VGND VGND VPWR VPWR _2080_ sky130_fd_sc_hd__a211o_1
X_2316_ _1421_ VGND VGND VPWR VPWR _1422_ sky130_fd_sc_hd__clkbuf_4
X_3365_ _1315_ _1308_ _1693_ VGND VGND VPWR VPWR _0407_ sky130_fd_sc_hd__and3_1
X_3296_ _1983_ _0333_ VGND VGND VPWR VPWR _0334_ sky130_fd_sc_hd__nand2_1
X_2247_ net57 _1316_ VGND VGND VPWR VPWR _1353_ sky130_fd_sc_hd__nor2_4
XFILLER_0_25_3 VGND VGND VPWR VPWR sky130_fd_sc_hd__decap_8
X_2178_ _1275_ VGND VGND VPWR VPWR _1284_ sky130_fd_sc_hd__buf_2
XFILLER_0_35_238 VGND VGND VPWR VPWR sky130_fd_sc_hd__decap_4
XFILLER_0_43_293 VPWR VGND VPWR VGND sky130_ef_sc_hd__decap_12
XTAP_TAPCELL_ROW_31_391 VGND VPWR sky130_fd_sc_hd__tapvpwrvgnd_1
Xoutput79 net79 VGND VGND VPWR VPWR result[13] sky130_fd_sc_hd__buf_2
XFILLER_0_66_363 VGND VGND VPWR VPWR sky130_fd_sc_hd__fill_1
XFILLER_0_66_341 VGND VGND VPWR VPWR sky130_fd_sc_hd__decap_6
XPHY_EDGE_ROW_19_Right_19 VGND VGND VPWR VPWR sky130_fd_sc_hd__decap_3
X_3150_ _0190_ _1592_ _0192_ VGND VGND VPWR VPWR _0193_ sky130_fd_sc_hd__a21oi_1
XPHY_EDGE_ROW_28_Right_28 VGND VGND VPWR VPWR sky130_fd_sc_hd__decap_3
X_3081_ _1477_ _0123_ _0124_ _0125_ VGND VGND VPWR VPWR _0126_ sky130_fd_sc_hd__nand4b_4
X_2101_ net16 _0449_ VGND VGND VPWR VPWR _0460_ sky130_fd_sc_hd__or2b_1
XPHY_EDGE_ROW_37_Right_37 VGND VGND VPWR VPWR sky130_fd_sc_hd__decap_3
XTAP_TAPCELL_ROW_37_439 VGND VPWR sky130_fd_sc_hd__tapvpwrvgnd_1
X_2865_ net22 VGND VGND VPWR VPWR _1969_ sky130_fd_sc_hd__clkbuf_4
XTAP_TAPCELL_ROW_45_494 VGND VPWR sky130_fd_sc_hd__tapvpwrvgnd_1
X_3983_ _1716_ _1314_ _1422_ _1069_ VGND VGND VPWR VPWR _1070_ sky130_fd_sc_hd__a31o_1
X_2934_ _2037_ VGND VGND VPWR VPWR _2038_ sky130_fd_sc_hd__buf_4
XFILLER_0_17_249 VGND VGND VPWR VPWR sky130_fd_sc_hd__fill_1
XTAP_TAPCELL_ROW_20_306 VGND VPWR sky130_fd_sc_hd__tapvpwrvgnd_1
XPHY_EDGE_ROW_46_Right_46 VGND VGND VPWR VPWR sky130_fd_sc_hd__decap_3
X_2796_ _1849_ _1847_ _1658_ VGND VGND VPWR VPWR _1901_ sky130_fd_sc_hd__mux2_1
XFILLER_0_40_230 VGND VGND VPWR VPWR sky130_fd_sc_hd__decap_8
XFILLER_0_25_293 VPWR VGND VPWR VGND sky130_ef_sc_hd__decap_12
XFILLER_0_4_165 VGND VGND VPWR VPWR sky130_fd_sc_hd__fill_2
XFILLER_0_7_53 VGND VGND VPWR VPWR sky130_fd_sc_hd__decap_3
XPHY_EDGE_ROW_55_Right_55 VGND VGND VPWR VPWR sky130_fd_sc_hd__decap_3
X_3279_ _1577_ _1472_ _1623_ VGND VGND VPWR VPWR _0317_ sky130_fd_sc_hd__o21ai_1
XFILLER_0_0_393 VGND VGND VPWR VPWR sky130_fd_sc_hd__fill_2
X_3417_ _1753_ _1750_ _1799_ _1801_ VGND VGND VPWR VPWR _0463_ sky130_fd_sc_hd__o2bb2a_1
X_3348_ _1604_ _0377_ _0387_ VGND VGND VPWR VPWR _0388_ sky130_fd_sc_hd__o21a_1
XFILLER_0_48_352 VPWR VGND VPWR VGND sky130_ef_sc_hd__decap_12
XPHY_EDGE_ROW_64_Right_64 VGND VGND VPWR VPWR sky130_fd_sc_hd__decap_3
XFILLER_0_31_274 VGND VGND VPWR VPWR sky130_fd_sc_hd__decap_6
XPHY_EDGE_ROW_73_Right_73 VGND VGND VPWR VPWR sky130_fd_sc_hd__decap_3
XTAP_TAPCELL_ROW_42_475 VGND VPWR sky130_fd_sc_hd__tapvpwrvgnd_1
XFILLER_0_6_419 VGND VGND VPWR VPWR sky130_fd_sc_hd__fill_1
XFILLER_0_13_23 VGND VGND VPWR VPWR sky130_fd_sc_hd__decap_3
X_2581_ _1423_ net49 _1676_ _1680_ _1686_ VGND VGND VPWR VPWR _1687_ sky130_fd_sc_hd__o311a_1
X_2650_ _1264_ _1284_ VGND VGND VPWR VPWR _1756_ sky130_fd_sc_hd__nor2_1
XFILLER_0_1_157 VGND VGND VPWR VPWR sky130_fd_sc_hd__decap_4
XFILLER_0_10_403 VGND VGND VPWR VPWR sky130_fd_sc_hd__fill_1
X_3133_ _0174_ _2026_ _0176_ VGND VGND VPWR VPWR _0177_ sky130_fd_sc_hd__or3_1
X_4182_ _1259_ _1260_ _1261_ _1262_ _1282_ VGND VGND VPWR VPWR _1283_ sky130_fd_sc_hd__o221a_1
XFILLER_0_59_9 VGND VGND VPWR VPWR sky130_fd_sc_hd__fill_1
X_3202_ _1474_ _1475_ _1471_ _1472_ _1877_ _1970_ VGND VGND VPWR VPWR _0244_ sky130_fd_sc_hd__mux4_1
XFILLER_0_54_85 VGND VGND VPWR VPWR sky130_fd_sc_hd__decap_4
X_3064_ _1570_ _1479_ _1712_ VGND VGND VPWR VPWR _0109_ sky130_fd_sc_hd__o21ai_1
XFILLER_0_9_213 VGND VGND VPWR VPWR sky130_fd_sc_hd__decap_8
XFILLER_0_72_141 VGND VGND VPWR VPWR sky130_fd_sc_hd__decap_3
X_2848_ _1951_ _0965_ _1823_ VGND VGND VPWR VPWR _1952_ sky130_fd_sc_hd__a21oi_1
X_2917_ _1692_ _2001_ _2008_ _2020_ VGND VGND VPWR VPWR _2021_ sky130_fd_sc_hd__o211a_1
XFILLER_0_45_388 VGND VGND VPWR VPWR sky130_fd_sc_hd__decap_4
X_3966_ _0600_ _0349_ _1666_ _1785_ _0151_ VGND VGND VPWR VPWR _1052_ sky130_fd_sc_hd__a221o_1
X_3897_ _0939_ _1471_ _0872_ _0889_ VGND VGND VPWR VPWR _0978_ sky130_fd_sc_hd__or4_1
X_2779_ _1436_ _1432_ _1538_ _1549_ VGND VGND VPWR VPWR _1884_ sky130_fd_sc_hd__nand4_4
XFILLER_0_0_9 VGND VGND VPWR VPWR sky130_fd_sc_hd__fill_1
XTAP_TAPCELL_ROW_56_578 VGND VPWR sky130_fd_sc_hd__tapvpwrvgnd_1
XTAP_TAPCELL_ROW_47_512 VGND VPWR sky130_fd_sc_hd__tapvpwrvgnd_1
XFILLER_0_24_44 VGND VGND VPWR VPWR sky130_fd_sc_hd__decap_3
X_2702_ _1424_ _1484_ _1487_ VGND VGND VPWR VPWR _1807_ sky130_fd_sc_hd__o21a_1
X_3820_ _0894_ _0132_ _0895_ VGND VGND VPWR VPWR _0896_ sky130_fd_sc_hd__a21o_1
XFILLER_0_40_65 VGND VGND VPWR VPWR sky130_fd_sc_hd__decap_6
X_3682_ _1514_ _1373_ _1375_ _1367_ VGND VGND VPWR VPWR _0748_ sky130_fd_sc_hd__a31o_1
XFILLER_0_6_205 VPWR VGND VPWR VGND sky130_ef_sc_hd__decap_12
X_3751_ _1469_ _1928_ _0818_ _0821_ VGND VGND VPWR VPWR _0822_ sky130_fd_sc_hd__a211oi_2
X_2495_ _1599_ net18 _1600_ VGND VGND VPWR VPWR _1601_ sky130_fd_sc_hd__o21bai_2
XFILLER_0_49_96 VGND VGND VPWR VPWR sky130_fd_sc_hd__decap_3
XFILLER_0_42_369 VGND VGND VPWR VPWR sky130_fd_sc_hd__fill_1
X_2564_ _1669_ VGND VGND VPWR VPWR _1670_ sky130_fd_sc_hd__clkbuf_4
XFILLER_0_2_433 VGND VGND VPWR VPWR sky130_fd_sc_hd__decap_4
X_2633_ net37 net5 VGND VGND VPWR VPWR _1739_ sky130_fd_sc_hd__and2_1
XFILLER_0_10_222 VPWR VGND VPWR VGND sky130_ef_sc_hd__decap_12
X_4096_ _1186_ _1188_ _1190_ VGND VGND VPWR VPWR _1191_ sky130_fd_sc_hd__and3_1
X_4165_ _0433_ _0247_ _1830_ VGND VGND VPWR VPWR _1265_ sky130_fd_sc_hd__o21a_1
X_3116_ _1900_ _1901_ _0159_ VGND VGND VPWR VPWR _0160_ sky130_fd_sc_hd__a21oi_1
XFILLER_0_4_76 VGND VGND VPWR VPWR sky130_fd_sc_hd__decap_8
XTAP_TAPCELL_ROW_53_559 VGND VPWR sky130_fd_sc_hd__tapvpwrvgnd_1
X_3047_ _2017_ VGND VGND VPWR VPWR _0092_ sky130_fd_sc_hd__clkbuf_4
XTAP_TAPCELL_ROW_18_291 VGND VPWR sky130_fd_sc_hd__tapvpwrvgnd_1
XFILLER_0_45_141 VGND VGND VPWR VPWR sky130_fd_sc_hd__fill_1
X_3949_ _1558_ _1020_ _1031_ _1033_ _0559_ VGND VGND VPWR VPWR _1034_ sky130_fd_sc_hd__o2111a_1
XFILLER_0_33_358 VGND VGND VPWR VPWR sky130_fd_sc_hd__fill_2
XFILLER_0_5_260 VPWR VGND VPWR VGND sky130_ef_sc_hd__decap_12
XFILLER_0_5_293 VGND VGND VPWR VPWR sky130_fd_sc_hd__decap_8
XFILLER_0_18_377 VPWR VGND VPWR VGND sky130_ef_sc_hd__decap_12
XFILLER_0_68_222 VPWR VGND VPWR VGND sky130_ef_sc_hd__decap_12
XFILLER_0_56_406 VPWR VGND VPWR VGND sky130_ef_sc_hd__decap_12
XFILLER_0_24_325 VGND VGND VPWR VPWR sky130_fd_sc_hd__decap_6
XFILLER_0_51_188 VGND VGND VPWR VPWR sky130_fd_sc_hd__decap_8
XFILLER_0_24_347 VPWR VGND VPWR VGND sky130_ef_sc_hd__decap_12
XFILLER_0_35_32 VGND VGND VPWR VPWR sky130_fd_sc_hd__decap_3
X_2280_ _1382_ _1385_ _1383_ VGND VGND VPWR VPWR _1386_ sky130_fd_sc_hd__o21ai_2
XFILLER_0_19_55 VGND VGND VPWR VPWR sky130_fd_sc_hd__fill_1
XFILLER_0_19_88 VGND VGND VPWR VPWR sky130_fd_sc_hd__fill_1
X_3803_ _0596_ _0103_ _0105_ _1830_ VGND VGND VPWR VPWR _0877_ sky130_fd_sc_hd__o211a_1
XFILLER_0_42_155 VGND VGND VPWR VPWR sky130_fd_sc_hd__fill_1
XFILLER_0_30_317 VGND VGND VPWR VPWR sky130_fd_sc_hd__fill_1
X_3665_ _0245_ _1938_ _1439_ VGND VGND VPWR VPWR _0730_ sky130_fd_sc_hd__o21ai_1
X_3734_ _1125_ _0802_ _1769_ VGND VGND VPWR VPWR _0803_ sky130_fd_sc_hd__o21ai_1
X_2616_ _1621_ _1472_ _1619_ VGND VGND VPWR VPWR _1722_ sky130_fd_sc_hd__o21a_1
XTAP_TAPCELL_ROW_15_272 VGND VPWR sky130_fd_sc_hd__tapvpwrvgnd_1
X_4217_ clknet_2_2__leaf_clk _2091_ net122 VGND VGND VPWR VPWR net72 sky130_fd_sc_hd__dfrtp_1
XFILLER_0_55_3 VGND VGND VPWR VPWR sky130_fd_sc_hd__decap_6
X_3596_ _0655_ _1761_ _1364_ _1365_ VGND VGND VPWR VPWR _0656_ sky130_fd_sc_hd__o211a_1
X_2547_ net33 net44 VGND VGND VPWR VPWR _1653_ sky130_fd_sc_hd__or2b_1
X_2478_ _1565_ _1569_ _1574_ _1579_ _1581_ _1583_ VGND VGND VPWR VPWR _1584_ sky130_fd_sc_hd__mux4_2
XTAP_TAPCELL_ROW_66_651 VGND VPWR sky130_fd_sc_hd__tapvpwrvgnd_1
X_4148_ _1543_ _1821_ _1244_ _1246_ VGND VGND VPWR VPWR _1247_ sky130_fd_sc_hd__o211ai_1
X_4079_ _1480_ _1171_ _1172_ VGND VGND VPWR VPWR _1173_ sky130_fd_sc_hd__a21o_1
Xclkload1 clknet_2_2__leaf_clk VGND VGND VPWR VPWR clkload1/Y sky130_fd_sc_hd__clkinv_4
XFILLER_0_18_141 VGND VGND VPWR VPWR sky130_fd_sc_hd__fill_2
XFILLER_0_33_166 VGND VGND VPWR VPWR sky130_fd_sc_hd__fill_2
XFILLER_0_21_317 VGND VGND VPWR VPWR sky130_fd_sc_hd__fill_1
XTAP_TAPCELL_ROW_72_698 VGND VPWR sky130_fd_sc_hd__tapvpwrvgnd_1
XFILLER_0_29_428 VGND VGND VPWR VPWR sky130_fd_sc_hd__decap_4
XTAP_TAPCELL_ROW_29_375 VGND VPWR sky130_fd_sc_hd__tapvpwrvgnd_1
XFILLER_0_24_188 VGND VGND VPWR VPWR sky130_fd_sc_hd__decap_4
X_2401_ _1339_ _1501_ _1503_ _1506_ VGND VGND VPWR VPWR _1507_ sky130_fd_sc_hd__or4b_2
X_2332_ _1433_ _1435_ _1437_ VGND VGND VPWR VPWR _1438_ sky130_fd_sc_hd__and3b_1
X_3381_ _0367_ _0368_ _0382_ _0423_ VGND VGND VPWR VPWR _0424_ sky130_fd_sc_hd__o211a_1
X_3450_ _1970_ _0377_ _0497_ _1629_ VGND VGND VPWR VPWR _0498_ sky130_fd_sc_hd__o211a_1
XFILLER_0_20_394 VGND VGND VPWR VPWR sky130_fd_sc_hd__decap_6
X_4002_ _1784_ _1080_ VGND VGND VPWR VPWR _1090_ sky130_fd_sc_hd__nand2_1
X_2194_ _1295_ _1297_ _1298_ _1299_ VGND VGND VPWR VPWR _1300_ sky130_fd_sc_hd__o22a_2
X_2263_ net1 _1305_ VGND VGND VPWR VPWR _1369_ sky130_fd_sc_hd__and2b_2
XFILLER_0_1_55 VGND VGND VPWR VPWR sky130_fd_sc_hd__fill_1
XTAP_TAPCELL_ROW_63_632 VGND VPWR sky130_fd_sc_hd__tapvpwrvgnd_1
XFILLER_0_62_85 VPWR VGND VPWR VGND sky130_ef_sc_hd__decap_12
XFILLER_0_47_225 VGND VGND VPWR VPWR sky130_fd_sc_hd__decap_6
XFILLER_0_55_291 VGND VGND VPWR VPWR sky130_fd_sc_hd__decap_4
X_3717_ _1899_ _0781_ _0771_ _1914_ _0785_ VGND VGND VPWR VPWR _0786_ sky130_fd_sc_hd__a221oi_1
X_3648_ _0711_ _0702_ _0147_ VGND VGND VPWR VPWR _0712_ sky130_fd_sc_hd__o21ai_1
X_3579_ net61 _0304_ _0636_ VGND VGND VPWR VPWR _0637_ sky130_fd_sc_hd__o21ai_1
XFILLER_0_15_177 VGND VGND VPWR VPWR sky130_fd_sc_hd__decap_3
XFILLER_0_15_188 VPWR VGND VPWR VGND sky130_ef_sc_hd__decap_12
XTAP_TAPCELL_ROW_26_356 VGND VPWR sky130_fd_sc_hd__tapvpwrvgnd_1
XFILLER_0_53_217 VGND VGND VPWR VPWR sky130_fd_sc_hd__decap_6
XFILLER_0_21_169 VGND VGND VPWR VPWR sky130_fd_sc_hd__fill_2
XFILLER_0_69_361 VPWR VGND VPWR VGND sky130_ef_sc_hd__decap_12
XFILLER_0_32_33 VGND VGND VPWR VPWR sky130_fd_sc_hd__fill_1
X_2950_ _1842_ VGND VGND VPWR VPWR _2053_ sky130_fd_sc_hd__buf_2
X_2881_ _1642_ VGND VGND VPWR VPWR _1985_ sky130_fd_sc_hd__buf_2
X_3502_ _0032_ _0208_ _0403_ _0553_ VGND VGND VPWR VPWR _0554_ sky130_fd_sc_hd__or4_1
X_3433_ _0383_ _0426_ _0478_ _0479_ VGND VGND VPWR VPWR _0480_ sky130_fd_sc_hd__o211a_1
X_2246_ _0965_ _0911_ _1346_ _1351_ VGND VGND VPWR VPWR _1352_ sky130_fd_sc_hd__a31oi_2
X_2315_ _1420_ VGND VGND VPWR VPWR _1421_ sky130_fd_sc_hd__clkbuf_4
XFILLER_0_57_30 VPWR VGND VPWR VGND sky130_ef_sc_hd__decap_12
X_3364_ _0404_ _1307_ VGND VGND VPWR VPWR _0405_ sky130_fd_sc_hd__xnor2_1
X_3295_ _1459_ VGND VGND VPWR VPWR _0333_ sky130_fd_sc_hd__buf_2
X_2177_ net60 net28 VGND VGND VPWR VPWR _1275_ sky130_fd_sc_hd__and2_1
XTAP_TAPCELL_ROW_31_392 VGND VPWR sky130_fd_sc_hd__tapvpwrvgnd_1
X_3080_ _1946_ _2048_ VGND VGND VPWR VPWR _0125_ sky130_fd_sc_hd__nor2_1
X_2100_ net48 VGND VGND VPWR VPWR _0449_ sky130_fd_sc_hd__buf_2
XFILLER_0_57_320 VPWR VGND VPWR VGND sky130_ef_sc_hd__decap_12
X_3982_ net41 _1444_ _1447_ VGND VGND VPWR VPWR _1069_ sky130_fd_sc_hd__o21ai_1
X_2864_ net21 VGND VGND VPWR VPWR _1968_ sky130_fd_sc_hd__buf_2
XTAP_TAPCELL_ROW_45_495 VGND VPWR sky130_fd_sc_hd__tapvpwrvgnd_1
X_2795_ _1700_ VGND VGND VPWR VPWR _1900_ sky130_fd_sc_hd__clkbuf_4
XTAP_TAPCELL_ROW_20_307 VGND VPWR sky130_fd_sc_hd__tapvpwrvgnd_1
X_2933_ _1539_ net117 _1800_ VGND VGND VPWR VPWR _2037_ sky130_fd_sc_hd__a21oi_4
XFILLER_0_40_253 VGND VGND VPWR VPWR sky130_fd_sc_hd__decap_8
X_3416_ _1659_ _1892_ _1644_ _1998_ VGND VGND VPWR VPWR _0462_ sky130_fd_sc_hd__or4b_2
X_2229_ net46 net14 VGND VGND VPWR VPWR _1335_ sky130_fd_sc_hd__or2b_1
X_3278_ _1654_ _1656_ _0315_ VGND VGND VPWR VPWR _0316_ sky130_fd_sc_hd__a21o_1
X_3347_ _1877_ _1455_ _1846_ _1627_ VGND VGND VPWR VPWR _0387_ sky130_fd_sc_hd__o211ai_1
XFILLER_0_48_386 VPWR VGND VPWR VGND sky130_ef_sc_hd__decap_12
XFILLER_0_63_356 VGND VGND VPWR VPWR sky130_fd_sc_hd__fill_2
XFILLER_0_63_323 VGND VGND VPWR VPWR sky130_fd_sc_hd__decap_4
XFILLER_0_31_220 VGND VGND VPWR VPWR sky130_fd_sc_hd__decap_4
XFILLER_0_7_3 VPWR VGND VPWR VGND sky130_ef_sc_hd__decap_12
XTAP_TAPCELL_ROW_59_598 VGND VPWR sky130_fd_sc_hd__tapvpwrvgnd_1
XFILLER_0_73_109 VGND VGND VPWR VPWR sky130_fd_sc_hd__decap_3
XFILLER_0_54_378 VGND VGND VPWR VPWR sky130_fd_sc_hd__decap_4
XFILLER_0_54_301 VGND VGND VPWR VPWR sky130_fd_sc_hd__decap_6
XTAP_TAPCELL_ROW_42_476 VGND VPWR sky130_fd_sc_hd__tapvpwrvgnd_1
XFILLER_0_13_57 VGND VGND VPWR VPWR sky130_fd_sc_hd__fill_2
XFILLER_0_14_209 VGND VGND VPWR VPWR sky130_fd_sc_hd__decap_8
X_2580_ _1681_ _1682_ _1684_ _1685_ VGND VGND VPWR VPWR _1686_ sky130_fd_sc_hd__o211a_1
XPHY_EDGE_ROW_26_Left_100 VGND VGND VPWR VPWR sky130_fd_sc_hd__decap_3
XFILLER_0_22_253 VGND VGND VPWR VPWR sky130_fd_sc_hd__decap_3
XFILLER_0_22_231 VGND VGND VPWR VPWR sky130_fd_sc_hd__decap_8
XFILLER_0_1_136 VPWR VGND VPWR VGND sky130_ef_sc_hd__decap_12
XFILLER_0_1_169 VPWR VGND VPWR VGND sky130_ef_sc_hd__decap_12
X_3132_ _1317_ _0175_ _1357_ VGND VGND VPWR VPWR _0176_ sky130_fd_sc_hd__o21a_1
X_4181_ _0983_ _1266_ _1281_ VGND VGND VPWR VPWR _1282_ sky130_fd_sc_hd__a21oi_2
X_3201_ _1551_ VGND VGND VPWR VPWR _0243_ sky130_fd_sc_hd__clkbuf_4
X_3063_ _1954_ _0103_ _0105_ _0107_ VGND VGND VPWR VPWR _0108_ sky130_fd_sc_hd__o211ai_1
XFILLER_0_70_41 VGND VGND VPWR VPWR sky130_fd_sc_hd__decap_8
X_3965_ net41 _1922_ _0353_ _0579_ _1049_ VGND VGND VPWR VPWR _1051_ sky130_fd_sc_hd__a221o_1
XFILLER_0_9_236 VGND VGND VPWR VPWR sky130_fd_sc_hd__decap_8
XFILLER_0_72_197 VPWR VGND VPWR VGND sky130_ef_sc_hd__decap_12
XFILLER_0_70_85 VGND VGND VPWR VPWR sky130_fd_sc_hd__decap_8
X_2847_ _1818_ _1323_ _1496_ _1950_ VGND VGND VPWR VPWR _1951_ sky130_fd_sc_hd__a31o_1
X_2916_ _1685_ _2016_ _2019_ VGND VGND VPWR VPWR _2020_ sky130_fd_sc_hd__and3_1
X_2778_ _1876_ _1879_ _1882_ VGND VGND VPWR VPWR _1883_ sky130_fd_sc_hd__o21bai_2
X_3896_ _0968_ _0970_ _0974_ _0977_ VGND VGND VPWR VPWR _2063_ sky130_fd_sc_hd__nand4_1
XFILLER_0_13_242 VPWR VGND VPWR VGND sky130_ef_sc_hd__decap_12
XTAP_TAPCELL_ROW_56_579 VGND VPWR sky130_fd_sc_hd__tapvpwrvgnd_1
XFILLER_0_63_164 VGND VGND VPWR VPWR sky130_fd_sc_hd__decap_4
XFILLER_0_63_131 VGND VGND VPWR VPWR sky130_fd_sc_hd__fill_2
XFILLER_0_48_194 VGND VGND VPWR VPWR sky130_fd_sc_hd__fill_2
XFILLER_0_51_337 VGND VGND VPWR VPWR sky130_fd_sc_hd__decap_3
XFILLER_0_51_326 VGND VGND VPWR VPWR sky130_fd_sc_hd__decap_8
XTAP_TAPCELL_ROW_47_513 VGND VPWR sky130_fd_sc_hd__tapvpwrvgnd_1
XTAP_TAPCELL_ROW_4_190 VGND VPWR sky130_fd_sc_hd__tapvpwrvgnd_1
X_2701_ _1805_ VGND VGND VPWR VPWR _1806_ sky130_fd_sc_hd__clkbuf_4
X_2632_ _1692_ _1737_ VGND VGND VPWR VPWR _1738_ sky130_fd_sc_hd__or2_1
XFILLER_0_40_55 VGND VGND VPWR VPWR sky130_fd_sc_hd__fill_1
X_3681_ _1454_ _0633_ _1465_ _0245_ _1486_ VGND VGND VPWR VPWR _0747_ sky130_fd_sc_hd__o311a_1
XFILLER_0_6_217 VPWR VGND VPWR VGND sky130_ef_sc_hd__decap_12
X_3750_ _1157_ _0819_ _0151_ _1561_ _0820_ VGND VGND VPWR VPWR _0821_ sky130_fd_sc_hd__a221o_1
X_2494_ net17 _1575_ VGND VGND VPWR VPWR _1600_ sky130_fd_sc_hd__nor2_1
X_2563_ net68 net67 VGND VGND VPWR VPWR _1669_ sky130_fd_sc_hd__and2b_1
XFILLER_0_10_234 VGND VGND VPWR VPWR sky130_fd_sc_hd__decap_6
XFILLER_0_10_256 VPWR VGND VPWR VGND sky130_ef_sc_hd__decap_12
X_3046_ _1968_ VGND VGND VPWR VPWR _0091_ sky130_fd_sc_hd__buf_2
XFILLER_0_65_63 VGND VGND VPWR VPWR sky130_fd_sc_hd__decap_4
X_4164_ _0254_ _0433_ VGND VGND VPWR VPWR _1263_ sky130_fd_sc_hd__nand2_1
X_4095_ _1916_ _0603_ _0627_ _1032_ VGND VGND VPWR VPWR _1190_ sky130_fd_sc_hd__a22oi_1
X_3115_ _1721_ _1895_ VGND VGND VPWR VPWR _0159_ sky130_fd_sc_hd__nor2_2
X_3948_ _1032_ _0331_ VGND VGND VPWR VPWR _1033_ sky130_fd_sc_hd__nand2_1
XTAP_TAPCELL_ROW_18_292 VGND VPWR sky130_fd_sc_hd__tapvpwrvgnd_1
XFILLER_0_60_178 VPWR VGND VPWR VGND sky130_ef_sc_hd__decap_12
X_3879_ _0242_ _0403_ _0207_ _0953_ _0958_ VGND VGND VPWR VPWR _0959_ sky130_fd_sc_hd__o311a_1
XFILLER_0_33_337 VGND VGND VPWR VPWR sky130_fd_sc_hd__decap_4
XFILLER_0_5_272 VGND VGND VPWR VPWR sky130_fd_sc_hd__decap_8
XFILLER_0_18_389 VGND VGND VPWR VPWR sky130_fd_sc_hd__decap_3
XFILLER_0_68_234 VGND VGND VPWR VPWR sky130_fd_sc_hd__decap_6
XFILLER_0_56_418 VGND VGND VPWR VPWR sky130_fd_sc_hd__fill_2
XFILLER_0_51_134 VGND VGND VPWR VPWR sky130_fd_sc_hd__fill_2
XFILLER_0_51_101 VGND VGND VPWR VPWR sky130_fd_sc_hd__decap_8
XFILLER_0_36_131 VGND VGND VPWR VPWR sky130_fd_sc_hd__decap_8
XFILLER_0_24_359 VGND VGND VPWR VPWR sky130_fd_sc_hd__decap_4
XFILLER_0_32_392 VPWR VGND VPWR VGND sky130_ef_sc_hd__decap_12
XFILLER_0_35_11 VGND VGND VPWR VPWR sky130_fd_sc_hd__fill_2
XFILLER_0_59_223 VGND VGND VPWR VPWR sky130_fd_sc_hd__fill_1
XFILLER_0_35_77 VPWR VGND VPWR VGND sky130_ef_sc_hd__decap_12
X_3802_ _0872_ _0426_ _0478_ _0875_ VGND VGND VPWR VPWR _0876_ sky130_fd_sc_hd__o211a_1
XTAP_TAPCELL_ROW_15_273 VGND VPWR sky130_fd_sc_hd__tapvpwrvgnd_1
XFILLER_0_70_421 VPWR VGND VPWR VGND sky130_ef_sc_hd__decap_12
XFILLER_0_42_178 VPWR VGND VPWR VGND sky130_ef_sc_hd__decap_12
XFILLER_0_42_145 VGND VGND VPWR VPWR sky130_fd_sc_hd__fill_1
X_2615_ _1699_ VGND VGND VPWR VPWR _1721_ sky130_fd_sc_hd__buf_2
X_3664_ _1397_ _0304_ VGND VGND VPWR VPWR _0728_ sky130_fd_sc_hd__nor2_1
X_3733_ _1104_ _1815_ _0801_ VGND VGND VPWR VPWR _0802_ sky130_fd_sc_hd__a21oi_1
X_3595_ _1755_ _0547_ _1756_ VGND VGND VPWR VPWR _0655_ sky130_fd_sc_hd__and3_1
X_4147_ _1506_ _1143_ _1209_ _1245_ VGND VGND VPWR VPWR _1246_ sky130_fd_sc_hd__o211ai_2
X_2477_ _1582_ VGND VGND VPWR VPWR _1583_ sky130_fd_sc_hd__clkbuf_4
XFILLER_0_48_3 VGND VGND VPWR VPWR sky130_fd_sc_hd__decap_8
X_4216_ clknet_2_1__leaf_clk _0000_ net124 VGND VGND VPWR VPWR net108 sky130_fd_sc_hd__dfrtp_1
X_2546_ _1647_ _1651_ _1551_ VGND VGND VPWR VPWR _1652_ sky130_fd_sc_hd__o21ai_4
XTAP_TAPCELL_ROW_7_208 VGND VPWR sky130_fd_sc_hd__tapvpwrvgnd_1
XTAP_TAPCELL_ROW_66_652 VGND VPWR sky130_fd_sc_hd__tapvpwrvgnd_1
X_4078_ _1480_ _1171_ _1810_ VGND VGND VPWR VPWR _1172_ sky130_fd_sc_hd__o21ai_1
X_3029_ _1880_ VGND VGND VPWR VPWR _0074_ sky130_fd_sc_hd__clkbuf_4
XFILLER_0_73_281 VGND VGND VPWR VPWR sky130_fd_sc_hd__fill_2
Xclkload2 clknet_2_3__leaf_clk VGND VGND VPWR VPWR clkload2/Y sky130_fd_sc_hd__clkinvlp_4
XFILLER_0_33_134 VPWR VGND VPWR VGND sky130_ef_sc_hd__decap_12
XTAP_TAPCELL_ROW_72_699 VGND VPWR sky130_fd_sc_hd__tapvpwrvgnd_1
XTAP_TAPCELL_ROW_29_376 VGND VPWR sky130_fd_sc_hd__tapvpwrvgnd_1
XFILLER_0_64_281 VPWR VGND VPWR VGND sky130_ef_sc_hd__decap_12
XFILLER_0_52_410 VGND VGND VPWR VPWR sky130_fd_sc_hd__decap_8
XFILLER_0_52_421 VGND VGND VPWR VPWR sky130_fd_sc_hd__decap_3
X_2400_ _1336_ _1337_ _1335_ VGND VGND VPWR VPWR _1506_ sky130_fd_sc_hd__o21ai_1
XFILLER_0_24_178 VGND VGND VPWR VPWR sky130_fd_sc_hd__fill_2
XFILLER_0_21_57 VPWR VGND VPWR VGND sky130_ef_sc_hd__decap_12
X_4001_ _0600_ _0632_ _1817_ _1499_ VGND VGND VPWR VPWR _1089_ sky130_fd_sc_hd__o31ai_2
X_2331_ _1436_ VGND VGND VPWR VPWR _1437_ sky130_fd_sc_hd__clkbuf_2
X_3380_ _0132_ _1867_ _0393_ _0401_ _0422_ VGND VGND VPWR VPWR _0423_ sky130_fd_sc_hd__a311oi_2
XFILLER_0_20_362 VGND VGND VPWR VPWR sky130_fd_sc_hd__fill_2
X_2262_ _1302_ _1301_ VGND VGND VPWR VPWR _1368_ sky130_fd_sc_hd__and2b_1
XTAP_TAPCELL_ROW_63_633 VGND VPWR sky130_fd_sc_hd__tapvpwrvgnd_1
XFILLER_0_62_42 VGND VGND VPWR VPWR sky130_fd_sc_hd__fill_2
X_2193_ net55 net23 VGND VGND VPWR VPWR _1299_ sky130_fd_sc_hd__and2_1
XFILLER_0_62_97 VPWR VGND VPWR VGND sky130_ef_sc_hd__decap_12
X_3716_ _0764_ _0782_ _0784_ VGND VGND VPWR VPWR _0785_ sky130_fd_sc_hd__o21ba_1
XFILLER_0_70_295 VGND VGND VPWR VPWR sky130_fd_sc_hd__fill_2
XFILLER_0_30_159 VGND VGND VPWR VPWR sky130_fd_sc_hd__fill_1
XFILLER_0_30_115 VGND VGND VPWR VPWR sky130_fd_sc_hd__fill_1
X_3647_ _1427_ _1648_ _0022_ _0142_ VGND VGND VPWR VPWR _0711_ sky130_fd_sc_hd__and4_1
X_3578_ _0633_ _1937_ _0428_ _0429_ VGND VGND VPWR VPWR _0636_ sky130_fd_sc_hd__o211a_1
X_2529_ net59 VGND VGND VPWR VPWR _1635_ sky130_fd_sc_hd__inv_2
XFILLER_0_11_373 VGND VGND VPWR VPWR sky130_fd_sc_hd__fill_2
XTAP_TAPCELL_ROW_26_357 VGND VPWR sky130_fd_sc_hd__tapvpwrvgnd_1
XFILLER_0_34_421 VPWR VGND VPWR VGND sky130_ef_sc_hd__decap_12
XFILLER_0_29_204 VPWR VGND VPWR VGND sky130_ef_sc_hd__decap_12
XFILLER_0_16_46 VGND VGND VPWR VPWR sky130_fd_sc_hd__decap_8
XFILLER_0_69_373 VGND VGND VPWR VPWR sky130_fd_sc_hd__decap_3
X_2880_ _1945_ _1805_ _1423_ _1450_ _1983_ _1972_ VGND VGND VPWR VPWR _1984_ sky130_fd_sc_hd__mux4_1
XFILLER_0_37_281 VGND VGND VPWR VPWR sky130_fd_sc_hd__decap_6
XFILLER_0_32_45 VGND VGND VPWR VPWR sky130_fd_sc_hd__fill_2
XFILLER_0_4_304 VGND VGND VPWR VPWR sky130_fd_sc_hd__decap_4
X_3501_ _0066_ _1892_ _0104_ _1629_ VGND VGND VPWR VPWR _0553_ sky130_fd_sc_hd__a22oi_2
X_3432_ _1313_ _1421_ _0324_ VGND VGND VPWR VPWR _0479_ sky130_fd_sc_hd__a21o_1
X_3363_ _1303_ _1304_ VGND VGND VPWR VPWR _0404_ sky130_fd_sc_hd__nor2_1
X_2245_ _0922_ net19 _1349_ _1350_ VGND VGND VPWR VPWR _1351_ sky130_fd_sc_hd__o31ai_1
XFILLER_0_57_42 VPWR VGND VPWR VGND sky130_ef_sc_hd__decap_12
X_2314_ _1317_ net57 _1419_ VGND VGND VPWR VPWR _1420_ sky130_fd_sc_hd__o21ai_1
X_3294_ _1913_ _1867_ _0036_ _0208_ VGND VGND VPWR VPWR _0332_ sky130_fd_sc_hd__o31a_1
X_2176_ net60 _1253_ VGND VGND VPWR VPWR _1264_ sky130_fd_sc_hd__nor2_4
XFILLER_0_73_85 VPWR VGND VPWR VGND sky130_ef_sc_hd__decap_12
XFILLER_0_73_41 VPWR VGND VPWR VGND sky130_ef_sc_hd__decap_12
XTAP_TAPCELL_ROW_31_393 VGND VPWR sky130_fd_sc_hd__tapvpwrvgnd_1
XFILLER_0_7_142 VGND VGND VPWR VPWR sky130_fd_sc_hd__fill_2
XFILLER_0_7_186 VGND VGND VPWR VPWR sky130_fd_sc_hd__decap_6
XFILLER_0_16_421 VGND VGND VPWR VPWR sky130_fd_sc_hd__decap_8
XPHY_EDGE_ROW_1_Right_1 VGND VGND VPWR VPWR sky130_fd_sc_hd__decap_3
X_2932_ _2035_ _1826_ _0943_ _0933_ VGND VGND VPWR VPWR _2036_ sky130_fd_sc_hd__o2bb2a_1
XFILLER_0_57_332 VGND VGND VPWR VPWR sky130_fd_sc_hd__decap_4
XTAP_TAPCELL_ROW_45_496 VGND VPWR sky130_fd_sc_hd__tapvpwrvgnd_1
XFILLER_0_43_66 VGND VGND VPWR VPWR sky130_fd_sc_hd__fill_2
X_3981_ net41 _1431_ _1067_ VGND VGND VPWR VPWR _1068_ sky130_fd_sc_hd__o21ai_1
XFILLER_0_9_429 VGND VGND VPWR VPWR sky130_fd_sc_hd__fill_2
XFILLER_0_57_398 VGND VGND VPWR VPWR sky130_fd_sc_hd__fill_1
X_2863_ _1588_ VGND VGND VPWR VPWR _1967_ sky130_fd_sc_hd__buf_4
XFILLER_0_40_210 VPWR VGND VPWR VGND sky130_ef_sc_hd__decap_12
X_2794_ _1704_ _1893_ _1898_ VGND VGND VPWR VPWR _1899_ sky130_fd_sc_hd__o21ai_2
XTAP_TAPCELL_ROW_20_308 VGND VPWR sky130_fd_sc_hd__tapvpwrvgnd_1
XFILLER_0_13_413 VGND VGND VPWR VPWR sky130_fd_sc_hd__decap_4
XFILLER_0_17_229 VGND VGND VPWR VPWR sky130_fd_sc_hd__decap_6
XFILLER_0_68_41 VGND VGND VPWR VPWR sky130_fd_sc_hd__fill_1
XFILLER_0_40_298 VGND VGND VPWR VPWR sky130_fd_sc_hd__fill_1
X_3415_ _1511_ _1512_ _0458_ _1822_ VGND VGND VPWR VPWR _0461_ sky130_fd_sc_hd__a31o_1
XFILLER_0_0_362 VGND VGND VPWR VPWR sky130_fd_sc_hd__fill_2
XFILLER_0_7_88 VGND VGND VPWR VPWR sky130_fd_sc_hd__fill_1
X_3346_ _1458_ _1456_ _1696_ _1453_ _1586_ _1694_ VGND VGND VPWR VPWR _0386_ sky130_fd_sc_hd__mux4_1
XPHY_EDGE_ROW_15_Left_89 VGND VGND VPWR VPWR sky130_fd_sc_hd__decap_3
X_2228_ _1327_ _0535_ _1328_ _1333_ _0503_ VGND VGND VPWR VPWR _1334_ sky130_fd_sc_hd__o221ai_2
XFILLER_0_30_3 VPWR VGND VPWR VGND sky130_ef_sc_hd__decap_12
X_3277_ _1576_ _1475_ _1625_ VGND VGND VPWR VPWR _0315_ sky130_fd_sc_hd__o21ai_2
X_2159_ _1018_ _1040_ _1061_ _1071_ VGND VGND VPWR VPWR _1082_ sky130_fd_sc_hd__nand4_1
XFILLER_0_48_398 VPWR VGND VPWR VGND sky130_ef_sc_hd__decap_12
XFILLER_0_48_365 VPWR VGND VPWR VGND sky130_ef_sc_hd__decap_12
XFILLER_0_48_332 VGND VGND VPWR VPWR sky130_fd_sc_hd__fill_1
XTAP_TAPCELL_ROW_36_430 VGND VPWR sky130_fd_sc_hd__tapvpwrvgnd_1
XTAP_TAPCELL_ROW_59_599 VGND VPWR sky130_fd_sc_hd__tapvpwrvgnd_1
XFILLER_0_54_324 VGND VGND VPWR VPWR sky130_fd_sc_hd__decap_8
XTAP_TAPCELL_ROW_42_477 VGND VPWR sky130_fd_sc_hd__tapvpwrvgnd_1
X_4180_ _0242_ _0712_ _1267_ _1277_ _1280_ VGND VGND VPWR VPWR _1281_ sky130_fd_sc_hd__o2111ai_2
X_3200_ _0208_ VGND VGND VPWR VPWR _0242_ sky130_fd_sc_hd__buf_4
XFILLER_0_22_221 VGND VGND VPWR VPWR sky130_fd_sc_hd__fill_2
XFILLER_0_1_104 VGND VGND VPWR VPWR sky130_fd_sc_hd__decap_8
XFILLER_0_1_126 VGND VGND VPWR VPWR sky130_fd_sc_hd__fill_2
XFILLER_0_1_148 VGND VGND VPWR VPWR sky130_fd_sc_hd__decap_3
XFILLER_0_10_416 VGND VGND VPWR VPWR sky130_fd_sc_hd__decap_4
X_3131_ _0091_ _0126_ VGND VGND VPWR VPWR _0175_ sky130_fd_sc_hd__nor2_1
XFILLER_0_54_54 VGND VGND VPWR VPWR sky130_fd_sc_hd__decap_3
X_3062_ _0106_ VGND VGND VPWR VPWR _0107_ sky130_fd_sc_hd__buf_2
XFILLER_0_72_121 VGND VGND VPWR VPWR sky130_fd_sc_hd__decap_8
X_2915_ _1946_ _2018_ VGND VGND VPWR VPWR _2019_ sky130_fd_sc_hd__or2_1
XFILLER_0_57_140 VPWR VGND VPWR VGND sky130_ef_sc_hd__decap_12
XFILLER_0_45_335 VGND VGND VPWR VPWR sky130_fd_sc_hd__fill_1
X_3964_ _0568_ _0001_ _1682_ _0579_ VGND VGND VPWR VPWR _1049_ sky130_fd_sc_hd__o22ai_1
X_3895_ _1029_ _0304_ _0975_ VGND VGND VPWR VPWR _0977_ sky130_fd_sc_hd__o21ai_1
XFILLER_0_72_187 VGND VGND VPWR VPWR sky130_fd_sc_hd__decap_8
XFILLER_0_72_165 VPWR VGND VPWR VGND sky130_ef_sc_hd__decap_12
XFILLER_0_70_97 VGND VGND VPWR VPWR sky130_fd_sc_hd__fill_1
X_2846_ _1322_ _1819_ VGND VGND VPWR VPWR _1950_ sky130_fd_sc_hd__or2_1
X_2777_ _1880_ _1873_ _1881_ _1699_ VGND VGND VPWR VPWR _1882_ sky130_fd_sc_hd__o211a_1
XFILLER_0_13_254 VPWR VGND VPWR VGND sky130_ef_sc_hd__decap_12
X_3329_ _1693_ _1441_ VGND VGND VPWR VPWR _0367_ sky130_fd_sc_hd__nor2_1
XFILLER_0_0_181 VPWR VGND VPWR VGND sky130_ef_sc_hd__decap_12
XFILLER_0_63_154 VGND VGND VPWR VPWR sky130_fd_sc_hd__decap_6
XFILLER_0_63_110 VGND VGND VPWR VPWR sky130_fd_sc_hd__fill_2
XFILLER_0_48_173 VGND VGND VPWR VPWR sky130_fd_sc_hd__fill_1
XTAP_TAPCELL_ROW_47_514 VGND VPWR sky130_fd_sc_hd__tapvpwrvgnd_1
XTAP_TAPCELL_ROW_4_191 VGND VPWR sky130_fd_sc_hd__tapvpwrvgnd_1
XFILLER_0_39_173 VGND VGND VPWR VPWR sky130_fd_sc_hd__fill_1
XFILLER_0_27_313 VGND VGND VPWR VPWR sky130_fd_sc_hd__fill_2
XFILLER_0_24_57 VGND VGND VPWR VPWR sky130_fd_sc_hd__fill_1
XFILLER_0_24_24 VGND VGND VPWR VPWR sky130_fd_sc_hd__decap_4
X_2700_ net18 VGND VGND VPWR VPWR _1805_ sky130_fd_sc_hd__buf_2
X_2562_ _1434_ net65 net66 VGND VGND VPWR VPWR _1668_ sky130_fd_sc_hd__nor3_2
XFILLER_0_42_305 VGND VGND VPWR VPWR sky130_fd_sc_hd__decap_3
X_2631_ _1705_ _1707_ _1709_ _1736_ VGND VGND VPWR VPWR _1737_ sky130_fd_sc_hd__o22a_1
X_3680_ _0745_ _1486_ _0245_ VGND VGND VPWR VPWR _0746_ sky130_fd_sc_hd__a21oi_1
XFILLER_0_6_229 VGND VGND VPWR VPWR sky130_fd_sc_hd__decap_4
X_4163_ _0449_ _1443_ _1446_ VGND VGND VPWR VPWR _1262_ sky130_fd_sc_hd__o21ai_1
XFILLER_0_49_65 VGND VGND VPWR VPWR sky130_fd_sc_hd__decap_6
X_2493_ _1306_ VGND VGND VPWR VPWR _1599_ sky130_fd_sc_hd__buf_4
XFILLER_0_10_268 VGND VGND VPWR VPWR sky130_fd_sc_hd__decap_3
X_3114_ _0132_ _0150_ _0157_ VGND VGND VPWR VPWR _0158_ sky130_fd_sc_hd__a21oi_1
X_3045_ _0085_ _0086_ _0046_ _0089_ _1611_ VGND VGND VPWR VPWR _0090_ sky130_fd_sc_hd__a41o_1
X_4094_ _0433_ _0143_ _1187_ VGND VGND VPWR VPWR _1188_ sky130_fd_sc_hd__a21o_1
XFILLER_0_4_89 VGND VGND VPWR VPWR sky130_fd_sc_hd__decap_6
X_3947_ _1613_ _2010_ _1636_ VGND VGND VPWR VPWR _1032_ sky130_fd_sc_hd__and3_2
XFILLER_0_45_154 VGND VGND VPWR VPWR sky130_fd_sc_hd__fill_1
X_3878_ _1608_ _1614_ _0956_ _0957_ VGND VGND VPWR VPWR _0958_ sky130_fd_sc_hd__a22o_1
XFILLER_0_33_327 VGND VGND VPWR VPWR sky130_fd_sc_hd__decap_8
XTAP_TAPCELL_ROW_18_293 VGND VPWR sky130_fd_sc_hd__tapvpwrvgnd_1
X_2829_ _1814_ _1824_ _1829_ _1933_ VGND VGND VPWR VPWR _1934_ sky130_fd_sc_hd__o211a_1
XFILLER_0_60_168 VGND VGND VPWR VPWR sky130_fd_sc_hd__decap_4
XFILLER_0_26_390 VGND VGND VPWR VPWR sky130_fd_sc_hd__fill_1
XPHY_EDGE_ROW_45_Left_119 VGND VGND VPWR VPWR sky130_fd_sc_hd__decap_3
XPHY_EDGE_ROW_18_Left_92 VGND VGND VPWR VPWR sky130_fd_sc_hd__decap_3
XTAP_TAPCELL_ROW_52_550 VGND VPWR sky130_fd_sc_hd__tapvpwrvgnd_1
XPHY_EDGE_ROW_54_Left_128 VGND VGND VPWR VPWR sky130_fd_sc_hd__decap_3
XFILLER_0_36_176 VPWR VGND VPWR VGND sky130_ef_sc_hd__decap_12
XPHY_EDGE_ROW_63_Left_137 VGND VGND VPWR VPWR sky130_fd_sc_hd__decap_3
XFILLER_0_19_57 VGND VGND VPWR VPWR sky130_fd_sc_hd__fill_2
XFILLER_0_35_89 VPWR VGND VPWR VGND sky130_ef_sc_hd__decap_12
XPHY_EDGE_ROW_72_Left_146 VGND VGND VPWR VPWR sky130_fd_sc_hd__decap_3
XFILLER_0_59_279 VGND VGND VPWR VPWR sky130_fd_sc_hd__fill_1
XFILLER_0_59_257 VGND VGND VPWR VPWR sky130_fd_sc_hd__fill_1
X_3801_ _1313_ _1421_ net36 VGND VGND VPWR VPWR _0875_ sky130_fd_sc_hd__a21o_1
XFILLER_0_27_110 VGND VGND VPWR VPWR sky130_fd_sc_hd__fill_2
X_3732_ _1398_ _1397_ _0764_ _1395_ VGND VGND VPWR VPWR _0801_ sky130_fd_sc_hd__a2bb2o_1
XTAP_TAPCELL_ROW_15_274 VGND VPWR sky130_fd_sc_hd__tapvpwrvgnd_1
XFILLER_0_70_433 VGND VGND VPWR VPWR sky130_fd_sc_hd__decap_4
XFILLER_0_42_168 VGND VGND VPWR VPWR sky130_fd_sc_hd__decap_4
XFILLER_0_42_135 VGND VGND VPWR VPWR sky130_fd_sc_hd__decap_4
XFILLER_0_42_124 VGND VGND VPWR VPWR sky130_fd_sc_hd__decap_3
X_2614_ _1711_ _1713_ _1715_ _1718_ _1629_ _1719_ VGND VGND VPWR VPWR _1720_ sky130_fd_sc_hd__mux4_1
X_2545_ _1650_ VGND VGND VPWR VPWR _1651_ sky130_fd_sc_hd__buf_4
X_3663_ _0715_ _0725_ _0727_ VGND VGND VPWR VPWR _2087_ sky130_fd_sc_hd__nand3b_1
XTAP_TAPCELL_ROW_7_209 VGND VPWR sky130_fd_sc_hd__tapvpwrvgnd_1
X_3594_ _1364_ _1365_ _1755_ _1757_ _1761_ VGND VGND VPWR VPWR _0653_ sky130_fd_sc_hd__a221oi_1
X_4215_ clknet_2_2__leaf_clk _2082_ net122 VGND VGND VPWR VPWR net99 sky130_fd_sc_hd__dfrtp_1
X_2476_ _1510_ VGND VGND VPWR VPWR _1582_ sky130_fd_sc_hd__buf_4
X_4146_ _1177_ _1338_ VGND VGND VPWR VPWR _1245_ sky130_fd_sc_hd__or2b_1
XTAP_TAPCELL_ROW_66_653 VGND VPWR sky130_fd_sc_hd__tapvpwrvgnd_1
X_3028_ _1711_ _1595_ _1715_ _1601_ _1582_ _1604_ VGND VGND VPWR VPWR _0073_ sky130_fd_sc_hd__mux4_2
X_4077_ _1474_ _1482_ _0939_ _0941_ _1489_ VGND VGND VPWR VPWR _1171_ sky130_fd_sc_hd__o41a_1
XFILLER_0_61_422 VGND VGND VPWR VPWR sky130_fd_sc_hd__fill_1
XFILLER_0_33_146 VGND VGND VPWR VPWR sky130_fd_sc_hd__fill_1
XTAP_TAPCELL_ROW_29_377 VGND VPWR sky130_fd_sc_hd__tapvpwrvgnd_1
XPHY_EDGE_ROW_3_Left_77 VGND VGND VPWR VPWR sky130_fd_sc_hd__decap_3
XFILLER_0_37_430 VGND VGND VPWR VPWR sky130_fd_sc_hd__decap_3
XFILLER_0_64_293 VPWR VGND VPWR VGND sky130_ef_sc_hd__decap_12
XFILLER_0_21_69 VPWR VGND VPWR VGND sky130_ef_sc_hd__decap_12
XFILLER_0_20_330 VGND VGND VPWR VPWR sky130_fd_sc_hd__decap_8
X_2330_ net65 VGND VGND VPWR VPWR _1436_ sky130_fd_sc_hd__clkbuf_4
X_4000_ _1831_ _1073_ _1076_ _1079_ _1087_ VGND VGND VPWR VPWR _1088_ sky130_fd_sc_hd__o2111a_1
XFILLER_0_20_385 VGND VGND VPWR VPWR sky130_fd_sc_hd__decap_3
X_2261_ _1264_ _1284_ _1287_ _1363_ _1366_ VGND VGND VPWR VPWR _1367_ sky130_fd_sc_hd__o2111ai_4
X_2192_ net55 net23 VGND VGND VPWR VPWR _1298_ sky130_fd_sc_hd__nor2_1
XTAP_TAPCELL_ROW_63_634 VGND VPWR sky130_fd_sc_hd__tapvpwrvgnd_1
XFILLER_0_47_205 VGND VGND VPWR VPWR sky130_fd_sc_hd__decap_8
XFILLER_0_27_9 VGND VGND VPWR VPWR sky130_fd_sc_hd__fill_1
XFILLER_0_1_57 VPWR VGND VPWR VGND sky130_ef_sc_hd__decap_12
X_3715_ _0764_ _0782_ _1490_ _1437_ _1433_ VGND VGND VPWR VPWR _0784_ sky130_fd_sc_hd__a2111o_1
XFILLER_0_7_346 VGND VGND VPWR VPWR sky130_fd_sc_hd__fill_1
XFILLER_0_60_3 VGND VGND VPWR VPWR sky130_fd_sc_hd__decap_6
X_3646_ _1492_ _0700_ _0701_ _0211_ _0709_ VGND VGND VPWR VPWR _0710_ sky130_fd_sc_hd__o32a_1
X_3577_ net61 _1938_ _0478_ VGND VGND VPWR VPWR _0635_ sky130_fd_sc_hd__o21ai_1
X_2528_ _1374_ _1510_ VGND VGND VPWR VPWR _1634_ sky130_fd_sc_hd__nand2_4
X_4129_ _1222_ _1224_ _1225_ _1831_ VGND VGND VPWR VPWR _1226_ sky130_fd_sc_hd__a31o_1
X_2459_ _1562_ _1289_ _1564_ VGND VGND VPWR VPWR _1565_ sky130_fd_sc_hd__a21oi_1
XFILLER_0_61_241 VGND VGND VPWR VPWR sky130_fd_sc_hd__fill_1
XFILLER_0_46_282 VGND VGND VPWR VPWR sky130_fd_sc_hd__fill_1
XFILLER_0_29_216 VGND VGND VPWR VPWR sky130_fd_sc_hd__decap_8
XFILLER_0_16_25 VGND VGND VPWR VPWR sky130_fd_sc_hd__decap_3
X_3500_ _0540_ _0332_ _0541_ _0544_ _0551_ VGND VGND VPWR VPWR _0552_ sky130_fd_sc_hd__a221oi_1
X_2313_ _0697_ _0719_ _1362_ _1418_ VGND VGND VPWR VPWR _1419_ sky130_fd_sc_hd__o22ai_4
X_3431_ _1446_ VGND VGND VPWR VPWR _0478_ sky130_fd_sc_hd__buf_2
X_3362_ _0402_ VGND VGND VPWR VPWR _0403_ sky130_fd_sc_hd__clkbuf_4
XFILLER_0_12_138 VGND VGND VPWR VPWR sky130_fd_sc_hd__fill_2
XFILLER_0_73_53 VGND VGND VPWR VPWR sky130_fd_sc_hd__decap_3
X_2244_ _1348_ net52 VGND VGND VPWR VPWR _1350_ sky130_fd_sc_hd__nand2_1
X_3293_ _0328_ _0329_ _0088_ _0330_ _0022_ _0031_ VGND VGND VPWR VPWR _0331_ sky130_fd_sc_hd__mux4_2
XFILLER_0_57_54 VGND VGND VPWR VPWR sky130_fd_sc_hd__fill_2
X_2175_ net28 VGND VGND VPWR VPWR _1253_ sky130_fd_sc_hd__clkbuf_4
XFILLER_0_73_97 VPWR VGND VPWR VGND sky130_ef_sc_hd__decap_12
XTAP_TAPCELL_ROW_23_328 VGND VPWR sky130_fd_sc_hd__tapvpwrvgnd_1
XFILLER_0_7_110 VGND VGND VPWR VPWR sky130_fd_sc_hd__fill_2
XFILLER_0_31_436 VGND VGND VPWR VPWR sky130_fd_sc_hd__fill_1
XTAP_TAPCELL_ROW_31_394 VGND VPWR sky130_fd_sc_hd__tapvpwrvgnd_1
X_3629_ _1291_ _2009_ _2010_ _0349_ _1385_ VGND VGND VPWR VPWR _0691_ sky130_fd_sc_hd__a32o_1
XFILLER_0_16_411 VGND VGND VPWR VPWR sky130_fd_sc_hd__decap_8
XTAP_TAPCELL_ROW_39_450 VGND VPWR sky130_fd_sc_hd__tapvpwrvgnd_1
XFILLER_0_66_388 VGND VGND VPWR VPWR sky130_fd_sc_hd__decap_6
XFILLER_0_34_263 VGND VGND VPWR VPWR sky130_fd_sc_hd__decap_3
XFILLER_0_27_57 VGND VGND VPWR VPWR sky130_fd_sc_hd__decap_8
XPHY_EDGE_ROW_6_Left_80 VGND VGND VPWR VPWR sky130_fd_sc_hd__decap_3
X_2931_ _1813_ net49 _1423_ _0847_ VGND VGND VPWR VPWR _2035_ sky130_fd_sc_hd__a31oi_2
XTAP_TAPCELL_ROW_45_497 VGND VPWR sky130_fd_sc_hd__tapvpwrvgnd_1
Xclkbuf_0_clk clk VGND VGND VPWR VPWR clknet_0_clk sky130_fd_sc_hd__clkbuf_16
X_3980_ _1785_ _1937_ _1940_ _1941_ VGND VGND VPWR VPWR _1067_ sky130_fd_sc_hd__o211a_1
XFILLER_0_17_219 VGND VGND VPWR VPWR sky130_fd_sc_hd__decap_4
XFILLER_0_40_222 VGND VGND VPWR VPWR sky130_fd_sc_hd__decap_4
X_2862_ _1954_ _1959_ _1965_ VGND VGND VPWR VPWR _1966_ sky130_fd_sc_hd__a21o_1
X_2793_ _1662_ _1895_ _1897_ VGND VGND VPWR VPWR _1898_ sky130_fd_sc_hd__o21ai_1
XTAP_TAPCELL_ROW_20_309 VGND VPWR sky130_fd_sc_hd__tapvpwrvgnd_1
XFILLER_0_4_146 VGND VGND VPWR VPWR sky130_fd_sc_hd__decap_4
X_3276_ _0065_ _0312_ _0313_ VGND VGND VPWR VPWR _0314_ sky130_fd_sc_hd__a21oi_2
X_3414_ _1511_ _1512_ _0458_ VGND VGND VPWR VPWR _0459_ sky130_fd_sc_hd__a21oi_1
XFILLER_0_0_385 VGND VGND VPWR VPWR sky130_fd_sc_hd__decap_3
XPHY_EDGE_ROW_15_Right_15 VGND VGND VPWR VPWR sky130_fd_sc_hd__decap_3
X_3345_ _1693_ _0333_ _0383_ _0337_ _1970_ _1890_ VGND VGND VPWR VPWR _0385_ sky130_fd_sc_hd__mux4_1
X_2227_ _1329_ _1331_ _1332_ VGND VGND VPWR VPWR _1333_ sky130_fd_sc_hd__o21ai_1
XTAP_TAPCELL_ROW_36_431 VGND VPWR sky130_fd_sc_hd__tapvpwrvgnd_1
XPHY_EDGE_ROW_24_Right_24 VGND VGND VPWR VPWR sky130_fd_sc_hd__decap_3
XFILLER_0_23_3 VGND VGND VPWR VPWR sky130_fd_sc_hd__decap_3
X_2158_ net36 net4 VGND VGND VPWR VPWR _1071_ sky130_fd_sc_hd__xnor2_4
XFILLER_0_48_377 VGND VGND VPWR VPWR sky130_fd_sc_hd__decap_3
XPHY_EDGE_ROW_33_Right_33 VGND VGND VPWR VPWR sky130_fd_sc_hd__decap_3
XFILLER_0_66_141 VGND VGND VPWR VPWR sky130_fd_sc_hd__decap_3
XPHY_EDGE_ROW_42_Right_42 VGND VGND VPWR VPWR sky130_fd_sc_hd__decap_3
XFILLER_0_13_15 VGND VGND VPWR VPWR sky130_fd_sc_hd__fill_2
XPHY_EDGE_ROW_51_Right_51 VGND VGND VPWR VPWR sky130_fd_sc_hd__decap_3
X_3130_ _0091_ _0126_ _1969_ _1487_ VGND VGND VPWR VPWR _0174_ sky130_fd_sc_hd__o211a_1
XFILLER_0_38_23 VGND VGND VPWR VPWR sky130_fd_sc_hd__decap_4
XPHY_EDGE_ROW_60_Right_60 VGND VGND VPWR VPWR sky130_fd_sc_hd__decap_3
X_3061_ _1556_ VGND VGND VPWR VPWR _0106_ sky130_fd_sc_hd__clkbuf_4
XFILLER_0_72_155 VGND VGND VPWR VPWR sky130_fd_sc_hd__decap_3
X_2845_ _1417_ _1429_ _1353_ _1948_ _0922_ VGND VGND VPWR VPWR _1949_ sky130_fd_sc_hd__o221a_1
X_2914_ net51 _1676_ _2017_ VGND VGND VPWR VPWR _2018_ sky130_fd_sc_hd__o21a_1
XFILLER_0_57_152 VPWR VGND VPWR VGND sky130_ef_sc_hd__decap_12
XFILLER_0_45_325 VGND VGND VPWR VPWR sky130_fd_sc_hd__fill_2
X_3963_ net41 _0196_ _0092_ VGND VGND VPWR VPWR _1048_ sky130_fd_sc_hd__o21ai_1
X_3894_ _0939_ _1937_ _0428_ _0429_ VGND VGND VPWR VPWR _0975_ sky130_fd_sc_hd__o211a_1
XFILLER_0_72_177 VGND VGND VPWR VPWR sky130_fd_sc_hd__decap_4
X_2776_ _1572_ net18 _1654_ _1656_ _1870_ VGND VGND VPWR VPWR _1881_ sky130_fd_sc_hd__o2111ai_2
XFILLER_0_13_222 VGND VGND VPWR VPWR sky130_fd_sc_hd__fill_2
XFILLER_0_13_266 VGND VGND VPWR VPWR sky130_fd_sc_hd__decap_6
X_3259_ _0294_ _0295_ _0296_ _0297_ VGND VGND VPWR VPWR _0298_ sky130_fd_sc_hd__or4_1
X_3328_ _1693_ _1938_ _1439_ VGND VGND VPWR VPWR _0366_ sky130_fd_sc_hd__o21ai_1
XFILLER_0_0_193 VGND VGND VPWR VPWR sky130_fd_sc_hd__decap_3
XFILLER_0_48_141 VGND VGND VPWR VPWR sky130_fd_sc_hd__decap_8
XFILLER_0_8_271 VGND VGND VPWR VPWR sky130_fd_sc_hd__fill_1
XTAP_TAPCELL_ROW_4_192 VGND VPWR sky130_fd_sc_hd__tapvpwrvgnd_1
XTAP_TAPCELL_ROW_55_570 VGND VPWR sky130_fd_sc_hd__tapvpwrvgnd_1
XFILLER_0_24_36 VGND VGND VPWR VPWR sky130_fd_sc_hd__decap_8
X_2492_ _1597_ VGND VGND VPWR VPWR _1598_ sky130_fd_sc_hd__buf_2
XFILLER_0_54_177 VGND VGND VPWR VPWR sky130_fd_sc_hd__fill_1
XFILLER_0_50_383 VPWR VGND VPWR VGND sky130_ef_sc_hd__decap_12
XFILLER_0_49_55 VGND VGND VPWR VPWR sky130_fd_sc_hd__fill_1
XFILLER_0_49_11 VGND VGND VPWR VPWR sky130_fd_sc_hd__fill_2
X_2561_ _1664_ _1538_ _1541_ _1666_ VGND VGND VPWR VPWR _1667_ sky130_fd_sc_hd__a31o_4
XFILLER_0_42_317 VGND VGND VPWR VPWR sky130_fd_sc_hd__decap_6
X_2630_ _1645_ _1720_ _1735_ VGND VGND VPWR VPWR _1736_ sky130_fd_sc_hd__o21a_1
XFILLER_0_35_391 VGND VGND VPWR VPWR sky130_fd_sc_hd__fill_1
XFILLER_0_35_380 VGND VGND VPWR VPWR sky130_fd_sc_hd__fill_2
XFILLER_0_2_403 VPWR VGND VPWR VGND sky130_ef_sc_hd__decap_12
X_4162_ _1450_ _1939_ VGND VGND VPWR VPWR _1261_ sky130_fd_sc_hd__nor2_1
X_3113_ _0151_ _0152_ _0153_ _0156_ VGND VGND VPWR VPWR _0157_ sky130_fd_sc_hd__or4_1
X_4093_ _2004_ _0403_ _0133_ _1592_ _0107_ VGND VGND VPWR VPWR _1187_ sky130_fd_sc_hd__a221o_1
XFILLER_0_4_46 VPWR VGND VPWR VGND sky130_ef_sc_hd__decap_12
X_3044_ _1583_ _1559_ _1556_ _0088_ VGND VGND VPWR VPWR _0089_ sky130_fd_sc_hd__or4b_1
XTAP_TAPCELL_ROW_18_294 VGND VPWR sky130_fd_sc_hd__tapvpwrvgnd_1
X_2828_ _1889_ _1915_ _1932_ VGND VGND VPWR VPWR _1933_ sky130_fd_sc_hd__and3_1
X_3877_ _1874_ _0037_ _1985_ _1598_ VGND VGND VPWR VPWR _0957_ sky130_fd_sc_hd__or4_1
X_3946_ _0596_ _1584_ _1865_ _1030_ VGND VGND VPWR VPWR _1031_ sky130_fd_sc_hd__a211o_1
XFILLER_0_14_80 VGND VGND VPWR VPWR sky130_fd_sc_hd__decap_4
XFILLER_0_18_314 VGND VGND VPWR VPWR sky130_fd_sc_hd__fill_2
X_2759_ _1842_ _1863_ VGND VGND VPWR VPWR _1864_ sky130_fd_sc_hd__and2_1
XTAP_TAPCELL_ROW_69_673 VGND VPWR sky130_fd_sc_hd__tapvpwrvgnd_1
XFILLER_0_68_203 VPWR VGND VPWR VGND sky130_ef_sc_hd__decap_12
XFILLER_0_68_247 VGND VGND VPWR VPWR sky130_fd_sc_hd__decap_4
XTAP_TAPCELL_ROW_52_551 VGND VPWR sky130_fd_sc_hd__tapvpwrvgnd_1
XFILLER_0_24_306 VGND VGND VPWR VPWR sky130_fd_sc_hd__fill_2
XFILLER_0_17_380 VGND VGND VPWR VPWR sky130_fd_sc_hd__fill_1
XFILLER_0_59_225 VPWR VGND VPWR VGND sky130_ef_sc_hd__decap_12
XFILLER_0_35_57 VGND VGND VPWR VPWR sky130_fd_sc_hd__decap_3
XFILLER_0_51_78 VPWR VGND VPWR VGND sky130_ef_sc_hd__decap_12
X_3800_ net36 _0426_ _0428_ _0429_ VGND VGND VPWR VPWR _0874_ sky130_fd_sc_hd__o211a_1
XFILLER_0_27_177 VGND VGND VPWR VPWR sky130_fd_sc_hd__decap_3
X_3662_ _1454_ _0304_ _0726_ VGND VGND VPWR VPWR _0727_ sky130_fd_sc_hd__o21ai_1
X_3731_ _1469_ _1431_ _0478_ _0799_ VGND VGND VPWR VPWR _0800_ sky130_fd_sc_hd__o211a_1
XFILLER_0_15_317 VPWR VGND VPWR VGND sky130_ef_sc_hd__decap_12
X_2613_ _1581_ VGND VGND VPWR VPWR _1719_ sky130_fd_sc_hd__buf_4
XFILLER_0_42_158 VGND VGND VPWR VPWR sky130_fd_sc_hd__fill_2
X_2544_ _1648_ _1649_ _1635_ VGND VGND VPWR VPWR _1650_ sky130_fd_sc_hd__and3_1
XFILLER_0_30_309 VGND VGND VPWR VPWR sky130_fd_sc_hd__decap_8
XFILLER_0_2_222 VGND VGND VPWR VPWR sky130_fd_sc_hd__decap_3
X_3593_ _1364_ _1365_ _0650_ _0651_ VGND VGND VPWR VPWR _0652_ sky130_fd_sc_hd__a31o_1
X_2475_ _1580_ VGND VGND VPWR VPWR _1581_ sky130_fd_sc_hd__buf_4
X_4214_ clknet_2_2__leaf_clk _2081_ net122 VGND VGND VPWR VPWR net98 sky130_fd_sc_hd__dfrtp_1
XTAP_TAPCELL_ROW_66_654 VGND VPWR sky130_fd_sc_hd__tapvpwrvgnd_1
X_4145_ _1143_ _0406_ _1209_ _1242_ VGND VGND VPWR VPWR _1244_ sky130_fd_sc_hd__a211o_1
X_4076_ _1336_ _1431_ _1169_ VGND VGND VPWR VPWR _1170_ sky130_fd_sc_hd__o21ai_1
X_3027_ _0065_ _0067_ _0071_ VGND VGND VPWR VPWR _0072_ sky130_fd_sc_hd__o21ai_2
XFILLER_0_33_169 VGND VGND VPWR VPWR sky130_fd_sc_hd__decap_3
X_3929_ _1313_ _1421_ net40 VGND VGND VPWR VPWR _1012_ sky130_fd_sc_hd__a21o_1
XFILLER_0_14_361 VGND VGND VPWR VPWR sky130_fd_sc_hd__decap_3
XFILLER_0_14_372 VGND VGND VPWR VPWR sky130_fd_sc_hd__fill_2
XTAP_TAPCELL_ROW_29_378 VGND VPWR sky130_fd_sc_hd__tapvpwrvgnd_1
XFILLER_0_52_401 VGND VGND VPWR VPWR sky130_fd_sc_hd__decap_4
XFILLER_0_24_125 VPWR VGND VPWR VGND sky130_ef_sc_hd__decap_12
XFILLER_0_24_103 VGND VGND VPWR VPWR sky130_fd_sc_hd__fill_1
XTAP_TAPCELL_ROW_12_245 VGND VPWR sky130_fd_sc_hd__tapvpwrvgnd_1
XFILLER_0_24_147 VGND VGND VPWR VPWR sky130_fd_sc_hd__fill_1
XFILLER_0_12_309 VGND VGND VPWR VPWR sky130_fd_sc_hd__decap_6
XFILLER_0_46_45 VPWR VGND VPWR VGND sky130_ef_sc_hd__decap_12
X_2260_ _1364_ _1365_ VGND VGND VPWR VPWR _1366_ sky130_fd_sc_hd__nand2_1
X_2191_ _1296_ VGND VGND VPWR VPWR _1297_ sky130_fd_sc_hd__buf_2
XFILLER_0_1_69 VPWR VGND VPWR VGND sky130_ef_sc_hd__decap_12
XFILLER_0_7_303 VGND VGND VPWR VPWR sky130_fd_sc_hd__fill_1
XTAP_TAPCELL_ROW_71_690 VGND VPWR sky130_fd_sc_hd__tapvpwrvgnd_1
XFILLER_0_70_253 VGND VGND VPWR VPWR sky130_fd_sc_hd__decap_6
XFILLER_0_62_209 VGND VGND VPWR VPWR sky130_fd_sc_hd__fill_1
X_3645_ _0107_ _0702_ _0707_ VGND VGND VPWR VPWR _0709_ sky130_fd_sc_hd__a21oi_1
X_3714_ _1454_ _0633_ _0245_ _1465_ _1427_ VGND VGND VPWR VPWR _0782_ sky130_fd_sc_hd__o41a_1
X_2527_ _1479_ _1326_ _1481_ net9 _1572_ _1632_ VGND VGND VPWR VPWR _1633_ sky130_fd_sc_hd__mux4_1
XFILLER_0_53_3 VGND VGND VPWR VPWR sky130_fd_sc_hd__fill_2
XFILLER_0_23_180 VGND VGND VPWR VPWR sky130_fd_sc_hd__decap_8
X_3576_ _0633_ _0304_ VGND VGND VPWR VPWR _0634_ sky130_fd_sc_hd__nor2_1
X_2458_ _1563_ _1253_ VGND VGND VPWR VPWR _1564_ sky130_fd_sc_hd__and2_1
XFILLER_0_11_320 VGND VGND VPWR VPWR sky130_fd_sc_hd__fill_1
XFILLER_0_11_353 VPWR VGND VPWR VGND sky130_ef_sc_hd__decap_12
X_2389_ _1442_ _1448_ _1494_ VGND VGND VPWR VPWR _1495_ sky130_fd_sc_hd__o21ba_1
X_4059_ _0363_ _1612_ _2009_ _0349_ _1502_ VGND VGND VPWR VPWR _1151_ sky130_fd_sc_hd__a32o_1
X_4128_ _0031_ _0037_ _0205_ VGND VGND VPWR VPWR _1225_ sky130_fd_sc_hd__or3_1
XTAP_TAPCELL_ROW_60_605 VGND VPWR sky130_fd_sc_hd__tapvpwrvgnd_1
XFILLER_0_32_25 VGND VGND VPWR VPWR sky130_fd_sc_hd__decap_3
XFILLER_0_52_253 VGND VGND VPWR VPWR sky130_fd_sc_hd__fill_2
XFILLER_0_52_220 VGND VGND VPWR VPWR sky130_fd_sc_hd__decap_4
XFILLER_0_4_317 VGND VGND VPWR VPWR sky130_fd_sc_hd__fill_1
X_3292_ _1423_ _1805_ _1945_ _1347_ _1577_ _1970_ VGND VGND VPWR VPWR _0330_ sky130_fd_sc_hd__mux4_1
X_3361_ _1537_ _1437_ _1433_ _1548_ VGND VGND VPWR VPWR _0402_ sky130_fd_sc_hd__or4b_2
X_3430_ _0445_ _0457_ _0465_ _0476_ VGND VGND VPWR VPWR _0477_ sky130_fd_sc_hd__nand4_1
X_2312_ _1311_ _1388_ _1416_ _1417_ VGND VGND VPWR VPWR _1418_ sky130_fd_sc_hd__a31oi_4
X_2243_ net52 _1348_ VGND VGND VPWR VPWR _1349_ sky130_fd_sc_hd__nor2_1
X_2174_ _1082_ _1232_ VGND VGND VPWR VPWR _1243_ sky130_fd_sc_hd__nor2_2
XFILLER_0_28_250 VGND VGND VPWR VPWR sky130_fd_sc_hd__fill_2
XTAP_TAPCELL_ROW_23_329 VGND VPWR sky130_fd_sc_hd__tapvpwrvgnd_1
XFILLER_0_7_155 VGND VGND VPWR VPWR sky130_fd_sc_hd__decap_6
X_3628_ _1914_ _0689_ _0273_ VGND VGND VPWR VPWR _0690_ sky130_fd_sc_hd__and3_1
XFILLER_0_3_361 VGND VGND VPWR VPWR sky130_fd_sc_hd__fill_2
XFILLER_0_9_9 VGND VGND VPWR VPWR sky130_fd_sc_hd__fill_1
XFILLER_0_11_194 VGND VGND VPWR VPWR sky130_fd_sc_hd__decap_6
X_3559_ _1264_ _1671_ _1284_ _1378_ _0615_ VGND VGND VPWR VPWR _0616_ sky130_fd_sc_hd__o32a_1
XFILLER_0_66_323 VGND VGND VPWR VPWR sky130_fd_sc_hd__fill_2
XTAP_TAPCELL_ROW_39_451 VGND VPWR sky130_fd_sc_hd__tapvpwrvgnd_1
XFILLER_0_34_253 VGND VGND VPWR VPWR sky130_fd_sc_hd__fill_2
XFILLER_0_34_231 VGND VGND VPWR VPWR sky130_fd_sc_hd__fill_2
XFILLER_0_26_209 VGND VGND VPWR VPWR sky130_fd_sc_hd__decap_6
XFILLER_0_69_183 VGND VGND VPWR VPWR sky130_fd_sc_hd__fill_1
X_2930_ _2032_ _2033_ net51 VGND VGND VPWR VPWR _2034_ sky130_fd_sc_hd__a21oi_1
XFILLER_0_57_389 VGND VGND VPWR VPWR sky130_fd_sc_hd__decap_3
XFILLER_0_57_345 VGND VGND VPWR VPWR sky130_fd_sc_hd__fill_1
XTAP_TAPCELL_ROW_45_498 VGND VPWR sky130_fd_sc_hd__tapvpwrvgnd_1
X_2861_ _1960_ _1962_ _1964_ VGND VGND VPWR VPWR _1965_ sky130_fd_sc_hd__and3_1
XFILLER_0_9_409 VPWR VGND VPWR VGND sky130_ef_sc_hd__decap_12
XFILLER_0_72_348 VPWR VGND VPWR VGND sky130_ef_sc_hd__decap_12
XFILLER_0_25_231 VPWR VGND VPWR VGND sky130_ef_sc_hd__decap_12
X_2792_ _1876_ _1896_ _1703_ VGND VGND VPWR VPWR _1897_ sky130_fd_sc_hd__o21a_1
X_3413_ _1368_ _1369_ _1370_ VGND VGND VPWR VPWR _0458_ sky130_fd_sc_hd__o21ba_1
XFILLER_0_7_57 VGND VGND VPWR VPWR sky130_fd_sc_hd__decap_4
X_2226_ net41 net9 VGND VGND VPWR VPWR _1332_ sky130_fd_sc_hd__or2b_1
X_3275_ _0251_ _0267_ _1986_ _1643_ _1663_ VGND VGND VPWR VPWR _0313_ sky130_fd_sc_hd__o311a_1
XFILLER_0_0_342 VPWR VGND VPWR VGND sky130_ef_sc_hd__decap_12
X_3344_ _1463_ VGND VGND VPWR VPWR _0383_ sky130_fd_sc_hd__buf_2
XTAP_TAPCELL_ROW_36_432 VGND VPWR sky130_fd_sc_hd__tapvpwrvgnd_1
X_2157_ _1050_ net5 VGND VGND VPWR VPWR _1061_ sky130_fd_sc_hd__xnor2_2
XFILLER_0_16_3 VPWR VGND VPWR VGND sky130_ef_sc_hd__decap_12
XFILLER_0_16_220 VPWR VGND VPWR VGND sky130_ef_sc_hd__decap_12
XFILLER_0_16_253 VGND VGND VPWR VPWR sky130_fd_sc_hd__decap_6
XFILLER_0_31_234 VGND VGND VPWR VPWR sky130_fd_sc_hd__fill_2
XFILLER_0_16_297 VGND VGND VPWR VPWR sky130_fd_sc_hd__decap_8
XFILLER_0_66_131 VGND VGND VPWR VPWR sky130_fd_sc_hd__decap_8
XFILLER_0_66_120 VGND VGND VPWR VPWR sky130_fd_sc_hd__fill_1
XFILLER_0_13_38 VGND VGND VPWR VPWR sky130_fd_sc_hd__fill_2
XFILLER_0_54_348 VGND VGND VPWR VPWR sky130_fd_sc_hd__fill_1
XFILLER_0_22_245 VGND VGND VPWR VPWR sky130_fd_sc_hd__decap_6
XFILLER_0_1_117 VGND VGND VPWR VPWR sky130_fd_sc_hd__decap_3
X_3060_ _0066_ _1892_ _0104_ _0022_ _2053_ VGND VGND VPWR VPWR _0105_ sky130_fd_sc_hd__a221o_1
XTAP_TAPCELL_ROW_58_590 VGND VPWR sky130_fd_sc_hd__tapvpwrvgnd_1
XFILLER_0_60_307 VGND VGND VPWR VPWR sky130_fd_sc_hd__fill_1
XFILLER_0_57_164 VGND VGND VPWR VPWR sky130_fd_sc_hd__decap_4
X_2844_ _0697_ _0719_ _1362_ _1418_ VGND VGND VPWR VPWR _1948_ sky130_fd_sc_hd__o22a_2
X_2913_ _1673_ VGND VGND VPWR VPWR _2017_ sky130_fd_sc_hd__clkbuf_4
X_3962_ _0024_ _0393_ _0810_ _1893_ VGND VGND VPWR VPWR _1047_ sky130_fd_sc_hd__o2bb2a_1
X_3893_ _1740_ _0971_ _0973_ _1828_ VGND VGND VPWR VPWR _0974_ sky130_fd_sc_hd__o211ai_1
XFILLER_0_53_370 VGND VGND VPWR VPWR sky130_fd_sc_hd__decap_8
X_2775_ _1728_ _1729_ VGND VGND VPWR VPWR _1880_ sky130_fd_sc_hd__nand2_2
XFILLER_0_13_289 VGND VGND VPWR VPWR sky130_fd_sc_hd__decap_4
X_3189_ _0225_ _0227_ _0230_ _0231_ VGND VGND VPWR VPWR _0232_ sky130_fd_sc_hd__o22a_1
X_3258_ net96 net95 net99 net98 VGND VGND VPWR VPWR _0297_ sky130_fd_sc_hd__or4_1
X_2209_ net25 VGND VGND VPWR VPWR _1315_ sky130_fd_sc_hd__buf_4
X_3327_ _1417_ _1429_ _1353_ _1948_ _1719_ VGND VGND VPWR VPWR _0365_ sky130_fd_sc_hd__o221a_1
XFILLER_0_48_197 VPWR VGND VPWR VGND sky130_ef_sc_hd__decap_12
XFILLER_0_36_348 VGND VGND VPWR VPWR sky130_fd_sc_hd__fill_2
XFILLER_0_8_283 VPWR VGND VPWR VGND sky130_ef_sc_hd__decap_12
XFILLER_0_5_3 VPWR VGND VPWR VGND sky130_ef_sc_hd__decap_12
Xclkbuf_2_0__f_clk clknet_0_clk VGND VGND VPWR VPWR clknet_2_0__leaf_clk sky130_fd_sc_hd__clkbuf_16
XFILLER_0_24_15 VGND VGND VPWR VPWR sky130_fd_sc_hd__fill_2
XTAP_TAPCELL_ROW_55_571 VGND VPWR sky130_fd_sc_hd__tapvpwrvgnd_1
XFILLER_0_27_337 VGND VGND VPWR VPWR sky130_fd_sc_hd__decap_6
X_2491_ _1593_ net24 _1596_ VGND VGND VPWR VPWR _1597_ sky130_fd_sc_hd__o21ai_1
X_2560_ _1665_ _1490_ VGND VGND VPWR VPWR _1666_ sky130_fd_sc_hd__nor2_4
XFILLER_0_50_395 VGND VGND VPWR VPWR sky130_fd_sc_hd__decap_6
XFILLER_0_49_78 VGND VGND VPWR VPWR sky130_fd_sc_hd__decap_4
XFILLER_0_2_415 VGND VGND VPWR VPWR sky130_fd_sc_hd__decap_4
X_3043_ _1968_ net22 _0087_ _1315_ _1621_ _1697_ VGND VGND VPWR VPWR _0088_ sky130_fd_sc_hd__mux4_2
XFILLER_0_65_22 VGND VGND VPWR VPWR sky130_fd_sc_hd__fill_2
X_4161_ _1258_ _1487_ _1450_ _1492_ VGND VGND VPWR VPWR _1260_ sky130_fd_sc_hd__a31o_1
X_3112_ _1925_ _0794_ _0154_ _0094_ _0155_ VGND VGND VPWR VPWR _0156_ sky130_fd_sc_hd__a221o_1
X_4092_ _1954_ _1558_ _0136_ _1176_ _1185_ VGND VGND VPWR VPWR _1186_ sky130_fd_sc_hd__o311a_1
XFILLER_0_73_421 VPWR VGND VPWR VGND sky130_ef_sc_hd__decap_12
XFILLER_0_45_101 VGND VGND VPWR VPWR sky130_fd_sc_hd__decap_8
X_3945_ _1630_ _2053_ VGND VGND VPWR VPWR _1030_ sky130_fd_sc_hd__and2_1
XTAP_TAPCELL_ROW_18_295 VGND VPWR sky130_fd_sc_hd__tapvpwrvgnd_1
X_2827_ _1921_ _1927_ _1931_ _1685_ VGND VGND VPWR VPWR _1932_ sky130_fd_sc_hd__and4_1
X_2758_ _1856_ _1858_ _1860_ _1862_ _1510_ _1581_ VGND VGND VPWR VPWR _1863_ sky130_fd_sc_hd__mux4_1
XFILLER_0_45_123 VPWR VGND VPWR VGND sky130_ef_sc_hd__decap_12
X_3876_ _1960_ _0672_ _0955_ VGND VGND VPWR VPWR _0956_ sky130_fd_sc_hd__a21o_1
XFILLER_0_30_91 VGND VGND VPWR VPWR sky130_fd_sc_hd__fill_1
XFILLER_0_30_80 VGND VGND VPWR VPWR sky130_fd_sc_hd__decap_4
XFILLER_0_18_348 VGND VGND VPWR VPWR sky130_fd_sc_hd__decap_3
X_2689_ _1450_ _0449_ _1794_ VGND VGND VPWR VPWR _1795_ sky130_fd_sc_hd__a21oi_1
XTAP_TAPCELL_ROW_69_674 VGND VPWR sky130_fd_sc_hd__tapvpwrvgnd_1
XFILLER_0_68_215 VGND VGND VPWR VPWR sky130_fd_sc_hd__decap_4
XTAP_TAPCELL_ROW_1_163 VGND VPWR sky130_fd_sc_hd__tapvpwrvgnd_1
XFILLER_0_64_421 VPWR VGND VPWR VGND sky130_ef_sc_hd__decap_12
XTAP_TAPCELL_ROW_52_552 VGND VPWR sky130_fd_sc_hd__tapvpwrvgnd_1
XFILLER_0_32_373 VGND VGND VPWR VPWR sky130_fd_sc_hd__decap_4
XFILLER_0_17_370 VGND VGND VPWR VPWR sky130_fd_sc_hd__fill_2
XFILLER_0_59_237 VPWR VGND VPWR VGND sky130_ef_sc_hd__decap_12
XFILLER_0_59_215 VGND VGND VPWR VPWR sky130_fd_sc_hd__decap_8
XFILLER_0_51_13 VGND VGND VPWR VPWR sky130_fd_sc_hd__fill_1
XFILLER_0_51_57 VGND VGND VPWR VPWR sky130_fd_sc_hd__decap_6
XFILLER_0_42_104 VPWR VGND VPWR VGND sky130_ef_sc_hd__decap_12
X_2612_ _1621_ _1330_ _1717_ VGND VGND VPWR VPWR _1718_ sky130_fd_sc_hd__o21ai_2
X_3730_ _2032_ _2033_ net34 VGND VGND VPWR VPWR _0799_ sky130_fd_sc_hd__a21o_1
X_3661_ net62 _1444_ _1447_ VGND VGND VPWR VPWR _0726_ sky130_fd_sc_hd__o21a_1
X_3592_ _1759_ _0650_ _1545_ VGND VGND VPWR VPWR _0651_ sky130_fd_sc_hd__o21ai_1
XFILLER_0_15_329 VGND VGND VPWR VPWR sky130_fd_sc_hd__decap_6
X_4213_ clknet_2_2__leaf_clk _2079_ net122 VGND VGND VPWR VPWR net96 sky130_fd_sc_hd__dfrtp_1
X_2474_ _1301_ VGND VGND VPWR VPWR _1580_ sky130_fd_sc_hd__clkinv_4
X_2543_ net55 net58 VGND VGND VPWR VPWR _1649_ sky130_fd_sc_hd__nor2_4
XTAP_TAPCELL_ROW_66_655 VGND VPWR sky130_fd_sc_hd__tapvpwrvgnd_1
X_4144_ _1335_ _1192_ _1339_ VGND VGND VPWR VPWR _1242_ sky130_fd_sc_hd__a21oi_1
X_4075_ _1480_ _1443_ _1940_ _1941_ VGND VGND VPWR VPWR _1169_ sky130_fd_sc_hd__o211a_1
X_3026_ _0068_ _1725_ _0069_ _0070_ VGND VGND VPWR VPWR _0071_ sky130_fd_sc_hd__o211ai_2
XFILLER_0_65_218 VGND VGND VPWR VPWR sky130_fd_sc_hd__fill_1
XFILLER_0_58_292 VPWR VGND VPWR VGND sky130_ef_sc_hd__decap_12
XFILLER_0_46_421 VPWR VGND VPWR VGND sky130_ef_sc_hd__decap_12
Xwire109 net126 VGND VGND VPWR VPWR net109 sky130_fd_sc_hd__buf_1
X_3928_ net40 _1441_ _0428_ _0429_ VGND VGND VPWR VPWR _1011_ sky130_fd_sc_hd__o211a_1
XFILLER_0_73_273 VGND VGND VPWR VPWR sky130_fd_sc_hd__decap_3
X_3859_ _1050_ _0304_ _0937_ VGND VGND VPWR VPWR _0938_ sky130_fd_sc_hd__o21ai_1
XTAP_TAPCELL_ROW_6_200 VGND VPWR sky130_fd_sc_hd__tapvpwrvgnd_1
XTAP_TAPCELL_ROW_29_379 VGND VPWR sky130_fd_sc_hd__tapvpwrvgnd_1
XFILLER_0_64_240 VPWR VGND VPWR VGND sky130_ef_sc_hd__decap_12
XFILLER_0_24_137 VGND VGND VPWR VPWR sky130_fd_sc_hd__decap_3
XFILLER_0_21_16 VPWR VGND VPWR VGND sky130_ef_sc_hd__decap_12
XTAP_TAPCELL_ROW_12_246 VGND VPWR sky130_fd_sc_hd__tapvpwrvgnd_1
XFILLER_0_20_365 VGND VGND VPWR VPWR sky130_fd_sc_hd__decap_4
XFILLER_0_20_321 VGND VGND VPWR VPWR sky130_fd_sc_hd__decap_3
XFILLER_0_46_79 VGND VGND VPWR VPWR sky130_fd_sc_hd__decap_4
XFILLER_0_46_57 VGND VGND VPWR VPWR sky130_fd_sc_hd__decap_8
XFILLER_0_46_35 VGND VGND VPWR VPWR sky130_fd_sc_hd__fill_2
X_2190_ net58 net26 VGND VGND VPWR VPWR _1296_ sky130_fd_sc_hd__and2_1
XFILLER_0_1_15 VPWR VGND VPWR VGND sky130_ef_sc_hd__decap_12
XTAP_TAPCELL_ROW_71_691 VGND VPWR sky130_fd_sc_hd__tapvpwrvgnd_1
XFILLER_0_62_34 VGND VGND VPWR VPWR sky130_fd_sc_hd__decap_8
XFILLER_0_28_432 VGND VGND VPWR VPWR sky130_fd_sc_hd__decap_4
XFILLER_0_28_421 VGND VGND VPWR VPWR sky130_fd_sc_hd__decap_4
XFILLER_0_7_315 VPWR VGND VPWR VGND sky130_ef_sc_hd__decap_12
XFILLER_0_70_287 VGND VGND VPWR VPWR sky130_fd_sc_hd__fill_1
XFILLER_0_55_295 VGND VGND VPWR VPWR sky130_fd_sc_hd__fill_1
X_3713_ _1706_ net117 _1808_ _1809_ VGND VGND VPWR VPWR _0781_ sky130_fd_sc_hd__and4_2
XFILLER_0_30_107 VGND VGND VPWR VPWR sky130_fd_sc_hd__decap_8
X_3644_ _0501_ _1985_ _2053_ _0704_ _0706_ VGND VGND VPWR VPWR _0707_ sky130_fd_sc_hd__o221a_1
X_3575_ _1458_ VGND VGND VPWR VPWR _0633_ sky130_fd_sc_hd__buf_2
X_2388_ _1488_ _1493_ VGND VGND VPWR VPWR _1494_ sky130_fd_sc_hd__nor2_1
XFILLER_0_46_3 VGND VGND VPWR VPWR sky130_fd_sc_hd__decap_4
X_2526_ _1301_ VGND VGND VPWR VPWR _1632_ sky130_fd_sc_hd__buf_4
X_2457_ _1305_ VGND VGND VPWR VPWR _1563_ sky130_fd_sc_hd__clkbuf_4
XFILLER_0_11_365 VGND VGND VPWR VPWR sky130_fd_sc_hd__decap_8
X_3009_ _1950_ _0965_ _0911_ _0053_ VGND VGND VPWR VPWR _0054_ sky130_fd_sc_hd__a31oi_4
X_4058_ _1613_ _2010_ _0626_ VGND VGND VPWR VPWR _1150_ sky130_fd_sc_hd__and3_1
X_4127_ _0596_ _0190_ _1223_ VGND VGND VPWR VPWR _1224_ sky130_fd_sc_hd__o21ai_1
XTAP_TAPCELL_ROW_60_606 VGND VPWR sky130_fd_sc_hd__tapvpwrvgnd_1
XFILLER_0_37_262 VPWR VGND VPWR VGND sky130_ef_sc_hd__decap_12
XFILLER_0_25_435 VGND VGND VPWR VPWR sky130_fd_sc_hd__fill_2
XFILLER_0_25_413 VGND VGND VPWR VPWR sky130_fd_sc_hd__fill_2
X_2242_ _1347_ VGND VGND VPWR VPWR _1348_ sky130_fd_sc_hd__inv_2
X_3291_ _1330_ _1785_ _1481_ _1326_ _1576_ _1894_ VGND VGND VPWR VPWR _0329_ sky130_fd_sc_hd__mux4_2
XFILLER_0_57_23 VGND VGND VPWR VPWR sky130_fd_sc_hd__fill_1
X_2311_ _0492_ net115 _1320_ _1324_ VGND VGND VPWR VPWR _1417_ sky130_fd_sc_hd__nand4_4
X_3360_ _1916_ _0393_ _0397_ _0398_ _0400_ VGND VGND VPWR VPWR _0401_ sky130_fd_sc_hd__a221o_1
XFILLER_0_20_173 VPWR VGND VPWR VGND sky130_ef_sc_hd__decap_12
XPHY_EDGE_ROW_69_Left_143 VGND VGND VPWR VPWR sky130_fd_sc_hd__decap_3
X_2173_ _1114_ _1146_ _1178_ _1221_ VGND VGND VPWR VPWR _1232_ sky130_fd_sc_hd__nand4b_2
XFILLER_0_7_134 VGND VGND VPWR VPWR sky130_fd_sc_hd__decap_8
X_2509_ _1608_ _1611_ _1614_ _1557_ VGND VGND VPWR VPWR _1615_ sky130_fd_sc_hd__a31o_1
X_3558_ _1808_ _1665_ _1664_ _1809_ VGND VGND VPWR VPWR _0615_ sky130_fd_sc_hd__or4b_2
XFILLER_0_31_405 VGND VGND VPWR VPWR sky130_fd_sc_hd__decap_4
X_3627_ _0024_ _1651_ _1703_ VGND VGND VPWR VPWR _0689_ sky130_fd_sc_hd__o21a_1
X_3489_ _1955_ _1561_ _0088_ _0539_ VGND VGND VPWR VPWR _0540_ sky130_fd_sc_hd__a31o_1
XTAP_TAPCELL_ROW_39_452 VGND VPWR sky130_fd_sc_hd__tapvpwrvgnd_1
XFILLER_0_19_251 VGND VGND VPWR VPWR sky130_fd_sc_hd__decap_4
XFILLER_0_19_262 VGND VGND VPWR VPWR sky130_fd_sc_hd__decap_6
XFILLER_0_43_47 VGND VGND VPWR VPWR sky130_fd_sc_hd__fill_2
XFILLER_0_72_327 VGND VGND VPWR VPWR sky130_fd_sc_hd__fill_1
XFILLER_0_57_313 VGND VGND VPWR VPWR sky130_fd_sc_hd__decap_4
XTAP_TAPCELL_ROW_45_499 VGND VPWR sky130_fd_sc_hd__tapvpwrvgnd_1
XFILLER_0_25_243 VGND VGND VPWR VPWR sky130_fd_sc_hd__fill_1
XFILLER_0_25_221 VGND VGND VPWR VPWR sky130_fd_sc_hd__decap_3
X_2791_ _1463_ _1461_ _1253_ _1459_ _1632_ _1562_ VGND VGND VPWR VPWR _1896_ sky130_fd_sc_hd__mux4_1
X_2860_ _1565_ _1581_ _1628_ _1963_ VGND VGND VPWR VPWR _1964_ sky130_fd_sc_hd__a211o_1
XFILLER_0_68_55 VGND VGND VPWR VPWR sky130_fd_sc_hd__decap_8
X_3412_ _0452_ _0455_ _0456_ _0311_ VGND VGND VPWR VPWR _0457_ sky130_fd_sc_hd__a31o_1
XFILLER_0_0_354 VGND VGND VPWR VPWR sky130_fd_sc_hd__decap_8
X_2225_ _1330_ net40 VGND VGND VPWR VPWR _1331_ sky130_fd_sc_hd__and2b_1
X_3274_ _1715_ _1711_ _1718_ _1713_ _0078_ _1721_ VGND VGND VPWR VPWR _0312_ sky130_fd_sc_hd__mux4_2
X_3343_ _0371_ _0372_ _0381_ _0311_ VGND VGND VPWR VPWR _0382_ sky130_fd_sc_hd__a31o_1
XFILLER_0_0_365 VPWR VGND VPWR VGND sky130_ef_sc_hd__decap_12
XFILLER_0_48_324 VGND VGND VPWR VPWR sky130_fd_sc_hd__decap_8
X_2156_ net37 VGND VGND VPWR VPWR _1050_ sky130_fd_sc_hd__clkbuf_4
XPHY_EDGE_ROW_5_Right_5 VGND VGND VPWR VPWR sky130_fd_sc_hd__decap_3
XFILLER_0_8_410 VGND VGND VPWR VPWR sky130_fd_sc_hd__decap_8
XFILLER_0_8_421 VPWR VGND VPWR VGND sky130_ef_sc_hd__decap_12
XFILLER_0_71_393 VPWR VGND VPWR VGND sky130_ef_sc_hd__decap_12
XFILLER_0_63_327 VGND VGND VPWR VPWR sky130_fd_sc_hd__fill_1
X_2989_ _1316_ _0022_ _1728_ _0034_ VGND VGND VPWR VPWR _0035_ sky130_fd_sc_hd__o31a_1
XFILLER_0_16_232 VGND VGND VPWR VPWR sky130_fd_sc_hd__fill_1
XFILLER_0_3_192 VGND VGND VPWR VPWR sky130_fd_sc_hd__fill_2
XFILLER_0_39_335 VGND VGND VPWR VPWR sky130_fd_sc_hd__fill_1
XFILLER_0_62_393 VPWR VGND VPWR VGND sky130_ef_sc_hd__decap_12
XFILLER_0_22_213 VGND VGND VPWR VPWR sky130_fd_sc_hd__decap_8
X_2912_ _2009_ _2010_ _2011_ _2013_ _2015_ VGND VGND VPWR VPWR _2016_ sky130_fd_sc_hd__a311oi_1
XTAP_TAPCELL_ROW_58_591 VGND VPWR sky130_fd_sc_hd__tapvpwrvgnd_1
XFILLER_0_57_110 VGND VGND VPWR VPWR sky130_fd_sc_hd__fill_2
X_3961_ _1799_ _1801_ _1044_ _1045_ VGND VGND VPWR VPWR _1046_ sky130_fd_sc_hd__o211ai_1
XTAP_TAPCELL_ROW_33_403 VGND VPWR sky130_fd_sc_hd__tapvpwrvgnd_1
XFILLER_0_9_207 VGND VGND VPWR VPWR sky130_fd_sc_hd__fill_1
X_2843_ _1313_ _1421_ _1946_ VGND VGND VPWR VPWR _1947_ sky130_fd_sc_hd__a21oi_1
X_2774_ _1877_ _1878_ _1657_ _1869_ VGND VGND VPWR VPWR _1879_ sky130_fd_sc_hd__o22ai_4
XFILLER_0_53_393 VGND VGND VPWR VPWR sky130_fd_sc_hd__decap_8
XFILLER_0_13_202 VGND VGND VPWR VPWR sky130_fd_sc_hd__fill_2
X_3892_ _1050_ _1471_ _1529_ _0972_ VGND VGND VPWR VPWR _0973_ sky130_fd_sc_hd__o211ai_2
X_3326_ _0304_ _0306_ _0364_ VGND VGND VPWR VPWR _2058_ sky130_fd_sc_hd__o21ai_1
X_3188_ _1318_ _0228_ _0229_ _2038_ VGND VGND VPWR VPWR _0231_ sky130_fd_sc_hd__a31o_1
XFILLER_0_68_419 VGND VGND VPWR VPWR sky130_fd_sc_hd__fill_1
X_2139_ net49 net17 VGND VGND VPWR VPWR _0869_ sky130_fd_sc_hd__or2b_1
X_3257_ net92 net91 net94 net93 VGND VGND VPWR VPWR _0296_ sky130_fd_sc_hd__or4_1
X_2208_ _1313_ VGND VGND VPWR VPWR _1314_ sky130_fd_sc_hd__clkbuf_4
XFILLER_0_63_113 VGND VGND VPWR VPWR sky130_fd_sc_hd__fill_2
XFILLER_0_63_102 VGND VGND VPWR VPWR sky130_fd_sc_hd__decap_8
XFILLER_0_48_176 VGND VGND VPWR VPWR sky130_fd_sc_hd__fill_2
XFILLER_0_48_121 VGND VGND VPWR VPWR sky130_fd_sc_hd__fill_1
XFILLER_0_36_327 VGND VGND VPWR VPWR sky130_fd_sc_hd__decap_4
XFILLER_0_36_305 VGND VGND VPWR VPWR sky130_fd_sc_hd__decap_3
XFILLER_0_44_371 VPWR VGND VPWR VGND sky130_ef_sc_hd__decap_12
XFILLER_0_44_360 VGND VGND VPWR VPWR sky130_fd_sc_hd__decap_4
XFILLER_0_8_295 VGND VGND VPWR VPWR sky130_fd_sc_hd__decap_6
XFILLER_0_12_290 VPWR VGND VPWR VGND sky130_ef_sc_hd__decap_12
XTAP_TAPCELL_ROW_55_572 VGND VPWR sky130_fd_sc_hd__tapvpwrvgnd_1
XFILLER_0_54_168 VGND VGND VPWR VPWR sky130_fd_sc_hd__fill_1
XFILLER_0_39_187 VPWR VGND VPWR VGND sky130_ef_sc_hd__decap_12
XFILLER_0_35_360 VPWR VGND VPWR VGND sky130_ef_sc_hd__decap_12
XFILLER_0_27_305 VGND VGND VPWR VPWR sky130_fd_sc_hd__decap_8
X_2490_ _1315_ _1575_ VGND VGND VPWR VPWR _1596_ sky130_fd_sc_hd__or2b_1
X_4160_ _1258_ _2024_ _1450_ VGND VGND VPWR VPWR _1259_ sky130_fd_sc_hd__a21oi_1
XFILLER_0_62_190 VGND VGND VPWR VPWR sky130_fd_sc_hd__decap_6
XFILLER_0_50_352 VGND VGND VPWR VPWR sky130_fd_sc_hd__decap_8
XFILLER_0_50_330 VPWR VGND VPWR VGND sky130_ef_sc_hd__decap_12
XFILLER_0_49_57 VGND VGND VPWR VPWR sky130_fd_sc_hd__fill_1
XFILLER_0_4_15 VGND VGND VPWR VPWR sky130_fd_sc_hd__decap_4
X_3042_ net24 VGND VGND VPWR VPWR _0087_ sky130_fd_sc_hd__buf_2
XFILLER_0_65_67 VGND VGND VPWR VPWR sky130_fd_sc_hd__fill_1
X_3111_ _1683_ _0794_ _0772_ _0004_ VGND VGND VPWR VPWR _0155_ sky130_fd_sc_hd__a2bb2o_1
X_4091_ _1177_ _1179_ _0592_ _1180_ net110 VGND VGND VPWR VPWR _1185_ sky130_fd_sc_hd__o221a_1
XFILLER_0_4_37 VGND VGND VPWR VPWR sky130_fd_sc_hd__decap_3
XFILLER_0_73_433 VGND VGND VPWR VPWR sky130_fd_sc_hd__decap_4
X_3875_ _0218_ _1560_ _1556_ VGND VGND VPWR VPWR _0955_ sky130_fd_sc_hd__a21o_1
XFILLER_0_45_135 VGND VGND VPWR VPWR sky130_fd_sc_hd__decap_6
XFILLER_0_45_113 VGND VGND VPWR VPWR sky130_fd_sc_hd__fill_1
X_3944_ _1521_ _1535_ _0632_ _1823_ VGND VGND VPWR VPWR _1028_ sky130_fd_sc_hd__a31o_1
XFILLER_0_18_305 VGND VGND VPWR VPWR sky130_fd_sc_hd__decap_3
XTAP_TAPCELL_ROW_18_296 VGND VPWR sky130_fd_sc_hd__tapvpwrvgnd_1
X_2826_ _1806_ _1928_ _0847_ _1930_ VGND VGND VPWR VPWR _1931_ sky130_fd_sc_hd__o2bb2a_1
X_2688_ _1503_ _0384_ _1792_ _1501_ _1793_ VGND VGND VPWR VPWR _1794_ sky130_fd_sc_hd__a41o_1
X_2757_ _1576_ _1478_ _1861_ VGND VGND VPWR VPWR _1862_ sky130_fd_sc_hd__o21ai_2
XFILLER_0_5_221 VGND VGND VPWR VPWR sky130_fd_sc_hd__decap_3
X_3309_ _1541_ _1664_ VGND VGND VPWR VPWR _0347_ sky130_fd_sc_hd__nand2_1
XTAP_TAPCELL_ROW_69_675 VGND VPWR sky130_fd_sc_hd__tapvpwrvgnd_1
XFILLER_0_49_430 VGND VGND VPWR VPWR sky130_fd_sc_hd__fill_1
XTAP_TAPCELL_ROW_1_164 VGND VPWR sky130_fd_sc_hd__tapvpwrvgnd_1
XPHY_EDGE_ROW_32_Left_106 VGND VGND VPWR VPWR sky130_fd_sc_hd__decap_3
XFILLER_0_59_249 VGND VGND VPWR VPWR sky130_fd_sc_hd__decap_8
XFILLER_0_27_113 VGND VGND VPWR VPWR sky130_fd_sc_hd__decap_6
XFILLER_0_27_102 VGND VGND VPWR VPWR sky130_fd_sc_hd__decap_8
XFILLER_0_42_149 VGND VGND VPWR VPWR sky130_fd_sc_hd__decap_6
XFILLER_0_42_116 VGND VGND VPWR VPWR sky130_fd_sc_hd__decap_8
XPHY_EDGE_ROW_41_Left_115 VGND VGND VPWR VPWR sky130_fd_sc_hd__decap_3
X_2611_ _1716_ _1572_ VGND VGND VPWR VPWR _1717_ sky130_fd_sc_hd__nand2_1
XFILLER_0_35_190 VGND VGND VPWR VPWR sky130_fd_sc_hd__fill_1
X_2542_ _1571_ _1301_ VGND VGND VPWR VPWR _1648_ sky130_fd_sc_hd__nor2_2
X_3660_ _0716_ _1944_ _0717_ _0724_ VGND VGND VPWR VPWR _0725_ sky130_fd_sc_hd__o31a_1
XFILLER_0_23_374 VPWR VGND VPWR VGND sky130_ef_sc_hd__decap_12
X_3591_ _0607_ _0649_ _1381_ VGND VGND VPWR VPWR _0650_ sky130_fd_sc_hd__a21oi_1
X_4212_ clknet_2_2__leaf_clk _2078_ net122 VGND VGND VPWR VPWR net95 sky130_fd_sc_hd__dfrtp_1
XFILLER_0_62_9 VGND VGND VPWR VPWR sky130_fd_sc_hd__fill_1
X_4143_ _0427_ _1431_ _1240_ VGND VGND VPWR VPWR _1241_ sky130_fd_sc_hd__o21ai_1
XPHY_EDGE_ROW_50_Left_124 VGND VGND VPWR VPWR sky130_fd_sc_hd__decap_3
XFILLER_0_2_268 VGND VGND VPWR VPWR sky130_fd_sc_hd__fill_2
X_2473_ _1577_ _1459_ _1578_ VGND VGND VPWR VPWR _1579_ sky130_fd_sc_hd__a21oi_1
XTAP_TAPCELL_ROW_66_656 VGND VPWR sky130_fd_sc_hd__tapvpwrvgnd_1
X_4074_ _1337_ _2032_ _2033_ _1166_ VGND VGND VPWR VPWR _1167_ sky130_fd_sc_hd__a31o_1
X_3025_ _1703_ VGND VGND VPWR VPWR _0070_ sky130_fd_sc_hd__clkbuf_4
XFILLER_0_25_70 VGND VGND VPWR VPWR sky130_fd_sc_hd__decap_8
XFILLER_0_73_296 VGND VGND VPWR VPWR sky130_fd_sc_hd__fill_1
X_3927_ _1314_ _1422_ _1009_ VGND VGND VPWR VPWR _1010_ sky130_fd_sc_hd__a21o_1
X_3858_ _1471_ _1444_ _0428_ _0429_ VGND VGND VPWR VPWR _0937_ sky130_fd_sc_hd__o211a_1
XFILLER_0_18_102 VGND VGND VPWR VPWR sky130_fd_sc_hd__fill_1
X_3789_ _1591_ _0037_ _0035_ VGND VGND VPWR VPWR _0863_ sky130_fd_sc_hd__or3_1
XFILLER_0_41_193 VGND VGND VPWR VPWR sky130_fd_sc_hd__decap_3
X_2809_ _1913_ VGND VGND VPWR VPWR _1914_ sky130_fd_sc_hd__clkbuf_4
XFILLER_0_26_190 VGND VGND VPWR VPWR sky130_fd_sc_hd__decap_6
XTAP_TAPCELL_ROW_6_201 VGND VPWR sky130_fd_sc_hd__tapvpwrvgnd_1
XFILLER_0_5_91 VGND VGND VPWR VPWR sky130_fd_sc_hd__decap_8
XFILLER_0_49_293 VGND VGND VPWR VPWR sky130_fd_sc_hd__decap_8
XFILLER_0_52_436 VGND VGND VPWR VPWR sky130_fd_sc_hd__fill_1
XFILLER_0_21_28 VPWR VGND VPWR VGND sky130_ef_sc_hd__decap_12
XTAP_TAPCELL_ROW_12_247 VGND VPWR sky130_fd_sc_hd__tapvpwrvgnd_1
XFILLER_0_1_27 VPWR VGND VPWR VGND sky130_ef_sc_hd__decap_12
XTAP_TAPCELL_ROW_71_692 VGND VPWR sky130_fd_sc_hd__tapvpwrvgnd_1
XFILLER_0_55_230 VGND VGND VPWR VPWR sky130_fd_sc_hd__decap_3
X_3712_ net118 _1613_ _0771_ _0774_ _0779_ VGND VGND VPWR VPWR _0780_ sky130_fd_sc_hd__a311oi_1
XFILLER_0_7_327 VGND VGND VPWR VPWR sky130_fd_sc_hd__fill_2
X_2525_ _1451_ _1478_ _1423_ _1449_ _1570_ _1627_ VGND VGND VPWR VPWR _1631_ sky130_fd_sc_hd__mux4_1
X_3574_ _0584_ _0585_ _0587_ _0631_ VGND VGND VPWR VPWR _2085_ sky130_fd_sc_hd__o211ai_1
XFILLER_0_23_160 VGND VGND VPWR VPWR sky130_fd_sc_hd__decap_8
X_3643_ _0705_ _0041_ _1557_ VGND VGND VPWR VPWR _0706_ sky130_fd_sc_hd__a21oi_1
X_2387_ _1484_ _1489_ _1424_ _1492_ VGND VGND VPWR VPWR _1493_ sky130_fd_sc_hd__a31o_1
X_4126_ _1561_ _0206_ _1557_ VGND VGND VPWR VPWR _1223_ sky130_fd_sc_hd__a21oi_1
XFILLER_0_39_3 VPWR VGND VPWR VGND sky130_ef_sc_hd__decap_12
X_2456_ _1306_ VGND VGND VPWR VPWR _1562_ sky130_fd_sc_hd__clkbuf_4
X_3008_ _0922_ _1350_ _1946_ _1349_ VGND VGND VPWR VPWR _0053_ sky130_fd_sc_hd__a31o_1
X_4057_ _0024_ _0544_ _0810_ _0067_ VGND VGND VPWR VPWR _1149_ sky130_fd_sc_hd__o2bb2a_1
XFILLER_0_61_233 VGND VGND VPWR VPWR sky130_fd_sc_hd__decap_8
XFILLER_0_6_360 VGND VGND VPWR VPWR sky130_fd_sc_hd__decap_4
XTAP_TAPCELL_ROW_60_607 VGND VPWR sky130_fd_sc_hd__tapvpwrvgnd_1
XFILLER_0_37_274 VGND VGND VPWR VPWR sky130_fd_sc_hd__decap_6
XFILLER_0_40_417 VGND VGND VPWR VPWR sky130_fd_sc_hd__decap_3
XFILLER_0_20_141 VGND VGND VPWR VPWR sky130_fd_sc_hd__fill_1
XFILLER_0_12_119 VGND VGND VPWR VPWR sky130_fd_sc_hd__decap_4
X_2241_ net20 VGND VGND VPWR VPWR _1347_ sky130_fd_sc_hd__buf_2
X_3290_ _1479_ _1478_ _1451_ _1449_ _1618_ _1894_ VGND VGND VPWR VPWR _0328_ sky130_fd_sc_hd__mux4_1
XFILLER_0_57_57 VPWR VGND VPWR VGND sky130_ef_sc_hd__decap_12
X_2310_ _1401_ _1405_ _1415_ VGND VGND VPWR VPWR _1416_ sky130_fd_sc_hd__a21oi_2
X_2172_ _1189_ _1210_ VGND VGND VPWR VPWR _1221_ sky130_fd_sc_hd__nand2b_2
XFILLER_0_43_266 VPWR VGND VPWR VGND sky130_ef_sc_hd__decap_12
XFILLER_0_28_230 VGND VGND VPWR VPWR sky130_fd_sc_hd__decap_6
XFILLER_0_22_60 VPWR VGND VPWR VGND sky130_ef_sc_hd__decap_12
X_3488_ _1591_ _0073_ VGND VGND VPWR VPWR _0539_ sky130_fd_sc_hd__nor2_1
X_2508_ _1612_ _1613_ VGND VGND VPWR VPWR _1614_ sky130_fd_sc_hd__nand2_4
X_3626_ _0024_ _1651_ _0683_ _0684_ _0687_ VGND VGND VPWR VPWR _0688_ sky130_fd_sc_hd__o32a_1
X_3557_ _1284_ _1926_ _1922_ net60 VGND VGND VPWR VPWR _0614_ sky130_fd_sc_hd__a22oi_1
X_4109_ _1338_ _1937_ _1447_ VGND VGND VPWR VPWR _1205_ sky130_fd_sc_hd__o21ai_1
XTAP_TAPCELL_ROW_39_453 VGND VPWR sky130_fd_sc_hd__tapvpwrvgnd_1
X_2439_ _1544_ VGND VGND VPWR VPWR _1545_ sky130_fd_sc_hd__clkbuf_8
XTAP_TAPCELL_ROW_22_320 VGND VPWR sky130_fd_sc_hd__tapvpwrvgnd_1
XFILLER_0_19_296 VGND VGND VPWR VPWR sky130_fd_sc_hd__decap_6
XTAP_TAPCELL_ROW_73_710 VGND VPWR sky130_fd_sc_hd__tapvpwrvgnd_1
XFILLER_0_69_141 VGND VGND VPWR VPWR sky130_fd_sc_hd__fill_2
XFILLER_0_43_15 VGND VGND VPWR VPWR sky130_fd_sc_hd__decap_6
XFILLER_0_72_306 VGND VGND VPWR VPWR sky130_fd_sc_hd__fill_2
XFILLER_0_25_255 VGND VGND VPWR VPWR sky130_fd_sc_hd__decap_4
XFILLER_0_4_138 VGND VGND VPWR VPWR sky130_fd_sc_hd__fill_2
X_2790_ _1458_ _1456_ _1455_ _1453_ _1894_ _1694_ VGND VGND VPWR VPWR _1895_ sky130_fd_sc_hd__mux4_1
X_3342_ _1910_ _1841_ _0380_ _1646_ _0083_ VGND VGND VPWR VPWR _0381_ sky130_fd_sc_hd__a221o_1
X_3411_ _1954_ _0107_ _1959_ VGND VGND VPWR VPWR _0456_ sky130_fd_sc_hd__or3_1
XFILLER_0_0_377 VGND VGND VPWR VPWR sky130_fd_sc_hd__decap_8
XFILLER_0_7_15 VPWR VGND VPWR VGND sky130_ef_sc_hd__decap_12
X_3273_ _2004_ VGND VGND VPWR VPWR _0311_ sky130_fd_sc_hd__clkbuf_4
X_2224_ net8 VGND VGND VPWR VPWR _1330_ sky130_fd_sc_hd__clkbuf_4
X_2155_ _1029_ net6 VGND VGND VPWR VPWR _1040_ sky130_fd_sc_hd__xnor2_2
XFILLER_0_48_314 VGND VGND VPWR VPWR sky130_fd_sc_hd__decap_4
XFILLER_0_33_81 VGND VGND VPWR VPWR sky130_fd_sc_hd__decap_3
XFILLER_0_8_433 VGND VGND VPWR VPWR sky130_fd_sc_hd__decap_4
X_2988_ _0033_ _1840_ VGND VGND VPWR VPWR _0034_ sky130_fd_sc_hd__nand2_1
X_3609_ _1364_ _0353_ _0667_ _0668_ _0669_ VGND VGND VPWR VPWR _0670_ sky130_fd_sc_hd__a2111oi_1
XFILLER_0_39_303 VPWR VGND VPWR VGND sky130_ef_sc_hd__decap_12
XPHY_EDGE_ROW_11_Right_11 VGND VGND VPWR VPWR sky130_fd_sc_hd__decap_3
XFILLER_0_62_372 VGND VGND VPWR VPWR sky130_fd_sc_hd__fill_1
XPHY_EDGE_ROW_20_Right_20 VGND VGND VPWR VPWR sky130_fd_sc_hd__decap_3
XFILLER_0_38_37 VGND VGND VPWR VPWR sky130_fd_sc_hd__fill_2
X_2911_ _1945_ _1667_ _2014_ net51 VGND VGND VPWR VPWR _2015_ sky130_fd_sc_hd__a22o_1
XTAP_TAPCELL_ROW_58_592 VGND VPWR sky130_fd_sc_hd__tapvpwrvgnd_1
X_3960_ net40 _1009_ _1778_ _0632_ _0600_ VGND VGND VPWR VPWR _1045_ sky130_fd_sc_hd__a221o_1
XTAP_TAPCELL_ROW_33_404 VGND VPWR sky130_fd_sc_hd__tapvpwrvgnd_1
X_3891_ _1071_ _0903_ _1773_ _1772_ VGND VGND VPWR VPWR _0972_ sky130_fd_sc_hd__o211ai_1
X_2842_ _1945_ VGND VGND VPWR VPWR _1946_ sky130_fd_sc_hd__clkbuf_4
X_2773_ _1315_ _1632_ VGND VGND VPWR VPWR _1878_ sky130_fd_sc_hd__nand2_2
XFILLER_0_60_309 VPWR VGND VPWR VGND sky130_ef_sc_hd__decap_12
X_3256_ net83 net82 net85 net84 VGND VGND VPWR VPWR _0295_ sky130_fd_sc_hd__or4_1
X_3325_ _0304_ _0308_ _0310_ _0362_ VGND VGND VPWR VPWR _0364_ sky130_fd_sc_hd__a211oi_1
XFILLER_0_21_291 VGND VGND VPWR VPWR sky130_fd_sc_hd__fill_1
XFILLER_0_0_141 VGND VGND VPWR VPWR sky130_fd_sc_hd__fill_2
XFILLER_0_0_163 VGND VGND VPWR VPWR sky130_fd_sc_hd__decap_4
X_3187_ _0228_ _0229_ _1318_ VGND VGND VPWR VPWR _0230_ sky130_fd_sc_hd__a21oi_1
X_2138_ net17 net49 VGND VGND VPWR VPWR _0858_ sky130_fd_sc_hd__or2b_1
X_2207_ _1312_ VGND VGND VPWR VPWR _1313_ sky130_fd_sc_hd__clkbuf_4
XFILLER_0_21_3 VGND VGND VPWR VPWR sky130_fd_sc_hd__decap_8
XFILLER_0_63_169 VPWR VGND VPWR VGND sky130_ef_sc_hd__decap_12
XFILLER_0_29_391 VGND VGND VPWR VPWR sky130_fd_sc_hd__fill_1
XFILLER_0_8_263 VGND VGND VPWR VPWR sky130_fd_sc_hd__decap_8
XFILLER_0_44_383 VPWR VGND VPWR VGND sky130_ef_sc_hd__decap_12
XTAP_TAPCELL_ROW_55_573 VGND VPWR sky130_fd_sc_hd__tapvpwrvgnd_1
XFILLER_0_39_166 VGND VGND VPWR VPWR sky130_fd_sc_hd__fill_2
XFILLER_0_50_342 VGND VGND VPWR VPWR sky130_fd_sc_hd__decap_4
XFILLER_0_35_372 VGND VGND VPWR VPWR sky130_fd_sc_hd__decap_8
XFILLER_0_35_350 VGND VGND VPWR VPWR sky130_fd_sc_hd__fill_2
X_3110_ _0772_ _0794_ VGND VGND VPWR VPWR _0154_ sky130_fd_sc_hd__nor2_2
XFILLER_0_4_27 VGND VGND VPWR VPWR sky130_fd_sc_hd__fill_1
X_4090_ _1338_ _1923_ _1181_ _1182_ _1183_ VGND VGND VPWR VPWR _1184_ sky130_fd_sc_hd__a2111oi_1
X_3041_ _1427_ _0031_ VGND VGND VPWR VPWR _0086_ sky130_fd_sc_hd__nand2_1
XFILLER_0_45_169 VGND VGND VPWR VPWR sky130_fd_sc_hd__decap_6
X_3943_ _1535_ _1521_ _0622_ _0611_ VGND VGND VPWR VPWR _1027_ sky130_fd_sc_hd__o2bb2a_1
X_3874_ _0939_ _0948_ _0952_ VGND VGND VPWR VPWR _0953_ sky130_fd_sc_hd__o21ba_1
X_2825_ _1929_ VGND VGND VPWR VPWR _1930_ sky130_fd_sc_hd__buf_4
XFILLER_0_14_50 VGND VGND VPWR VPWR sky130_fd_sc_hd__decap_3
XTAP_TAPCELL_ROW_18_297 VGND VPWR sky130_fd_sc_hd__tapvpwrvgnd_1
XFILLER_0_69_3 VPWR VGND VPWR VGND sky130_ef_sc_hd__decap_12
X_2687_ net16 _0449_ _0427_ _1451_ VGND VGND VPWR VPWR _1793_ sky130_fd_sc_hd__o211a_1
X_2756_ _1337_ _1566_ VGND VGND VPWR VPWR _1861_ sky130_fd_sc_hd__nand2_1
XFILLER_0_41_397 VGND VGND VPWR VPWR sky130_fd_sc_hd__decap_4
X_3239_ _0061_ net116 _0229_ VGND VGND VPWR VPWR _0281_ sky130_fd_sc_hd__a21boi_1
XTAP_TAPCELL_ROW_69_676 VGND VPWR sky130_fd_sc_hd__tapvpwrvgnd_1
XFILLER_0_39_80 VPWR VGND VPWR VGND sky130_ef_sc_hd__decap_12
X_3308_ _0331_ _0332_ _1615_ _0345_ VGND VGND VPWR VPWR _0346_ sky130_fd_sc_hd__o2bb2a_1
XTAP_TAPCELL_ROW_1_165 VGND VPWR sky130_fd_sc_hd__tapvpwrvgnd_1
XFILLER_0_36_147 VPWR VGND VPWR VGND sky130_ef_sc_hd__decap_12
XFILLER_0_32_331 VGND VGND VPWR VPWR sky130_fd_sc_hd__fill_2
XFILLER_0_32_353 VGND VGND VPWR VPWR sky130_fd_sc_hd__decap_4
XFILLER_0_19_28 VGND VGND VPWR VPWR sky130_fd_sc_hd__fill_1
XFILLER_0_59_206 VGND VGND VPWR VPWR sky130_fd_sc_hd__fill_2
XFILLER_0_67_272 VGND VGND VPWR VPWR sky130_fd_sc_hd__fill_2
XFILLER_0_55_412 VGND VGND VPWR VPWR sky130_fd_sc_hd__decap_3
XFILLER_0_27_169 VGND VGND VPWR VPWR sky130_fd_sc_hd__decap_8
XFILLER_0_42_139 VGND VGND VPWR VPWR sky130_fd_sc_hd__fill_1
X_2610_ net9 VGND VGND VPWR VPWR _1716_ sky130_fd_sc_hd__inv_2
X_3590_ _1285_ _1286_ _1756_ VGND VGND VPWR VPWR _0649_ sky130_fd_sc_hd__a21oi_1
X_2472_ _1563_ net27 VGND VGND VPWR VPWR _1578_ sky130_fd_sc_hd__and2b_1
X_2541_ _1566_ _1585_ _1510_ net58 net59 VGND VGND VPWR VPWR _1647_ sky130_fd_sc_hd__o41a_4
X_4211_ clknet_2_3__leaf_clk _2077_ net123 VGND VGND VPWR VPWR net94 sky130_fd_sc_hd__dfrtp_1
X_4142_ _1452_ _1443_ _1940_ _1941_ VGND VGND VPWR VPWR _1240_ sky130_fd_sc_hd__o211a_1
X_4073_ _1336_ _1937_ _1446_ VGND VGND VPWR VPWR _1166_ sky130_fd_sc_hd__o21ai_1
XTAP_TAPCELL_ROW_66_657 VGND VPWR sky130_fd_sc_hd__tapvpwrvgnd_1
X_3024_ _1721_ _1698_ VGND VGND VPWR VPWR _0069_ sky130_fd_sc_hd__or2_1
XFILLER_0_73_286 VGND VGND VPWR VPWR sky130_fd_sc_hd__decap_4
XFILLER_0_73_253 VGND VGND VPWR VPWR sky130_fd_sc_hd__fill_2
X_2808_ net67 net68 net117 VGND VGND VPWR VPWR _1913_ sky130_fd_sc_hd__and3_2
X_3926_ _1330_ VGND VGND VPWR VPWR _1009_ sky130_fd_sc_hd__buf_2
X_3788_ _1865_ _2057_ _0855_ _0857_ _0861_ VGND VGND VPWR VPWR _0862_ sky130_fd_sc_hd__o2111a_1
X_3857_ _0910_ _0913_ _0917_ _0935_ VGND VGND VPWR VPWR _0936_ sky130_fd_sc_hd__o211a_1
X_2739_ _1587_ _1588_ _1842_ _1843_ VGND VGND VPWR VPWR _1844_ sky130_fd_sc_hd__or4_1
XTAP_TAPCELL_ROW_6_202 VGND VPWR sky130_fd_sc_hd__tapvpwrvgnd_1
XFILLER_0_64_253 VGND VGND VPWR VPWR sky130_fd_sc_hd__decap_4
XFILLER_0_32_150 VPWR VGND VPWR VGND sky130_ef_sc_hd__decap_12
XTAP_TAPCELL_ROW_12_248 VGND VPWR sky130_fd_sc_hd__tapvpwrvgnd_1
XFILLER_0_32_194 VGND VGND VPWR VPWR sky130_fd_sc_hd__fill_2
XTAP_TAPCELL_ROW_28_370 VGND VPWR sky130_fd_sc_hd__tapvpwrvgnd_1
XFILLER_0_1_39 VPWR VGND VPWR VGND sky130_ef_sc_hd__decap_12
XTAP_TAPCELL_ROW_71_693 VGND VPWR sky130_fd_sc_hd__tapvpwrvgnd_1
XPHY_EDGE_ROW_23_Left_97 VGND VGND VPWR VPWR sky130_fd_sc_hd__decap_3
X_3642_ _1972_ _0377_ _0497_ VGND VGND VPWR VPWR _0705_ sky130_fd_sc_hd__o21a_1
X_3711_ _1518_ _0349_ _0004_ _1516_ _0778_ VGND VGND VPWR VPWR _0779_ sky130_fd_sc_hd__a221o_1
X_2455_ _1560_ VGND VGND VPWR VPWR _1561_ sky130_fd_sc_hd__clkbuf_4
XPHY_EDGE_ROW_49_Right_49 VGND VGND VPWR VPWR sky130_fd_sc_hd__decap_3
X_2524_ _1617_ _1620_ _1624_ _1626_ _1627_ _1629_ VGND VGND VPWR VPWR _1630_ sky130_fd_sc_hd__mux4_2
X_3573_ _0311_ _0595_ _0606_ _0630_ VGND VGND VPWR VPWR _0631_ sky130_fd_sc_hd__o211a_1
XPHY_EDGE_ROW_58_Right_58 VGND VGND VPWR VPWR sky130_fd_sc_hd__decap_3
X_4056_ _1502_ _1145_ _1147_ VGND VGND VPWR VPWR _1148_ sky130_fd_sc_hd__a21o_1
X_4125_ _0080_ _0639_ _0640_ _1116_ VGND VGND VPWR VPWR _1222_ sky130_fd_sc_hd__o211ai_1
X_2386_ _1491_ VGND VGND VPWR VPWR _1492_ sky130_fd_sc_hd__clkbuf_4
X_3007_ _2044_ _2047_ _0049_ _0052_ VGND VGND VPWR VPWR _2077_ sky130_fd_sc_hd__nand4_1
XPHY_EDGE_ROW_67_Right_67 VGND VGND VPWR VPWR sky130_fd_sc_hd__decap_3
XFILLER_0_61_267 VPWR VGND VPWR VGND sky130_ef_sc_hd__decap_12
X_3909_ _1728_ _1642_ _0085_ _0093_ _0990_ VGND VGND VPWR VPWR _0991_ sky130_fd_sc_hd__o41a_1
XFILLER_0_6_372 VPWR VGND VPWR VGND sky130_ef_sc_hd__decap_12
XFILLER_0_69_312 VPWR VGND VPWR VGND sky130_ef_sc_hd__decap_12
XFILLER_0_16_29 VGND VGND VPWR VPWR sky130_fd_sc_hd__fill_2
XTAP_TAPCELL_ROW_60_608 VGND VPWR sky130_fd_sc_hd__tapvpwrvgnd_1
XFILLER_0_4_309 VGND VGND VPWR VPWR sky130_fd_sc_hd__decap_8
XFILLER_0_52_267 VGND VGND VPWR VPWR sky130_fd_sc_hd__decap_4
XFILLER_0_12_109 VGND VGND VPWR VPWR sky130_fd_sc_hd__decap_4
X_2240_ _1322_ _0858_ _1321_ VGND VGND VPWR VPWR _1346_ sky130_fd_sc_hd__o21bai_1
XFILLER_0_57_69 VPWR VGND VPWR VGND sky130_ef_sc_hd__decap_12
X_2171_ net35 _1200_ VGND VGND VPWR VPWR _1210_ sky130_fd_sc_hd__nand2_1
XFILLER_0_73_57 VPWR VGND VPWR VGND sky130_ef_sc_hd__decap_12
XFILLER_0_28_242 VGND VGND VPWR VPWR sky130_fd_sc_hd__decap_8
XFILLER_0_43_278 VGND VGND VPWR VPWR sky130_fd_sc_hd__fill_2
X_3625_ _0251_ _0267_ _1986_ _1643_ _0685_ VGND VGND VPWR VPWR _0687_ sky130_fd_sc_hd__o311a_1
XFILLER_0_28_297 VGND VGND VPWR VPWR sky130_fd_sc_hd__fill_2
XFILLER_0_28_275 VGND VGND VPWR VPWR sky130_fd_sc_hd__decap_6
XFILLER_0_28_253 VGND VGND VPWR VPWR sky130_fd_sc_hd__fill_2
XFILLER_0_3_353 VGND VGND VPWR VPWR sky130_fd_sc_hd__decap_3
X_2507_ _1548_ VGND VGND VPWR VPWR _1613_ sky130_fd_sc_hd__clkbuf_4
X_3487_ _2032_ _2033_ _0242_ VGND VGND VPWR VPWR _0538_ sky130_fd_sc_hd__a21oi_1
X_2438_ _1537_ _1539_ _1541_ _1543_ VGND VGND VPWR VPWR _1544_ sky130_fd_sc_hd__a31o_1
X_3556_ _0610_ _1696_ _1427_ _1491_ VGND VGND VPWR VPWR _0613_ sky130_fd_sc_hd__a31o_1
X_4108_ _1177_ _1441_ VGND VGND VPWR VPWR _1204_ sky130_fd_sc_hd__nor2_1
XFILLER_0_47_91 VPWR VGND VPWR VGND sky130_ef_sc_hd__decap_12
XTAP_TAPCELL_ROW_39_454 VGND VPWR sky130_fd_sc_hd__tapvpwrvgnd_1
X_4039_ _1900_ _0025_ _0027_ _0070_ _1707_ VGND VGND VPWR VPWR _1130_ sky130_fd_sc_hd__o2111ai_1
XFILLER_0_2_93 VGND VGND VPWR VPWR sky130_fd_sc_hd__decap_3
X_2369_ net6 VGND VGND VPWR VPWR _1475_ sky130_fd_sc_hd__clkbuf_4
XFILLER_0_34_223 VGND VGND VPWR VPWR sky130_fd_sc_hd__decap_8
XTAP_TAPCELL_ROW_22_321 VGND VPWR sky130_fd_sc_hd__tapvpwrvgnd_1
XFILLER_0_19_286 VGND VGND VPWR VPWR sky130_fd_sc_hd__decap_3
XFILLER_0_22_407 VPWR VGND VPWR VGND sky130_ef_sc_hd__decap_12
XTAP_TAPCELL_ROW_73_711 VGND VPWR sky130_fd_sc_hd__tapvpwrvgnd_1
XFILLER_0_57_337 VGND VGND VPWR VPWR sky130_fd_sc_hd__decap_8
XFILLER_0_43_27 VPWR VGND VPWR VGND sky130_ef_sc_hd__decap_12
XFILLER_0_7_27 VGND VGND VPWR VPWR sky130_fd_sc_hd__decap_8
X_3272_ _0654_ _1325_ _1429_ _0309_ VGND VGND VPWR VPWR _0310_ sky130_fd_sc_hd__o31a_1
X_3410_ _0065_ _0453_ _0454_ _1707_ VGND VGND VPWR VPWR _0455_ sky130_fd_sc_hd__a211o_1
X_3341_ _0068_ _0376_ _0379_ VGND VGND VPWR VPWR _0380_ sky130_fd_sc_hd__a21o_1
XFILLER_0_0_323 VGND VGND VPWR VPWR sky130_fd_sc_hd__fill_2
X_2223_ net9 net41 VGND VGND VPWR VPWR _1329_ sky130_fd_sc_hd__and2b_1
X_2154_ net38 VGND VGND VPWR VPWR _1029_ sky130_fd_sc_hd__clkbuf_4
X_2987_ _1347_ net21 net22 net24 _1593_ _1586_ VGND VGND VPWR VPWR _0033_ sky130_fd_sc_hd__mux4_1
XTAP_TAPCELL_ROW_44_490 VGND VPWR sky130_fd_sc_hd__tapvpwrvgnd_1
XFILLER_0_3_161 VGND VGND VPWR VPWR sky130_fd_sc_hd__fill_1
X_3608_ _1458_ _1667_ _2014_ net61 VGND VGND VPWR VPWR _0669_ sky130_fd_sc_hd__a22o_1
X_3539_ _1592_ _0208_ _0136_ VGND VGND VPWR VPWR _0594_ sky130_fd_sc_hd__or3_1
XPHY_EDGE_ROW_10_Left_84 VGND VGND VPWR VPWR sky130_fd_sc_hd__decap_3
XFILLER_0_66_112 VGND VGND VPWR VPWR sky130_fd_sc_hd__decap_8
XFILLER_0_39_337 VPWR VGND VPWR VGND sky130_ef_sc_hd__decap_12
XFILLER_0_39_315 VPWR VGND VPWR VGND sky130_ef_sc_hd__decap_12
XFILLER_0_66_167 VGND VGND VPWR VPWR sky130_fd_sc_hd__decap_8
XFILLER_0_62_351 VGND VGND VPWR VPWR sky130_fd_sc_hd__decap_3
XFILLER_0_54_307 VGND VGND VPWR VPWR sky130_fd_sc_hd__fill_1
XFILLER_0_38_27 VGND VGND VPWR VPWR sky130_fd_sc_hd__fill_1
XTAP_TAPCELL_ROW_58_593 VGND VPWR sky130_fd_sc_hd__tapvpwrvgnd_1
XFILLER_0_54_26 VGND VGND VPWR VPWR sky130_fd_sc_hd__fill_2
X_2841_ net19 VGND VGND VPWR VPWR _1945_ sky130_fd_sc_hd__buf_2
X_2910_ _1664_ _1538_ _1541_ _1679_ VGND VGND VPWR VPWR _2014_ sky130_fd_sc_hd__a31o_2
XTAP_TAPCELL_ROW_33_405 VGND VPWR sky130_fd_sc_hd__tapvpwrvgnd_1
X_3890_ _1741_ _0912_ _1040_ VGND VGND VPWR VPWR _0971_ sky130_fd_sc_hd__o21ai_1
X_2772_ _1593_ VGND VGND VPWR VPWR _1877_ sky130_fd_sc_hd__clkbuf_8
XFILLER_0_53_384 VGND VGND VPWR VPWR sky130_fd_sc_hd__decap_8
XFILLER_0_53_351 VGND VGND VPWR VPWR sky130_fd_sc_hd__fill_2
XFILLER_0_0_120 VGND VGND VPWR VPWR sky130_fd_sc_hd__decap_8
X_3255_ net88 net87 net90 net89 VGND VGND VPWR VPWR _0294_ sky130_fd_sc_hd__or4_1
X_2206_ _0654_ _0815_ _0976_ _1311_ VGND VGND VPWR VPWR _1312_ sky130_fd_sc_hd__or4_2
X_3324_ _0311_ _0327_ _0346_ _0361_ VGND VGND VPWR VPWR _0362_ sky130_fd_sc_hd__o211ai_1
XFILLER_0_0_153 VGND VGND VPWR VPWR sky130_fd_sc_hd__decap_4
XFILLER_0_0_197 VGND VGND VPWR VPWR sky130_fd_sc_hd__fill_2
X_3186_ _0762_ _0154_ _0794_ VGND VGND VPWR VPWR _0229_ sky130_fd_sc_hd__a21oi_1
X_2137_ _0836_ VGND VGND VPWR VPWR _0847_ sky130_fd_sc_hd__buf_2
XFILLER_0_44_81 VGND VGND VPWR VPWR sky130_fd_sc_hd__decap_3
XFILLER_0_14_3 VGND VGND VPWR VPWR sky130_fd_sc_hd__fill_1
XFILLER_0_48_167 VGND VGND VPWR VPWR sky130_fd_sc_hd__decap_6
XFILLER_0_44_340 VGND VGND VPWR VPWR sky130_fd_sc_hd__fill_2
XFILLER_0_71_192 VGND VGND VPWR VPWR sky130_fd_sc_hd__fill_2
XFILLER_0_44_395 VPWR VGND VPWR VGND sky130_ef_sc_hd__decap_12
XTAP_TAPCELL_ROW_47_508 VGND VPWR sky130_fd_sc_hd__tapvpwrvgnd_1
XTAP_TAPCELL_ROW_4_185 VGND VPWR sky130_fd_sc_hd__tapvpwrvgnd_1
XTAP_TAPCELL_ROW_55_574 VGND VPWR sky130_fd_sc_hd__tapvpwrvgnd_1
XFILLER_0_54_148 VPWR VGND VPWR VGND sky130_ef_sc_hd__decap_12
XFILLER_0_49_37 VPWR VGND VPWR VGND sky130_ef_sc_hd__decap_12
XFILLER_0_65_36 VPWR VGND VPWR VGND sky130_ef_sc_hd__decap_12
XFILLER_0_58_421 VPWR VGND VPWR VGND sky130_ef_sc_hd__decap_12
XFILLER_0_58_410 VGND VGND VPWR VPWR sky130_fd_sc_hd__decap_8
X_3040_ _1315_ net59 VGND VGND VPWR VPWR _0085_ sky130_fd_sc_hd__nand2_2
X_2824_ _1683_ VGND VGND VPWR VPWR _1929_ sky130_fd_sc_hd__clkbuf_4
XFILLER_0_60_118 VGND VGND VPWR VPWR sky130_fd_sc_hd__fill_1
X_3942_ _0632_ _1778_ _1828_ VGND VGND VPWR VPWR _1026_ sky130_fd_sc_hd__o21ai_1
XFILLER_0_18_318 VGND VGND VPWR VPWR sky130_fd_sc_hd__fill_1
X_3873_ _0939_ _1667_ _2014_ _1029_ _0951_ VGND VGND VPWR VPWR _0952_ sky130_fd_sc_hd__a221o_1
X_2755_ _1618_ _1805_ _1859_ VGND VGND VPWR VPWR _1860_ sky130_fd_sc_hd__o21ai_1
X_2686_ _1338_ net14 _1336_ _1479_ VGND VGND VPWR VPWR _1792_ sky130_fd_sc_hd__a22o_1
XFILLER_0_41_376 VPWR VGND VPWR VGND sky130_ef_sc_hd__decap_12
XFILLER_0_26_384 VGND VGND VPWR VPWR sky130_fd_sc_hd__decap_6
XTAP_TAPCELL_ROW_69_677 VGND VPWR sky130_fd_sc_hd__tapvpwrvgnd_1
X_3238_ _0265_ _0277_ _0279_ VGND VGND VPWR VPWR _0280_ sky130_fd_sc_hd__and3_1
XFILLER_0_39_92 VPWR VGND VPWR VGND sky130_ef_sc_hd__decap_12
X_3307_ _0032_ _0339_ _0344_ VGND VGND VPWR VPWR _0345_ sky130_fd_sc_hd__o21ai_2
X_3169_ _1587_ _1956_ _1880_ _1957_ _1699_ VGND VGND VPWR VPWR _0212_ sky130_fd_sc_hd__a221o_1
XFILLER_0_49_410 VPWR VGND VPWR VGND sky130_ef_sc_hd__decap_12
XTAP_TAPCELL_ROW_1_166 VGND VPWR sky130_fd_sc_hd__tapvpwrvgnd_1
XFILLER_0_36_159 VPWR VGND VPWR VGND sky130_ef_sc_hd__decap_12
XFILLER_0_3_3 VPWR VGND VPWR VGND sky130_ef_sc_hd__decap_12
XFILLER_0_70_405 VPWR VGND VPWR VGND sky130_ef_sc_hd__decap_12
XFILLER_0_67_295 VPWR VGND VPWR VGND sky130_ef_sc_hd__decap_12
XFILLER_0_55_435 VGND VGND VPWR VPWR sky130_fd_sc_hd__fill_2
XTAP_TAPCELL_ROW_15_268 VGND VPWR sky130_fd_sc_hd__tapvpwrvgnd_1
X_4210_ clknet_2_3__leaf_clk _2076_ net122 VGND VGND VPWR VPWR net93 sky130_fd_sc_hd__dfrtp_1
X_2471_ _1576_ VGND VGND VPWR VPWR _1577_ sky130_fd_sc_hd__buf_4
X_2540_ _1645_ VGND VGND VPWR VPWR _1646_ sky130_fd_sc_hd__clkbuf_4
X_4141_ _1341_ _2032_ _2033_ _1238_ VGND VGND VPWR VPWR _1239_ sky130_fd_sc_hd__a31o_1
X_4072_ _1143_ _1144_ _1148_ _1164_ VGND VGND VPWR VPWR _1165_ sky130_fd_sc_hd__o211a_1
X_3023_ _1731_ VGND VGND VPWR VPWR _0068_ sky130_fd_sc_hd__clkbuf_4
X_3925_ _0996_ _0999_ _1004_ _1007_ VGND VGND VPWR VPWR _2064_ sky130_fd_sc_hd__nand4_1
XFILLER_0_18_126 VPWR VGND VPWR VGND sky130_ef_sc_hd__decap_12
X_2807_ _1709_ _1891_ _1899_ _1904_ _1911_ VGND VGND VPWR VPWR _1912_ sky130_fd_sc_hd__a32o_1
XFILLER_0_41_71 VGND VGND VPWR VPWR sky130_fd_sc_hd__decap_8
X_3856_ _0926_ _0930_ _0934_ VGND VGND VPWR VPWR _0935_ sky130_fd_sc_hd__and3_1
X_2738_ _1599_ _1693_ _1751_ VGND VGND VPWR VPWR _1843_ sky130_fd_sc_hd__a21boi_4
X_3787_ _1391_ _1926_ _1923_ net35 _0860_ VGND VGND VPWR VPWR _0861_ sky130_fd_sc_hd__a221oi_2
XFILLER_0_14_365 VGND VGND VPWR VPWR sky130_fd_sc_hd__decap_4
XTAP_TAPCELL_ROW_6_203 VGND VPWR sky130_fd_sc_hd__tapvpwrvgnd_1
X_2669_ net39 _0986_ _1029_ _1475_ VGND VGND VPWR VPWR _1775_ sky130_fd_sc_hd__o211a_1
XTAP_TAPCELL_ROW_12_249 VGND VPWR sky130_fd_sc_hd__tapvpwrvgnd_1
XFILLER_0_32_162 VPWR VGND VPWR VGND sky130_ef_sc_hd__decap_12
XTAP_TAPCELL_ROW_63_628 VGND VPWR sky130_fd_sc_hd__tapvpwrvgnd_1
XFILLER_0_62_48 VPWR VGND VPWR VGND sky130_ef_sc_hd__decap_12
XTAP_TAPCELL_ROW_28_371 VGND VPWR sky130_fd_sc_hd__tapvpwrvgnd_1
XTAP_TAPCELL_ROW_71_694 VGND VPWR sky130_fd_sc_hd__tapvpwrvgnd_1
XFILLER_0_70_279 VGND VGND VPWR VPWR sky130_fd_sc_hd__decap_8
XFILLER_0_55_221 VGND VGND VPWR VPWR sky130_fd_sc_hd__decap_3
XFILLER_0_43_416 VGND VGND VPWR VPWR sky130_fd_sc_hd__fill_1
X_3572_ _0403_ _0594_ _0624_ _0625_ _0629_ VGND VGND VPWR VPWR _0630_ sky130_fd_sc_hd__o2111a_1
X_3641_ _1967_ _0496_ _0703_ VGND VGND VPWR VPWR _0704_ sky130_fd_sc_hd__o21ai_1
XFILLER_0_7_307 VGND VGND VPWR VPWR sky130_fd_sc_hd__decap_3
X_3710_ _0764_ _1928_ _0151_ _0032_ _0777_ VGND VGND VPWR VPWR _0778_ sky130_fd_sc_hd__a221o_1
X_2454_ _1559_ VGND VGND VPWR VPWR _1560_ sky130_fd_sc_hd__clkbuf_4
X_2385_ _1437_ _1433_ _1490_ VGND VGND VPWR VPWR _1491_ sky130_fd_sc_hd__or3_4
X_2523_ _1628_ VGND VGND VPWR VPWR _1629_ sky130_fd_sc_hd__buf_4
X_3006_ _2048_ _0050_ _0051_ VGND VGND VPWR VPWR _0052_ sky130_fd_sc_hd__o21ai_1
X_4055_ _1502_ _1145_ _1828_ VGND VGND VPWR VPWR _1147_ sky130_fd_sc_hd__o21ai_1
X_4124_ _0064_ _0065_ _1218_ _1219_ VGND VGND VPWR VPWR _1220_ sky130_fd_sc_hd__o31a_1
XFILLER_0_36_82 VGND VGND VPWR VPWR sky130_fd_sc_hd__fill_2
Xinput1 A[0] VGND VGND VPWR VPWR net1 sky130_fd_sc_hd__buf_1
XFILLER_0_46_210 VGND VGND VPWR VPWR sky130_fd_sc_hd__decap_8
X_3908_ _1474_ _1673_ _1676_ _1008_ _0559_ VGND VGND VPWR VPWR _0990_ sky130_fd_sc_hd__o221a_1
XFILLER_0_61_279 VGND VGND VPWR VPWR sky130_fd_sc_hd__fill_1
X_3839_ _1743_ _0899_ _1742_ VGND VGND VPWR VPWR _0916_ sky130_fd_sc_hd__a21oi_1
XFILLER_0_6_384 VPWR VGND VPWR VGND sky130_ef_sc_hd__decap_12
XFILLER_0_14_151 VPWR VGND VPWR VGND sky130_ef_sc_hd__decap_12
XFILLER_0_14_195 VGND VGND VPWR VPWR sky130_fd_sc_hd__fill_1
XFILLER_0_69_324 VPWR VGND VPWR VGND sky130_ef_sc_hd__decap_12
XFILLER_0_69_302 VGND VGND VPWR VPWR sky130_fd_sc_hd__fill_1
XTAP_TAPCELL_ROW_60_609 VGND VPWR sky130_fd_sc_hd__tapvpwrvgnd_1
XFILLER_0_32_29 VGND VGND VPWR VPWR sky130_fd_sc_hd__decap_4
XFILLER_0_52_246 VGND VGND VPWR VPWR sky130_fd_sc_hd__decap_6
XFILLER_0_37_287 VGND VGND VPWR VPWR sky130_fd_sc_hd__fill_1
XFILLER_0_37_232 VGND VGND VPWR VPWR sky130_fd_sc_hd__decap_6
XFILLER_0_57_15 VGND VGND VPWR VPWR sky130_fd_sc_hd__decap_8
XPHY_EDGE_ROW_29_Left_103 VGND VGND VPWR VPWR sky130_fd_sc_hd__decap_3
XFILLER_0_73_69 VPWR VGND VPWR VGND sky130_ef_sc_hd__decap_12
X_2170_ net3 VGND VGND VPWR VPWR _1200_ sky130_fd_sc_hd__clkbuf_4
XPHY_EDGE_ROW_38_Left_112 VGND VGND VPWR VPWR sky130_fd_sc_hd__decap_3
XPHY_EDGE_ROW_47_Left_121 VGND VGND VPWR VPWR sky130_fd_sc_hd__decap_3
X_3624_ _1905_ _1908_ _0375_ _1906_ _0078_ _1900_ VGND VGND VPWR VPWR _0685_ sky130_fd_sc_hd__mux4_2
XTAP_TAPCELL_ROW_31_388 VGND VPWR sky130_fd_sc_hd__tapvpwrvgnd_1
XFILLER_0_22_95 VPWR VGND VPWR VGND sky130_ef_sc_hd__decap_12
X_3555_ _0610_ _1427_ _1696_ VGND VGND VPWR VPWR _0612_ sky130_fd_sc_hd__a21oi_1
X_2506_ net69 net66 net65 VGND VGND VPWR VPWR _1612_ sky130_fd_sc_hd__nor3b_4
X_2437_ _1542_ VGND VGND VPWR VPWR _1543_ sky130_fd_sc_hd__buf_4
XFILLER_0_44_3 VGND VGND VPWR VPWR sky130_fd_sc_hd__decap_8
X_3486_ _0337_ _1939_ VGND VGND VPWR VPWR _0537_ sky130_fd_sc_hd__nor2_1
X_2368_ _0986_ VGND VGND VPWR VPWR _1474_ sky130_fd_sc_hd__clkbuf_4
XFILLER_0_66_305 VGND VGND VPWR VPWR sky130_fd_sc_hd__decap_3
XFILLER_0_63_80 VGND VGND VPWR VPWR sky130_fd_sc_hd__fill_1
XPHY_EDGE_ROW_56_Left_130 VGND VGND VPWR VPWR sky130_fd_sc_hd__decap_3
X_4107_ _1201_ _2024_ _1177_ VGND VGND VPWR VPWR _1203_ sky130_fd_sc_hd__a21oi_1
X_4038_ _1900_ _1704_ _0017_ _1706_ VGND VGND VPWR VPWR _1129_ sky130_fd_sc_hd__a31o_1
XFILLER_0_2_83 VGND VGND VPWR VPWR sky130_fd_sc_hd__fill_1
X_2299_ _1403_ _1404_ _1040_ _1061_ _1071_ VGND VGND VPWR VPWR _1405_ sky130_fd_sc_hd__o2111a_2
XFILLER_0_34_213 VGND VGND VPWR VPWR sky130_fd_sc_hd__fill_2
XTAP_TAPCELL_ROW_22_322 VGND VPWR sky130_fd_sc_hd__tapvpwrvgnd_1
XFILLER_0_22_419 VGND VGND VPWR VPWR sky130_fd_sc_hd__fill_1
XTAP_TAPCELL_ROW_73_712 VGND VPWR sky130_fd_sc_hd__tapvpwrvgnd_1
XFILLER_0_69_187 VPWR VGND VPWR VGND sky130_ef_sc_hd__decap_12
XFILLER_0_43_39 VGND VGND VPWR VPWR sky130_fd_sc_hd__decap_8
XFILLER_0_40_238 VGND VGND VPWR VPWR sky130_fd_sc_hd__fill_2
XFILLER_0_25_279 VGND VGND VPWR VPWR sky130_fd_sc_hd__fill_1
XFILLER_0_4_118 VPWR VGND VPWR VGND sky130_ef_sc_hd__decap_12
X_3271_ _1362_ _1418_ _1808_ _1809_ _2010_ VGND VGND VPWR VPWR _0309_ sky130_fd_sc_hd__o2111a_1
X_2222_ _0503_ _0514_ _0535_ _0546_ VGND VGND VPWR VPWR _1328_ sky130_fd_sc_hd__nand4_1
X_3340_ _0074_ _0377_ _0378_ _1700_ VGND VGND VPWR VPWR _0379_ sky130_fd_sc_hd__o211a_1
XFILLER_0_0_335 VGND VGND VPWR VPWR sky130_fd_sc_hd__fill_1
XFILLER_0_48_305 VGND VGND VPWR VPWR sky130_fd_sc_hd__decap_3
XTAP_TAPCELL_ROW_36_425 VGND VPWR sky130_fd_sc_hd__tapvpwrvgnd_1
X_2153_ _0997_ _1008_ VGND VGND VPWR VPWR _1018_ sky130_fd_sc_hd__nand2_2
XFILLER_0_17_73 VPWR VGND VPWR VGND sky130_ef_sc_hd__decap_12
X_2986_ _0031_ VGND VGND VPWR VPWR _0032_ sky130_fd_sc_hd__clkbuf_4
XTAP_TAPCELL_ROW_44_491 VGND VPWR sky130_fd_sc_hd__tapvpwrvgnd_1
XFILLER_0_16_246 VGND VGND VPWR VPWR sky130_fd_sc_hd__decap_6
Xinput70 rst_n VGND VGND VPWR VPWR net70 sky130_fd_sc_hd__clkbuf_1
X_3538_ _0065_ _0591_ _0592_ _1707_ VGND VGND VPWR VPWR _0593_ sky130_fd_sc_hd__a211o_1
XFILLER_0_3_140 VGND VGND VPWR VPWR sky130_fd_sc_hd__fill_1
X_3607_ _1759_ net117 _1670_ _1925_ _1288_ VGND VGND VPWR VPWR _0668_ sky130_fd_sc_hd__a32o_1
X_3469_ _1295_ _1297_ _1672_ _1674_ _0333_ VGND VGND VPWR VPWR _0519_ sky130_fd_sc_hd__o32a_1
XFILLER_0_39_349 VPWR VGND VPWR VGND sky130_ef_sc_hd__decap_12
XFILLER_0_39_327 VGND VGND VPWR VPWR sky130_fd_sc_hd__decap_8
XFILLER_0_47_393 VGND VGND VPWR VPWR sky130_fd_sc_hd__fill_2
XFILLER_0_47_382 VGND VGND VPWR VPWR sky130_fd_sc_hd__fill_2
XTAP_TAPCELL_ROW_58_594 VGND VPWR sky130_fd_sc_hd__tapvpwrvgnd_1
XFILLER_0_70_15 VPWR VGND VPWR VGND sky130_ef_sc_hd__decap_12
XFILLER_0_57_113 VPWR VGND VPWR VGND sky130_ef_sc_hd__decap_12
XFILLER_0_53_330 VGND VGND VPWR VPWR sky130_fd_sc_hd__decap_6
XFILLER_0_38_371 VGND VGND VPWR VPWR sky130_fd_sc_hd__decap_6
X_2840_ _1433_ _1490_ _1437_ VGND VGND VPWR VPWR _1944_ sky130_fd_sc_hd__or3b_2
XTAP_TAPCELL_ROW_33_406 VGND VPWR sky130_fd_sc_hd__tapvpwrvgnd_1
XFILLER_0_5_405 VPWR VGND VPWR VGND sky130_ef_sc_hd__decap_12
X_2771_ _1699_ VGND VGND VPWR VPWR _1876_ sky130_fd_sc_hd__clkbuf_4
XFILLER_0_0_132 VGND VGND VPWR VPWR sky130_fd_sc_hd__decap_8
XPHY_EDGE_ROW_9_Right_9 VGND VGND VPWR VPWR sky130_fd_sc_hd__decap_3
X_3185_ _0061_ net116 VGND VGND VPWR VPWR _0228_ sky130_fd_sc_hd__nand2_1
X_3254_ _2038_ _0697_ _0290_ _0293_ VGND VGND VPWR VPWR _2091_ sky130_fd_sc_hd__o31ai_1
X_3323_ _1606_ _0347_ _1312_ _0348_ _0360_ VGND VGND VPWR VPWR _0361_ sky130_fd_sc_hd__o311a_1
X_2205_ _1243_ _1294_ _1300_ _1310_ VGND VGND VPWR VPWR _1311_ sky130_fd_sc_hd__nand4_4
X_2136_ net50 net18 VGND VGND VPWR VPWR _0836_ sky130_fd_sc_hd__and2_1
XFILLER_0_63_127 VGND VGND VPWR VPWR sky130_fd_sc_hd__fill_2
XFILLER_0_60_81 VGND VGND VPWR VPWR sky130_fd_sc_hd__decap_3
X_2969_ _1724_ _0013_ _1876_ _0014_ VGND VGND VPWR VPWR _0015_ sky130_fd_sc_hd__o211a_1
XFILLER_0_8_93 VGND VGND VPWR VPWR sky130_fd_sc_hd__decap_3
XTAP_TAPCELL_ROW_47_509 VGND VPWR sky130_fd_sc_hd__tapvpwrvgnd_1
XTAP_TAPCELL_ROW_4_186 VGND VPWR sky130_fd_sc_hd__tapvpwrvgnd_1
XFILLER_0_39_113 VGND VGND VPWR VPWR sky130_fd_sc_hd__decap_8
XFILLER_0_62_171 VGND VGND VPWR VPWR sky130_fd_sc_hd__decap_6
XFILLER_0_49_49 VGND VGND VPWR VPWR sky130_fd_sc_hd__decap_6
XFILLER_0_2_419 VGND VGND VPWR VPWR sky130_fd_sc_hd__fill_1
XFILLER_0_65_48 VGND VGND VPWR VPWR sky130_fd_sc_hd__decap_8
XFILLER_0_65_15 VGND VGND VPWR VPWR sky130_fd_sc_hd__fill_1
XFILLER_0_4_29 VGND VGND VPWR VPWR sky130_fd_sc_hd__decap_8
XFILLER_0_58_433 VGND VGND VPWR VPWR sky130_fd_sc_hd__decap_4
X_3941_ _0611_ _1024_ _0622_ VGND VGND VPWR VPWR _1025_ sky130_fd_sc_hd__nor3_1
X_2754_ net17 _1575_ VGND VGND VPWR VPWR _1859_ sky130_fd_sc_hd__or2b_1
X_2823_ _1666_ VGND VGND VPWR VPWR _1928_ sky130_fd_sc_hd__buf_4
XFILLER_0_26_363 VGND VGND VPWR VPWR sky130_fd_sc_hd__fill_1
XFILLER_0_14_85 VGND VGND VPWR VPWR sky130_fd_sc_hd__fill_1
X_3872_ _1029_ _1475_ _1925_ _0950_ VGND VGND VPWR VPWR _0951_ sky130_fd_sc_hd__a31o_1
X_2685_ _1783_ _1784_ _1787_ _1788_ _1790_ VGND VGND VPWR VPWR _1791_ sky130_fd_sc_hd__o221a_1
XFILLER_0_41_388 VGND VGND VPWR VPWR sky130_fd_sc_hd__decap_4
XFILLER_0_30_95 VPWR VGND VPWR VGND sky130_ef_sc_hd__decap_12
X_3306_ _0340_ _1955_ _2053_ _0343_ VGND VGND VPWR VPWR _0344_ sky130_fd_sc_hd__a211o_1
XTAP_TAPCELL_ROW_69_678 VGND VPWR sky130_fd_sc_hd__tapvpwrvgnd_1
X_3237_ _0091_ _0278_ _1969_ _0126_ VGND VGND VPWR VPWR _0279_ sky130_fd_sc_hd__or4_1
X_2119_ _0492_ _0643_ VGND VGND VPWR VPWR _0654_ sky130_fd_sc_hd__nand2_1
X_3168_ _1611_ VGND VGND VPWR VPWR _0211_ sky130_fd_sc_hd__clkbuf_4
XTAP_TAPCELL_ROW_1_167 VGND VPWR sky130_fd_sc_hd__tapvpwrvgnd_1
XFILLER_0_64_403 VPWR VGND VPWR VGND sky130_ef_sc_hd__decap_12
X_3099_ _1862_ _1858_ _1853_ _1851_ _1697_ _1588_ VGND VGND VPWR VPWR _0143_ sky130_fd_sc_hd__mux4_1
XTAP_TAPCELL_ROW_52_545 VGND VPWR sky130_fd_sc_hd__tapvpwrvgnd_1
XFILLER_0_49_422 VGND VGND VPWR VPWR sky130_fd_sc_hd__decap_8
XTAP_TAPCELL_ROW_9_223 VGND VPWR sky130_fd_sc_hd__tapvpwrvgnd_1
XFILLER_0_67_252 VPWR VGND VPWR VGND sky130_ef_sc_hd__decap_12
XFILLER_0_70_417 VGND VGND VPWR VPWR sky130_fd_sc_hd__decap_3
XFILLER_0_55_403 VGND VGND VPWR VPWR sky130_fd_sc_hd__decap_4
XFILLER_0_27_127 VPWR VGND VPWR VGND sky130_ef_sc_hd__decap_12
XTAP_TAPCELL_ROW_15_269 VGND VPWR sky130_fd_sc_hd__tapvpwrvgnd_1
X_2470_ _1575_ VGND VGND VPWR VPWR _1576_ sky130_fd_sc_hd__buf_4
X_4140_ _0427_ _1937_ _1446_ VGND VGND VPWR VPWR _1238_ sky130_fd_sc_hd__o21ai_1
X_4071_ _1692_ _1149_ _1158_ _1163_ VGND VGND VPWR VPWR _1164_ sky130_fd_sc_hd__o211a_1
X_3022_ _0066_ _1892_ _1695_ _1900_ VGND VGND VPWR VPWR _0067_ sky130_fd_sc_hd__a22oi_4
XFILLER_0_73_233 VGND VGND VPWR VPWR sky130_fd_sc_hd__fill_1
XFILLER_0_58_285 VGND VGND VPWR VPWR sky130_fd_sc_hd__fill_1
X_3924_ _1005_ _0973_ _2038_ _1006_ VGND VGND VPWR VPWR _1007_ sky130_fd_sc_hd__a211o_1
XFILLER_0_18_138 VGND VGND VPWR VPWR sky130_fd_sc_hd__fill_2
XFILLER_0_73_266 VGND VGND VPWR VPWR sky130_fd_sc_hd__decap_3
XFILLER_0_61_406 VPWR VGND VPWR VGND sky130_ef_sc_hd__decap_12
X_2737_ _1374_ VGND VGND VPWR VPWR _1842_ sky130_fd_sc_hd__buf_2
X_2806_ _1909_ _1910_ _1709_ VGND VGND VPWR VPWR _1911_ sky130_fd_sc_hd__a21oi_1
X_3855_ _1622_ _0931_ _0932_ VGND VGND VPWR VPWR _0934_ sky130_fd_sc_hd__o21ai_1
X_3786_ _0001_ _1189_ _1467_ _1674_ _0859_ VGND VGND VPWR VPWR _0860_ sky130_fd_sc_hd__o221ai_2
X_2668_ _1772_ _1741_ _1773_ VGND VGND VPWR VPWR _1774_ sky130_fd_sc_hd__o21ai_1
XFILLER_0_66_80 VGND VGND VPWR VPWR sky130_fd_sc_hd__decap_4
X_2599_ _1701_ _1704_ _1589_ VGND VGND VPWR VPWR _1705_ sky130_fd_sc_hd__a21boi_2
XTAP_TAPCELL_ROW_6_204 VGND VPWR sky130_fd_sc_hd__tapvpwrvgnd_1
XFILLER_0_49_263 VGND VGND VPWR VPWR sky130_fd_sc_hd__decap_8
XFILLER_0_49_252 VGND VGND VPWR VPWR sky130_fd_sc_hd__fill_2
XFILLER_0_32_174 VPWR VGND VPWR VGND sky130_ef_sc_hd__decap_12
XFILLER_0_32_141 VGND VGND VPWR VPWR sky130_fd_sc_hd__decap_4
XTAP_TAPCELL_ROW_63_629 VGND VPWR sky130_fd_sc_hd__tapvpwrvgnd_1
XFILLER_0_28_436 VGND VGND VPWR VPWR sky130_fd_sc_hd__fill_1
XFILLER_0_28_425 VGND VGND VPWR VPWR sky130_fd_sc_hd__fill_1
XTAP_TAPCELL_ROW_28_372 VGND VPWR sky130_fd_sc_hd__tapvpwrvgnd_1
X_3640_ _1582_ _0021_ VGND VGND VPWR VPWR _0703_ sky130_fd_sc_hd__nand2_1
X_3571_ _0601_ _0628_ _0211_ VGND VGND VPWR VPWR _0629_ sky130_fd_sc_hd__a21o_1
X_2522_ net55 VGND VGND VPWR VPWR _1628_ sky130_fd_sc_hd__clkinv_4
XFILLER_0_11_314 VGND VGND VPWR VPWR sky130_fd_sc_hd__decap_6
XFILLER_0_60_9 VGND VGND VPWR VPWR sky130_fd_sc_hd__fill_1
X_2384_ net68 net67 _1434_ VGND VGND VPWR VPWR _1490_ sky130_fd_sc_hd__nand3b_4
X_4123_ _0689_ _0217_ _0810_ _0213_ VGND VGND VPWR VPWR _1219_ sky130_fd_sc_hd__o2bb2a_1
X_2453_ net58 VGND VGND VPWR VPWR _1559_ sky130_fd_sc_hd__buf_2
X_3005_ _0050_ _2048_ _2026_ VGND VGND VPWR VPWR _0051_ sky130_fd_sc_hd__a21oi_1
X_4054_ _1781_ _1024_ _1791_ VGND VGND VPWR VPWR _1145_ sky130_fd_sc_hd__o21ai_2
Xinput2 A[10] VGND VGND VPWR VPWR net2 sky130_fd_sc_hd__buf_2
XFILLER_0_46_299 VGND VGND VPWR VPWR sky130_fd_sc_hd__decap_3
X_3907_ _1008_ _0256_ _1928_ _1474_ _0988_ VGND VGND VPWR VPWR _0989_ sky130_fd_sc_hd__a221oi_1
X_3838_ _1744_ _0914_ _1742_ _1743_ VGND VGND VPWR VPWR _0915_ sky130_fd_sc_hd__o211a_1
XFILLER_0_6_396 VGND VGND VPWR VPWR sky130_fd_sc_hd__fill_2
X_3769_ _1221_ _1157_ _0808_ VGND VGND VPWR VPWR _0841_ sky130_fd_sc_hd__and3_1
XFILLER_0_14_141 VGND VGND VPWR VPWR sky130_fd_sc_hd__fill_1
XFILLER_0_14_163 VGND VGND VPWR VPWR sky130_fd_sc_hd__decap_6
XFILLER_0_10_391 VGND VGND VPWR VPWR sky130_fd_sc_hd__decap_3
XFILLER_0_40_409 VGND VGND VPWR VPWR sky130_fd_sc_hd__decap_8
XFILLER_0_20_188 VGND VGND VPWR VPWR sky130_fd_sc_hd__fill_2
XFILLER_0_20_155 VPWR VGND VPWR VGND sky130_ef_sc_hd__decap_12
XFILLER_0_73_15 VPWR VGND VPWR VGND sky130_ef_sc_hd__decap_12
XFILLER_0_22_85 VGND VGND VPWR VPWR sky130_fd_sc_hd__decap_6
XFILLER_0_7_149 VGND VGND VPWR VPWR sky130_fd_sc_hd__fill_1
X_2505_ _1610_ VGND VGND VPWR VPWR _1611_ sky130_fd_sc_hd__buf_2
X_3623_ _1643_ _0247_ _0024_ VGND VGND VPWR VPWR _0684_ sky130_fd_sc_hd__o21ai_1
XFILLER_0_31_409 VGND VGND VPWR VPWR sky130_fd_sc_hd__fill_1
XTAP_TAPCELL_ROW_31_389 VGND VPWR sky130_fd_sc_hd__tapvpwrvgnd_1
X_3485_ _0132_ _2032_ _2033_ _1944_ VGND VGND VPWR VPWR _0536_ sky130_fd_sc_hd__a31o_1
X_3554_ _1459_ _0383_ _1461_ _0470_ VGND VGND VPWR VPWR _0610_ sky130_fd_sc_hd__or4_2
X_4106_ _1201_ _1177_ _1487_ _1492_ VGND VGND VPWR VPWR _1202_ sky130_fd_sc_hd__a31o_1
X_2436_ _1434_ _1432_ _1538_ _1436_ VGND VGND VPWR VPWR _1542_ sky130_fd_sc_hd__and4bb_1
XFILLER_0_37_3 VGND VGND VPWR VPWR sky130_fd_sc_hd__decap_8
X_2367_ _1471_ _1472_ VGND VGND VPWR VPWR _1473_ sky130_fd_sc_hd__nor2_1
X_2298_ net39 _0986_ VGND VGND VPWR VPWR _1404_ sky130_fd_sc_hd__nor2_1
XFILLER_0_59_380 VGND VGND VPWR VPWR sky130_fd_sc_hd__fill_2
X_4037_ _1789_ _0092_ _1123_ _1783_ _1127_ VGND VGND VPWR VPWR _1128_ sky130_fd_sc_hd__o221a_1
XFILLER_0_19_222 VGND VGND VPWR VPWR sky130_fd_sc_hd__fill_2
XANTENNA_40 _2057_ VGND VGND VPWR VPWR sky130_fd_sc_hd__diode_2
XTAP_TAPCELL_ROW_22_323 VGND VPWR sky130_fd_sc_hd__tapvpwrvgnd_1
XFILLER_0_19_277 VGND VGND VPWR VPWR sky130_fd_sc_hd__decap_3
XFILLER_0_19_255 VGND VGND VPWR VPWR sky130_fd_sc_hd__fill_1
XTAP_TAPCELL_ROW_73_713 VGND VPWR sky130_fd_sc_hd__tapvpwrvgnd_1
XFILLER_0_72_309 VPWR VGND VPWR VGND sky130_ef_sc_hd__decap_12
XFILLER_0_69_199 VGND VGND VPWR VPWR sky130_fd_sc_hd__fill_1
XFILLER_0_69_177 VGND VGND VPWR VPWR sky130_fd_sc_hd__decap_6
XFILLER_0_69_166 VGND VGND VPWR VPWR sky130_fd_sc_hd__fill_2
XFILLER_0_68_15 VPWR VGND VPWR VGND sky130_ef_sc_hd__decap_12
X_2221_ net43 _1326_ VGND VGND VPWR VPWR _1327_ sky130_fd_sc_hd__and2b_1
X_3270_ _0307_ _1940_ _1446_ _0251_ VGND VGND VPWR VPWR _0308_ sky130_fd_sc_hd__a22o_1
X_2152_ net39 net7 VGND VGND VPWR VPWR _1008_ sky130_fd_sc_hd__or2_1
XTAP_TAPCELL_ROW_36_426 VGND VPWR sky130_fd_sc_hd__tapvpwrvgnd_1
XFILLER_0_17_85 VPWR VGND VPWR VGND sky130_ef_sc_hd__decap_12
XFILLER_0_63_309 VGND VGND VPWR VPWR sky130_fd_sc_hd__decap_6
XFILLER_0_56_394 VPWR VGND VPWR VGND sky130_ef_sc_hd__decap_12
X_2985_ _1559_ VGND VGND VPWR VPWR _0031_ sky130_fd_sc_hd__clkbuf_4
XTAP_TAPCELL_ROW_44_492 VGND VPWR sky130_fd_sc_hd__tapvpwrvgnd_1
X_3537_ _1879_ _1900_ _0070_ VGND VGND VPWR VPWR _0592_ sky130_fd_sc_hd__a21oi_2
Xinput60 B[5] VGND VGND VPWR VPWR net60 sky130_fd_sc_hd__clkbuf_4
Xinput71 valid_in VGND VGND VPWR VPWR net71 sky130_fd_sc_hd__clkbuf_1
X_3468_ _1662_ _0413_ _1644_ _0017_ VGND VGND VPWR VPWR _0518_ sky130_fd_sc_hd__or4b_1
X_3606_ _2017_ _0666_ _1458_ VGND VGND VPWR VPWR _0667_ sky130_fd_sc_hd__a21oi_1
X_3399_ _0441_ _0442_ _0147_ VGND VGND VPWR VPWR _0443_ sky130_fd_sc_hd__o21ai_2
X_2419_ _1524_ _1400_ _1468_ _1389_ VGND VGND VPWR VPWR _1525_ sky130_fd_sc_hd__a31oi_2
XFILLER_0_54_309 VGND VGND VPWR VPWR sky130_fd_sc_hd__decap_8
XFILLER_0_47_361 VPWR VGND VPWR VGND sky130_ef_sc_hd__decap_12
XFILLER_0_38_29 VGND VGND VPWR VPWR sky130_fd_sc_hd__decap_8
XTAP_TAPCELL_ROW_58_595 VGND VPWR sky130_fd_sc_hd__tapvpwrvgnd_1
XFILLER_0_57_125 VGND VGND VPWR VPWR sky130_fd_sc_hd__fill_2
XFILLER_0_57_103 VGND VGND VPWR VPWR sky130_fd_sc_hd__fill_1
XTAP_TAPCELL_ROW_33_407 VGND VPWR sky130_fd_sc_hd__tapvpwrvgnd_1
XFILLER_0_70_27 VGND VGND VPWR VPWR sky130_fd_sc_hd__fill_1
XFILLER_0_57_169 VGND VGND VPWR VPWR sky130_fd_sc_hd__decap_8
X_2770_ _1869_ _1871_ _1316_ _1873_ _1629_ _1874_ VGND VGND VPWR VPWR _1875_ sky130_fd_sc_hd__mux4_2
XFILLER_0_45_309 VGND VGND VPWR VPWR sky130_fd_sc_hd__decap_3
XFILLER_0_38_394 VGND VGND VPWR VPWR sky130_fd_sc_hd__decap_6
XFILLER_0_5_417 VPWR VGND VPWR VGND sky130_ef_sc_hd__decap_12
XFILLER_0_21_250 VPWR VGND VPWR VGND sky130_ef_sc_hd__decap_12
X_3322_ _0350_ _0359_ VGND VGND VPWR VPWR _0360_ sky130_fd_sc_hd__nor2_1
XFILLER_0_0_111 VGND VGND VPWR VPWR sky130_fd_sc_hd__fill_1
X_3184_ _0087_ _0226_ _1810_ VGND VGND VPWR VPWR _0227_ sky130_fd_sc_hd__o21ai_1
X_3253_ _1319_ _0291_ _0292_ _1428_ _1545_ VGND VGND VPWR VPWR _0293_ sky130_fd_sc_hd__o2111ai_1
X_2135_ net50 net18 VGND VGND VPWR VPWR _0826_ sky130_fd_sc_hd__nor2_2
X_2204_ _1303_ _1304_ _1307_ _1309_ VGND VGND VPWR VPWR _1310_ sky130_fd_sc_hd__o211a_1
XFILLER_0_36_309 VGND VGND VPWR VPWR sky130_fd_sc_hd__decap_3
XFILLER_0_29_383 VGND VGND VPWR VPWR sky130_fd_sc_hd__decap_8
XFILLER_0_29_361 VPWR VGND VPWR VGND sky130_ef_sc_hd__decap_12
XFILLER_0_60_93 VGND VGND VPWR VPWR sky130_fd_sc_hd__fill_1
X_2899_ _1434_ _1665_ net67 net68 VGND VGND VPWR VPWR _2003_ sky130_fd_sc_hd__or4b_1
X_2968_ _1724_ _1839_ VGND VGND VPWR VPWR _0014_ sky130_fd_sc_hd__nand2_1
XFILLER_0_12_261 VGND VGND VPWR VPWR sky130_fd_sc_hd__fill_1
XFILLER_0_12_272 VGND VGND VPWR VPWR sky130_fd_sc_hd__decap_3
XTAP_TAPCELL_ROW_4_187 VGND VPWR sky130_fd_sc_hd__tapvpwrvgnd_1
XFILLER_0_54_139 VGND VGND VPWR VPWR sky130_fd_sc_hd__fill_1
XFILLER_0_54_117 VGND VGND VPWR VPWR sky130_fd_sc_hd__decap_4
XFILLER_0_39_169 VGND VGND VPWR VPWR sky130_fd_sc_hd__decap_4
XFILLER_0_39_158 VGND VGND VPWR VPWR sky130_fd_sc_hd__decap_8
XFILLER_0_39_147 VGND VGND VPWR VPWR sky130_fd_sc_hd__fill_2
XFILLER_0_4_19 VGND VGND VPWR VPWR sky130_fd_sc_hd__fill_1
XFILLER_0_73_415 VGND VGND VPWR VPWR sky130_fd_sc_hd__decap_4
X_3940_ _1748_ _1765_ _1777_ VGND VGND VPWR VPWR _1024_ sky130_fd_sc_hd__o21ba_1
X_3871_ _0949_ _1670_ _1609_ _0094_ _1529_ VGND VGND VPWR VPWR _0950_ sky130_fd_sc_hd__a32o_1
X_2822_ net50 _1923_ _0847_ _1926_ VGND VGND VPWR VPWR _1927_ sky130_fd_sc_hd__a22oi_1
X_2753_ _1576_ _1326_ _1857_ VGND VGND VPWR VPWR _1858_ sky130_fd_sc_hd__o21ai_2
X_2684_ net43 _1789_ VGND VGND VPWR VPWR _1790_ sky130_fd_sc_hd__nand2_1
XFILLER_0_30_85 VGND VGND VPWR VPWR sky130_fd_sc_hd__decap_6
XFILLER_0_30_52 VPWR VGND VPWR VGND sky130_ef_sc_hd__decap_12
XFILLER_0_5_225 VGND VGND VPWR VPWR sky130_fd_sc_hd__fill_1
XFILLER_0_39_50 VGND VGND VPWR VPWR sky130_fd_sc_hd__decap_6
X_3305_ _0341_ _0342_ _0022_ VGND VGND VPWR VPWR _0343_ sky130_fd_sc_hd__a21oi_1
XTAP_TAPCELL_ROW_69_679 VGND VPWR sky130_fd_sc_hd__tapvpwrvgnd_1
X_3236_ _1317_ _0087_ _1491_ VGND VGND VPWR VPWR _0278_ sky130_fd_sc_hd__or3_1
X_3167_ _0032_ _0208_ _0209_ _0086_ _0085_ VGND VGND VPWR VPWR _0210_ sky130_fd_sc_hd__o311a_1
X_2118_ _0525_ _0557_ _0600_ _0632_ VGND VGND VPWR VPWR _0643_ sky130_fd_sc_hd__nor4_2
X_3098_ _1559_ VGND VGND VPWR VPWR _0142_ sky130_fd_sc_hd__clkbuf_4
XTAP_TAPCELL_ROW_1_168 VGND VPWR sky130_fd_sc_hd__tapvpwrvgnd_1
XFILLER_0_71_81 VPWR VGND VPWR VGND sky130_ef_sc_hd__decap_12
XFILLER_0_64_415 VGND VGND VPWR VPWR sky130_fd_sc_hd__decap_4
XTAP_TAPCELL_ROW_52_546 VGND VPWR sky130_fd_sc_hd__tapvpwrvgnd_1
XFILLER_0_51_109 VGND VGND VPWR VPWR sky130_fd_sc_hd__decap_3
XFILLER_0_36_139 VGND VGND VPWR VPWR sky130_fd_sc_hd__fill_1
XFILLER_0_17_331 VGND VGND VPWR VPWR sky130_fd_sc_hd__decap_4
XFILLER_0_17_353 VGND VGND VPWR VPWR sky130_fd_sc_hd__fill_1
XFILLER_0_44_194 VGND VGND VPWR VPWR sky130_fd_sc_hd__fill_2
XTAP_TAPCELL_ROW_9_224 VGND VPWR sky130_fd_sc_hd__tapvpwrvgnd_1
XFILLER_0_67_264 VGND VGND VPWR VPWR sky130_fd_sc_hd__decap_8
XFILLER_0_27_139 VGND VGND VPWR VPWR sky130_fd_sc_hd__decap_8
XFILLER_0_2_206 VGND VGND VPWR VPWR sky130_fd_sc_hd__decap_3
X_4070_ _0243_ _1555_ _1162_ VGND VGND VPWR VPWR _1163_ sky130_fd_sc_hd__o21ai_1
X_3021_ _1308_ VGND VGND VPWR VPWR _0066_ sky130_fd_sc_hd__buf_4
XFILLER_0_73_245 VGND VGND VPWR VPWR sky130_fd_sc_hd__decap_3
XFILLER_0_61_418 VGND VGND VPWR VPWR sky130_fd_sc_hd__decap_4
XFILLER_0_58_253 VGND VGND VPWR VPWR sky130_fd_sc_hd__decap_4
X_3854_ _1622_ _0931_ _1492_ VGND VGND VPWR VPWR _0932_ sky130_fd_sc_hd__a21oi_1
X_2805_ _1702_ VGND VGND VPWR VPWR _1910_ sky130_fd_sc_hd__clkbuf_4
X_3923_ _0949_ _0973_ _1018_ VGND VGND VPWR VPWR _1006_ sky130_fd_sc_hd__a21oi_1
XFILLER_0_67_3 VGND VGND VPWR VPWR sky130_fd_sc_hd__decap_8
XFILLER_0_61_429 VGND VGND VPWR VPWR sky130_fd_sc_hd__decap_8
X_2736_ _1833_ _1835_ _1837_ _1839_ _1581_ _1840_ VGND VGND VPWR VPWR _1841_ sky130_fd_sc_hd__mux4_2
X_3785_ _1467_ _1928_ VGND VGND VPWR VPWR _0859_ sky130_fd_sc_hd__nand2_1
X_2667_ _1050_ _1411_ VGND VGND VPWR VPWR _1773_ sky130_fd_sc_hd__nand2_1
X_3219_ _1541_ _2009_ _1317_ _1664_ VGND VGND VPWR VPWR _0261_ sky130_fd_sc_hd__and4_1
X_2598_ _1703_ VGND VGND VPWR VPWR _1704_ sky130_fd_sc_hd__clkbuf_4
XTAP_TAPCELL_ROW_6_205 VGND VPWR sky130_fd_sc_hd__tapvpwrvgnd_1
X_4199_ clknet_2_0__leaf_clk _2064_ net121 VGND VGND VPWR VPWR net81 sky130_fd_sc_hd__dfrtp_1
XFILLER_0_52_418 VGND VGND VPWR VPWR sky130_fd_sc_hd__fill_2
XFILLER_0_9_361 VGND VGND VPWR VPWR sky130_fd_sc_hd__fill_1
XFILLER_0_17_194 VGND VGND VPWR VPWR sky130_fd_sc_hd__decap_8
XFILLER_0_32_197 VGND VGND VPWR VPWR sky130_fd_sc_hd__decap_3
XFILLER_0_32_186 VGND VGND VPWR VPWR sky130_fd_sc_hd__decap_8
XFILLER_0_55_267 VPWR VGND VPWR VGND sky130_ef_sc_hd__decap_12
XFILLER_0_70_204 VGND VGND VPWR VPWR sky130_fd_sc_hd__decap_4
X_3570_ _0627_ _0208_ VGND VGND VPWR VPWR _0628_ sky130_fd_sc_hd__nand2_1
XTAP_TAPCELL_ROW_11_240 VGND VPWR sky130_fd_sc_hd__tapvpwrvgnd_1
XFILLER_0_11_326 VGND VGND VPWR VPWR sky130_fd_sc_hd__fill_1
X_2521_ _1580_ VGND VGND VPWR VPWR _1627_ sky130_fd_sc_hd__buf_4
X_2383_ _1485_ VGND VGND VPWR VPWR _1489_ sky130_fd_sc_hd__clkbuf_4
X_2452_ _1551_ _1555_ _1557_ VGND VGND VPWR VPWR _1558_ sky130_fd_sc_hd__o21ai_4
X_4053_ _1142_ _1500_ _1502_ _1823_ VGND VGND VPWR VPWR _1144_ sky130_fd_sc_hd__a31o_1
X_4122_ _0068_ _1996_ _0214_ VGND VGND VPWR VPWR _1218_ sky130_fd_sc_hd__a21oi_1
XPHY_EDGE_ROW_18_Right_18 VGND VGND VPWR VPWR sky130_fd_sc_hd__decap_3
X_3004_ _1424_ _1806_ _1946_ _1484_ _1487_ VGND VGND VPWR VPWR _0050_ sky130_fd_sc_hd__o41a_1
XPHY_EDGE_ROW_27_Right_27 VGND VGND VPWR VPWR sky130_fd_sc_hd__decap_3
Xinput3 A[11] VGND VGND VPWR VPWR net3 sky130_fd_sc_hd__buf_1
XFILLER_0_52_83 VGND VGND VPWR VPWR sky130_fd_sc_hd__fill_1
XFILLER_0_52_72 VGND VGND VPWR VPWR sky130_fd_sc_hd__fill_1
XFILLER_0_46_278 VGND VGND VPWR VPWR sky130_fd_sc_hd__decap_4
X_3906_ _1403_ _1539_ _1609_ _1679_ net39 VGND VGND VPWR VPWR _0988_ sky130_fd_sc_hd__a32o_1
X_3837_ _1815_ _1519_ _1526_ VGND VGND VPWR VPWR _0914_ sky130_fd_sc_hd__a21oi_1
X_3768_ _1157_ _0808_ _1221_ VGND VGND VPWR VPWR _0840_ sky130_fd_sc_hd__a21oi_1
X_2719_ _1818_ _1323_ _1496_ _1819_ _1823_ VGND VGND VPWR VPWR _1824_ sky130_fd_sc_hd__a311o_1
XPHY_EDGE_ROW_36_Right_36 VGND VGND VPWR VPWR sky130_fd_sc_hd__decap_3
X_3699_ net64 _0426_ _0428_ _0429_ VGND VGND VPWR VPWR _0766_ sky130_fd_sc_hd__o211a_1
XFILLER_0_14_197 VPWR VGND VPWR VGND sky130_ef_sc_hd__decap_12
XFILLER_0_69_337 VPWR VGND VPWR VGND sky130_ef_sc_hd__decap_12
XPHY_EDGE_ROW_45_Right_45 VGND VGND VPWR VPWR sky130_fd_sc_hd__decap_3
XFILLER_0_37_223 VGND VGND VPWR VPWR sky130_fd_sc_hd__fill_1
XTAP_TAPCELL_ROW_25_343 VGND VPWR sky130_fd_sc_hd__tapvpwrvgnd_1
XPHY_EDGE_ROW_54_Right_54 VGND VGND VPWR VPWR sky130_fd_sc_hd__decap_3
XFILLER_0_20_167 VGND VGND VPWR VPWR sky130_fd_sc_hd__fill_1
XFILLER_0_73_27 VGND VGND VPWR VPWR sky130_fd_sc_hd__fill_1
XPHY_EDGE_ROW_63_Right_63 VGND VGND VPWR VPWR sky130_fd_sc_hd__decap_3
X_3622_ _0324_ _1728_ _0086_ _0080_ _0682_ VGND VGND VPWR VPWR _0683_ sky130_fd_sc_hd__o32a_1
XFILLER_0_28_289 VGND VGND VPWR VPWR sky130_fd_sc_hd__decap_8
XPHY_EDGE_ROW_72_Right_72 VGND VGND VPWR VPWR sky130_fd_sc_hd__decap_3
XFILLER_0_51_281 VGND VGND VPWR VPWR sky130_fd_sc_hd__decap_4
X_2435_ _1540_ VGND VGND VPWR VPWR _1541_ sky130_fd_sc_hd__clkbuf_4
X_2504_ _1548_ net119 VGND VGND VPWR VPWR _1610_ sky130_fd_sc_hd__nand2_1
X_3484_ _1314_ _1422_ _0337_ VGND VGND VPWR VPWR _0534_ sky130_fd_sc_hd__a21oi_1
XFILLER_0_3_389 VGND VGND VPWR VPWR sky130_fd_sc_hd__decap_3
XFILLER_0_3_334 VGND VGND VPWR VPWR sky130_fd_sc_hd__fill_2
X_3553_ _0548_ _1756_ _1380_ _0608_ VGND VGND VPWR VPWR _0609_ sky130_fd_sc_hd__o211ai_1
X_4105_ _1482_ _1480_ _1477_ VGND VGND VPWR VPWR _1201_ sky130_fd_sc_hd__or3_1
X_4036_ net43 _1789_ _1926_ _1124_ _1126_ VGND VGND VPWR VPWR _1127_ sky130_fd_sc_hd__a311oi_1
XFILLER_0_47_61 VGND VGND VPWR VPWR sky130_fd_sc_hd__fill_1
X_2297_ _1402_ VGND VGND VPWR VPWR _1403_ sky130_fd_sc_hd__buf_2
XFILLER_0_2_41 VPWR VGND VPWR VGND sky130_ef_sc_hd__decap_12
X_2366_ net4 VGND VGND VPWR VPWR _1472_ sky130_fd_sc_hd__buf_4
XTAP_TAPCELL_ROW_22_324 VGND VPWR sky130_fd_sc_hd__tapvpwrvgnd_1
XFILLER_0_2_85 VGND VGND VPWR VPWR sky130_fd_sc_hd__decap_8
XANTENNA_30 _1737_ VGND VGND VPWR VPWR sky130_fd_sc_hd__diode_2
XANTENNA_41 net8 VGND VGND VPWR VPWR sky130_fd_sc_hd__diode_2
XFILLER_0_30_421 VGND VGND VPWR VPWR sky130_fd_sc_hd__decap_8
XTAP_TAPCELL_ROW_73_714 VGND VPWR sky130_fd_sc_hd__tapvpwrvgnd_1
XTAP_TAPCELL_ROW_73_703 VGND VPWR sky130_fd_sc_hd__tapvpwrvgnd_1
XFILLER_0_65_384 VGND VGND VPWR VPWR sky130_fd_sc_hd__fill_2
XFILLER_0_68_27 VGND VGND VPWR VPWR sky130_fd_sc_hd__fill_1
XFILLER_0_33_281 VGND VGND VPWR VPWR sky130_fd_sc_hd__decap_6
XFILLER_0_0_337 VGND VGND VPWR VPWR sky130_fd_sc_hd__fill_2
XFILLER_0_0_315 VGND VGND VPWR VPWR sky130_fd_sc_hd__decap_8
X_2220_ net11 VGND VGND VPWR VPWR _1326_ sky130_fd_sc_hd__clkbuf_4
X_2151_ net39 _0986_ VGND VGND VPWR VPWR _0997_ sky130_fd_sc_hd__nand2_1
XFILLER_0_17_53 VGND VGND VPWR VPWR sky130_fd_sc_hd__decap_3
XTAP_TAPCELL_ROW_36_427 VGND VPWR sky130_fd_sc_hd__tapvpwrvgnd_1
X_2984_ _0019_ _0029_ _1914_ VGND VGND VPWR VPWR _0030_ sky130_fd_sc_hd__o21ai_1
XFILLER_0_33_74 VGND VGND VPWR VPWR sky130_fd_sc_hd__fill_1
XFILLER_0_17_97 VPWR VGND VPWR VGND sky130_ef_sc_hd__decap_12
Xinput50 B[25] VGND VGND VPWR VPWR net50 sky130_fd_sc_hd__buf_2
X_3605_ _1808_ net61 net118 _1809_ VGND VGND VPWR VPWR _0666_ sky130_fd_sc_hd__or4bb_1
Xinput61 B[6] VGND VGND VPWR VPWR net61 sky130_fd_sc_hd__buf_2
X_3398_ _1967_ _1971_ _1973_ _0142_ VGND VGND VPWR VPWR _0442_ sky130_fd_sc_hd__o211a_1
X_3536_ _1908_ _1907_ _1871_ _1873_ _1724_ _1661_ VGND VGND VPWR VPWR _0591_ sky130_fd_sc_hd__mux4_2
X_2418_ net34 VGND VGND VPWR VPWR _1524_ sky130_fd_sc_hd__inv_2
X_3467_ _0459_ _0513_ _0516_ VGND VGND VPWR VPWR _0517_ sky130_fd_sc_hd__o21a_1
X_4019_ _1083_ _1095_ _0525_ VGND VGND VPWR VPWR _1108_ sky130_fd_sc_hd__o21ai_1
X_2349_ net32 VGND VGND VPWR VPWR _1455_ sky130_fd_sc_hd__clkbuf_4
XFILLER_0_66_159 VGND VGND VPWR VPWR sky130_fd_sc_hd__decap_3
XFILLER_0_62_343 VGND VGND VPWR VPWR sky130_fd_sc_hd__decap_8
XFILLER_0_47_373 VGND VGND VPWR VPWR sky130_fd_sc_hd__decap_4
XPHY_EDGE_ROW_0_Right_0 VGND VGND VPWR VPWR sky130_fd_sc_hd__decap_3
XFILLER_0_30_262 VPWR VGND VPWR VGND sky130_ef_sc_hd__decap_12
XFILLER_0_15_281 VPWR VGND VPWR VGND sky130_ef_sc_hd__decap_12
XFILLER_0_54_29 VGND VGND VPWR VPWR sky130_fd_sc_hd__fill_1
XTAP_TAPCELL_ROW_58_596 VGND VPWR sky130_fd_sc_hd__tapvpwrvgnd_1
XTAP_TAPCELL_ROW_33_408 VGND VPWR sky130_fd_sc_hd__tapvpwrvgnd_1
XFILLER_0_72_129 VGND VGND VPWR VPWR sky130_fd_sc_hd__fill_2
XFILLER_0_65_181 VGND VGND VPWR VPWR sky130_fd_sc_hd__fill_2
XTAP_TAPCELL_ROW_41_463 VGND VPWR sky130_fd_sc_hd__tapvpwrvgnd_1
XFILLER_0_5_429 VGND VGND VPWR VPWR sky130_fd_sc_hd__decap_8
X_3252_ _1317_ net57 _1354_ _0676_ VGND VGND VPWR VPWR _0292_ sky130_fd_sc_hd__a211o_1
XFILLER_0_28_41 VGND VGND VPWR VPWR sky130_fd_sc_hd__fill_1
XFILLER_0_21_262 VGND VGND VPWR VPWR sky130_fd_sc_hd__decap_6
X_3321_ _1694_ _0351_ _0352_ _0066_ _0358_ VGND VGND VPWR VPWR _0359_ sky130_fd_sc_hd__o221ai_1
XFILLER_0_0_167 VGND VGND VPWR VPWR sky130_fd_sc_hd__fill_1
X_3183_ _0091_ _1969_ _0126_ _1489_ VGND VGND VPWR VPWR _0226_ sky130_fd_sc_hd__o31a_1
X_2134_ _0665_ _0686_ _0729_ _0804_ VGND VGND VPWR VPWR _0815_ sky130_fd_sc_hd__a211o_1
XFILLER_0_28_85 VGND VGND VPWR VPWR sky130_fd_sc_hd__decap_4
X_2203_ _1306_ _1308_ VGND VGND VPWR VPWR _1309_ sky130_fd_sc_hd__nand2_2
XFILLER_0_48_126 VPWR VGND VPWR VGND sky130_ef_sc_hd__decap_12
XFILLER_0_44_332 VGND VGND VPWR VPWR sky130_fd_sc_hd__decap_8
XFILLER_0_44_321 VGND VGND VPWR VPWR sky130_fd_sc_hd__decap_8
XFILLER_0_44_95 VGND VGND VPWR VPWR sky130_fd_sc_hd__decap_4
XFILLER_0_44_73 VGND VGND VPWR VPWR sky130_fd_sc_hd__decap_8
XFILLER_0_29_373 VGND VGND VPWR VPWR sky130_fd_sc_hd__decap_4
XPHY_EDGE_ROW_14_Left_88 VGND VGND VPWR VPWR sky130_fd_sc_hd__decap_3
X_2967_ _1567_ _1200_ _1846_ VGND VGND VPWR VPWR _0013_ sky130_fd_sc_hd__o21a_1
X_2898_ _1647_ _1650_ VGND VGND VPWR VPWR _2002_ sky130_fd_sc_hd__nor2_2
X_3519_ _1646_ _0103_ _0024_ _0572_ VGND VGND VPWR VPWR _0573_ sky130_fd_sc_hd__o211a_1
XFILLER_0_39_104 VGND VGND VPWR VPWR sky130_fd_sc_hd__decap_8
XTAP_TAPCELL_ROW_4_188 VGND VPWR sky130_fd_sc_hd__tapvpwrvgnd_1
XFILLER_0_54_107 VGND VGND VPWR VPWR sky130_fd_sc_hd__fill_2
XFILLER_0_50_302 VGND VGND VPWR VPWR sky130_fd_sc_hd__decap_6
XFILLER_0_35_332 VGND VGND VPWR VPWR sky130_fd_sc_hd__decap_4
XFILLER_0_50_346 VGND VGND VPWR VPWR sky130_fd_sc_hd__fill_1
XTAP_TAPCELL_ROW_46_500 VGND VPWR sky130_fd_sc_hd__tapvpwrvgnd_1
X_3870_ _1029_ _1475_ VGND VGND VPWR VPWR _0949_ sky130_fd_sc_hd__nand2_1
X_2821_ _1925_ VGND VGND VPWR VPWR _1926_ sky130_fd_sc_hd__buf_4
XFILLER_0_53_195 VGND VGND VPWR VPWR sky130_fd_sc_hd__fill_1
X_2683_ _1326_ VGND VGND VPWR VPWR _1789_ sky130_fd_sc_hd__clkbuf_4
X_2752_ net10 _1571_ VGND VGND VPWR VPWR _1857_ sky130_fd_sc_hd__or2b_1
XFILLER_0_41_335 VGND VGND VPWR VPWR sky130_fd_sc_hd__fill_1
XFILLER_0_30_64 VGND VGND VPWR VPWR sky130_fd_sc_hd__fill_2
XFILLER_0_26_398 VPWR VGND VPWR VGND sky130_ef_sc_hd__decap_12
XFILLER_0_5_237 VGND VGND VPWR VPWR sky130_fd_sc_hd__decap_4
X_3235_ _0270_ _0276_ _1914_ VGND VGND VPWR VPWR _0277_ sky130_fd_sc_hd__o21ai_2
X_3304_ _1567_ _1472_ _1623_ _1627_ VGND VGND VPWR VPWR _0342_ sky130_fd_sc_hd__o211ai_2
X_3097_ _1856_ _0139_ _1860_ _0140_ _1840_ _1719_ VGND VGND VPWR VPWR _0141_ sky130_fd_sc_hd__mux4_1
X_3166_ _1894_ _1510_ _1597_ _1878_ _0046_ VGND VGND VPWR VPWR _0209_ sky130_fd_sc_hd__o311a_1
X_2117_ _0611_ _0622_ VGND VGND VPWR VPWR _0632_ sky130_fd_sc_hd__nor2_4
XTAP_TAPCELL_ROW_1_169 VGND VPWR sky130_fd_sc_hd__tapvpwrvgnd_1
XFILLER_0_71_93 VPWR VGND VPWR VGND sky130_ef_sc_hd__decap_12
XTAP_TAPCELL_ROW_52_547 VGND VPWR sky130_fd_sc_hd__tapvpwrvgnd_1
X_3999_ net42 _0642_ _0196_ _1086_ VGND VGND VPWR VPWR _1087_ sky130_fd_sc_hd__o31a_1
XFILLER_0_36_107 VPWR VGND VPWR VGND sky130_ef_sc_hd__decap_12
XFILLER_0_17_376 VGND VGND VPWR VPWR sky130_fd_sc_hd__decap_4
XFILLER_0_32_357 VGND VGND VPWR VPWR sky130_fd_sc_hd__fill_1
XFILLER_0_4_292 VPWR VGND VPWR VGND sky130_ef_sc_hd__decap_12
XTAP_TAPCELL_ROW_9_225 VGND VPWR sky130_fd_sc_hd__tapvpwrvgnd_1
XFILLER_0_35_184 VGND VGND VPWR VPWR sky130_fd_sc_hd__decap_6
XFILLER_0_23_324 VGND VGND VPWR VPWR sky130_fd_sc_hd__decap_6
XFILLER_0_23_313 VGND VGND VPWR VPWR sky130_fd_sc_hd__decap_3
X_3020_ _1704_ VGND VGND VPWR VPWR _0065_ sky130_fd_sc_hd__clkbuf_4
XFILLER_0_58_265 VPWR VGND VPWR VGND sky130_ef_sc_hd__decap_12
X_2804_ _1905_ _1906_ _1907_ _1908_ _1581_ _1583_ VGND VGND VPWR VPWR _1909_ sky130_fd_sc_hd__mux4_1
XFILLER_0_41_63 VGND VGND VPWR VPWR sky130_fd_sc_hd__fill_1
X_3853_ _0872_ _0889_ _1486_ VGND VGND VPWR VPWR _0931_ sky130_fd_sc_hd__o21ai_1
XTAP_TAPCELL_ROW_14_260 VGND VPWR sky130_fd_sc_hd__tapvpwrvgnd_1
X_3784_ net35 _1467_ _0196_ _0856_ VGND VGND VPWR VPWR _0857_ sky130_fd_sc_hd__o31a_1
X_3922_ _1029_ _0939_ _1403_ _1404_ VGND VGND VPWR VPWR _1005_ sky130_fd_sc_hd__o2bb2a_1
X_2597_ _1562_ _1627_ _1649_ _1702_ VGND VGND VPWR VPWR _1703_ sky130_fd_sc_hd__a31o_2
XFILLER_0_1_273 VGND VGND VPWR VPWR sky130_fd_sc_hd__decap_4
XTAP_TAPCELL_ROW_6_206 VGND VPWR sky130_fd_sc_hd__tapvpwrvgnd_1
X_2666_ net36 net4 VGND VGND VPWR VPWR _1772_ sky130_fd_sc_hd__nand2_2
X_2735_ _1628_ VGND VGND VPWR VPWR _1840_ sky130_fd_sc_hd__buf_4
XFILLER_0_14_357 VGND VGND VPWR VPWR sky130_fd_sc_hd__fill_1
X_3149_ _1984_ _0041_ _1649_ _0191_ VGND VGND VPWR VPWR _0192_ sky130_fd_sc_hd__a22o_1
X_3218_ _0719_ _1439_ _0257_ _0258_ _0259_ VGND VGND VPWR VPWR _0260_ sky130_fd_sc_hd__a221o_1
X_4198_ clknet_2_0__leaf_clk _2063_ net121 VGND VGND VPWR VPWR net80 sky130_fd_sc_hd__dfrtp_1
XFILLER_0_5_52 VGND VGND VPWR VPWR sky130_fd_sc_hd__decap_4
XFILLER_0_5_63 VGND VGND VPWR VPWR sky130_fd_sc_hd__decap_6
XFILLER_0_37_405 VGND VGND VPWR VPWR sky130_fd_sc_hd__decap_4
XFILLER_0_9_340 VGND VGND VPWR VPWR sky130_fd_sc_hd__fill_2
XFILLER_0_64_257 VGND VGND VPWR VPWR sky130_fd_sc_hd__fill_1
XPHY_EDGE_ROW_17_Left_91 VGND VGND VPWR VPWR sky130_fd_sc_hd__decap_3
XFILLER_0_20_338 VGND VGND VPWR VPWR sky130_fd_sc_hd__fill_2
XFILLER_0_1_3 VPWR VGND VPWR VGND sky130_ef_sc_hd__decap_12
XFILLER_0_55_279 VGND VGND VPWR VPWR sky130_fd_sc_hd__fill_1
XFILLER_0_55_246 VPWR VGND VPWR VGND sky130_ef_sc_hd__decap_12
XFILLER_0_43_408 VGND VGND VPWR VPWR sky130_fd_sc_hd__decap_8
X_2520_ _1621_ _1330_ _1625_ VGND VGND VPWR VPWR _1626_ sky130_fd_sc_hd__o21ai_1
X_2451_ _1556_ VGND VGND VPWR VPWR _1557_ sky130_fd_sc_hd__clkbuf_4
XFILLER_0_11_55 VGND VGND VPWR VPWR sky130_fd_sc_hd__fill_1
XTAP_TAPCELL_ROW_11_241 VGND VPWR sky130_fd_sc_hd__tapvpwrvgnd_1
X_2382_ _1484_ _1487_ _1424_ VGND VGND VPWR VPWR _1488_ sky130_fd_sc_hd__a21oi_1
X_3003_ _2049_ _2050_ _2052_ _0048_ VGND VGND VPWR VPWR _0049_ sky130_fd_sc_hd__o211a_1
X_4121_ _1215_ _1489_ _1452_ _1492_ VGND VGND VPWR VPWR _1217_ sky130_fd_sc_hd__a31oi_1
X_4052_ _1142_ _1500_ _1502_ VGND VGND VPWR VPWR _1143_ sky130_fd_sc_hd__a21oi_2
Xinput4 A[12] VGND VGND VPWR VPWR net4 sky130_fd_sc_hd__buf_2
XTAP_TAPCELL_ROW_62_620 VGND VPWR sky130_fd_sc_hd__tapvpwrvgnd_1
XFILLER_0_46_224 VPWR VGND VPWR VGND sky130_ef_sc_hd__decap_12
XFILLER_0_36_85 VGND VGND VPWR VPWR sky130_fd_sc_hd__decap_8
Xclkbuf_2_1__f_clk clknet_0_clk VGND VGND VPWR VPWR clknet_2_1__leaf_clk sky130_fd_sc_hd__clkbuf_16
X_3905_ _0266_ _1560_ _0985_ VGND VGND VPWR VPWR _0987_ sky130_fd_sc_hd__a21o_1
XFILLER_0_54_290 VGND VGND VPWR VPWR sky130_fd_sc_hd__fill_2
XFILLER_0_42_430 VGND VGND VPWR VPWR sky130_fd_sc_hd__decap_3
X_3767_ _1467_ _0426_ _0478_ _0838_ VGND VGND VPWR VPWR _0839_ sky130_fd_sc_hd__o211a_1
X_2718_ _1822_ VGND VGND VPWR VPWR _1823_ sky130_fd_sc_hd__buf_4
XFILLER_0_6_321 VGND VGND VPWR VPWR sky130_fd_sc_hd__decap_6
X_3836_ _1061_ _0912_ _1828_ VGND VGND VPWR VPWR _0913_ sky130_fd_sc_hd__o21ai_1
X_3698_ _1314_ _1422_ _0764_ VGND VGND VPWR VPWR _0765_ sky130_fd_sc_hd__a21o_1
X_2649_ _1749_ _1750_ _1753_ _1754_ VGND VGND VPWR VPWR _1755_ sky130_fd_sc_hd__a31o_2
XFILLER_0_10_371 VPWR VGND VPWR VGND sky130_ef_sc_hd__decap_12
XFILLER_0_69_349 VPWR VGND VPWR VGND sky130_ef_sc_hd__decap_12
XTAP_TAPCELL_ROW_25_344 VGND VPWR sky130_fd_sc_hd__tapvpwrvgnd_1
XFILLER_0_60_271 VGND VGND VPWR VPWR sky130_fd_sc_hd__decap_8
XPHY_EDGE_ROW_2_Left_76 VGND VGND VPWR VPWR sky130_fd_sc_hd__decap_3
X_3621_ _1907_ _1871_ _1873_ _1869_ _1658_ _1731_ VGND VGND VPWR VPWR _0682_ sky130_fd_sc_hd__mux4_2
XFILLER_0_43_216 VGND VGND VPWR VPWR sky130_fd_sc_hd__fill_1
XFILLER_0_22_43 VGND VGND VPWR VPWR sky130_fd_sc_hd__decap_3
X_3552_ _1287_ _0607_ _1379_ _1264_ _1284_ VGND VGND VPWR VPWR _0608_ sky130_fd_sc_hd__a2111o_1
XFILLER_0_16_419 VGND VGND VPWR VPWR sky130_fd_sc_hd__fill_1
XFILLER_0_51_7 VGND VGND VPWR VPWR sky130_fd_sc_hd__decap_6
X_2434_ net65 net66 VGND VGND VPWR VPWR _1540_ sky130_fd_sc_hd__and2_1
X_2503_ net69 net65 net66 VGND VGND VPWR VPWR _1609_ sky130_fd_sc_hd__nor3b_4
X_3483_ _0482_ _0483_ _0485_ _0533_ VGND VGND VPWR VPWR _2083_ sky130_fd_sc_hd__o211ai_1
XFILLER_0_11_113 VGND VGND VPWR VPWR sky130_fd_sc_hd__fill_1
XFILLER_0_11_135 VGND VGND VPWR VPWR sky130_fd_sc_hd__fill_1
X_2365_ _1411_ VGND VGND VPWR VPWR _1471_ sky130_fd_sc_hd__buf_2
X_4104_ _1545_ _1194_ _1195_ _1197_ _1198_ VGND VGND VPWR VPWR _1199_ sky130_fd_sc_hd__a32oi_1
X_4035_ _1790_ _2009_ net119 _0349_ _0525_ VGND VGND VPWR VPWR _1126_ sky130_fd_sc_hd__a32o_1
X_2296_ net39 net7 VGND VGND VPWR VPWR _1402_ sky130_fd_sc_hd__and2_1
XFILLER_0_2_53 VPWR VGND VPWR VGND sky130_ef_sc_hd__decap_12
XANTENNA_31 _1825_ VGND VGND VPWR VPWR sky130_fd_sc_hd__diode_2
XFILLER_0_63_72 VGND VGND VPWR VPWR sky130_fd_sc_hd__decap_8
XANTENNA_20 _1374_ VGND VGND VPWR VPWR sky130_fd_sc_hd__diode_2
XFILLER_0_34_205 VGND VGND VPWR VPWR sky130_fd_sc_hd__decap_8
XTAP_TAPCELL_ROW_22_325 VGND VPWR sky130_fd_sc_hd__tapvpwrvgnd_1
XFILLER_0_19_268 VGND VGND VPWR VPWR sky130_fd_sc_hd__fill_1
XFILLER_0_19_213 VGND VGND VPWR VPWR sky130_fd_sc_hd__decap_4
XFILLER_0_19_202 VGND VGND VPWR VPWR sky130_fd_sc_hd__decap_8
X_3819_ _1557_ _1649_ _0088_ VGND VGND VPWR VPWR _0895_ sky130_fd_sc_hd__and3_1
XFILLER_0_34_249 VGND VGND VPWR VPWR sky130_fd_sc_hd__decap_3
XANTENNA_42 _0925_ VGND VGND VPWR VPWR sky130_fd_sc_hd__diode_2
XTAP_TAPCELL_ROW_30_380 VGND VPWR sky130_fd_sc_hd__tapvpwrvgnd_1
XTAP_TAPCELL_ROW_73_715 VGND VPWR sky130_fd_sc_hd__tapvpwrvgnd_1
XTAP_TAPCELL_ROW_73_704 VGND VPWR sky130_fd_sc_hd__tapvpwrvgnd_1
XFILLER_0_69_113 VGND VGND VPWR VPWR sky130_fd_sc_hd__decap_4
X_2150_ net7 VGND VGND VPWR VPWR _0986_ sky130_fd_sc_hd__clkbuf_4
XFILLER_0_56_363 VGND VGND VPWR VPWR sky130_fd_sc_hd__fill_1
XTAP_TAPCELL_ROW_36_428 VGND VPWR sky130_fd_sc_hd__tapvpwrvgnd_1
X_2983_ _1645_ _0023_ _0024_ _0028_ VGND VGND VPWR VPWR _0029_ sky130_fd_sc_hd__o211a_1
Xinput51 B[26] VGND VGND VPWR VPWR net51 sky130_fd_sc_hd__buf_2
XFILLER_0_71_377 VPWR VGND VPWR VGND sky130_ef_sc_hd__decap_12
XFILLER_0_71_322 VPWR VGND VPWR VGND sky130_ef_sc_hd__decap_12
X_3535_ _0588_ _0133_ _0070_ VGND VGND VPWR VPWR _0590_ sky130_fd_sc_hd__mux2_1
Xinput40 B[16] VGND VGND VPWR VPWR net40 sky130_fd_sc_hd__buf_2
XFILLER_0_31_208 VPWR VGND VPWR VGND sky130_ef_sc_hd__decap_12
X_3604_ _1427_ _0633_ _1465_ _1491_ VGND VGND VPWR VPWR _0664_ sky130_fd_sc_hd__a31o_1
Xinput62 B[7] VGND VGND VPWR VPWR net62 sky130_fd_sc_hd__buf_2
XFILLER_0_58_83 VGND VGND VPWR VPWR sky130_fd_sc_hd__fill_1
X_3397_ _1591_ _1989_ VGND VGND VPWR VPWR _0441_ sky130_fd_sc_hd__nor2_1
XFILLER_0_42_3 VGND VGND VPWR VPWR sky130_fd_sc_hd__decap_8
X_3466_ _0515_ _0458_ _1543_ _1821_ _1373_ VGND VGND VPWR VPWR _0516_ sky130_fd_sc_hd__o221a_1
X_2417_ _1395_ _1455_ _1522_ VGND VGND VPWR VPWR _1523_ sky130_fd_sc_hd__a21oi_1
X_2348_ _1453_ VGND VGND VPWR VPWR _1454_ sky130_fd_sc_hd__buf_2
X_4018_ _0525_ _1083_ _1095_ VGND VGND VPWR VPWR _1107_ sky130_fd_sc_hd__or3_1
X_2279_ _1383_ _1384_ VGND VGND VPWR VPWR _1385_ sky130_fd_sc_hd__nand2_2
XFILLER_0_62_333 VGND VGND VPWR VPWR sky130_fd_sc_hd__fill_1
XFILLER_0_62_300 VGND VGND VPWR VPWR sky130_fd_sc_hd__fill_2
XFILLER_0_30_274 VGND VGND VPWR VPWR sky130_fd_sc_hd__fill_2
XFILLER_0_15_293 VGND VGND VPWR VPWR sky130_fd_sc_hd__decap_6
XFILLER_0_70_29 VPWR VGND VPWR VGND sky130_ef_sc_hd__decap_12
XTAP_TAPCELL_ROW_58_597 VGND VPWR sky130_fd_sc_hd__tapvpwrvgnd_1
XTAP_TAPCELL_ROW_33_409 VGND VPWR sky130_fd_sc_hd__tapvpwrvgnd_1
XFILLER_0_53_311 VPWR VGND VPWR VGND sky130_ef_sc_hd__decap_12
XTAP_TAPCELL_ROW_41_464 VGND VPWR sky130_fd_sc_hd__tapvpwrvgnd_1
X_3251_ _0178_ _0154_ _0233_ _0180_ VGND VGND VPWR VPWR _0291_ sky130_fd_sc_hd__o211a_1
X_3182_ _0091_ _1969_ _0126_ _0087_ _1487_ VGND VGND VPWR VPWR _0225_ sky130_fd_sc_hd__o311a_1
XFILLER_0_21_296 VGND VGND VPWR VPWR sky130_fd_sc_hd__fill_1
XFILLER_0_21_285 VGND VGND VPWR VPWR sky130_fd_sc_hd__decap_6
X_3320_ _1751_ _0353_ _0355_ _1555_ _0357_ VGND VGND VPWR VPWR _0358_ sky130_fd_sc_hd__a221oi_1
X_2202_ net1 VGND VGND VPWR VPWR _1308_ sky130_fd_sc_hd__buf_2
X_2133_ _0740_ _0762_ _0772_ _0794_ VGND VGND VPWR VPWR _0804_ sky130_fd_sc_hd__o22ai_4
XFILLER_0_48_105 VPWR VGND VPWR VGND sky130_ef_sc_hd__decap_12
XFILLER_0_44_85 VGND VGND VPWR VPWR sky130_fd_sc_hd__decap_3
XFILLER_0_60_73 VGND VGND VPWR VPWR sky130_fd_sc_hd__decap_8
XFILLER_0_48_149 VGND VGND VPWR VPWR sky130_fd_sc_hd__decap_3
XFILLER_0_48_138 VGND VGND VPWR VPWR sky130_fd_sc_hd__fill_2
X_2897_ _1708_ _1990_ _1994_ _1706_ _2000_ VGND VGND VPWR VPWR _2001_ sky130_fd_sc_hd__o32a_1
X_2966_ _1453_ _1253_ _1461_ _1289_ _1585_ _1618_ VGND VGND VPWR VPWR _0012_ sky130_fd_sc_hd__mux4_1
X_3518_ _1646_ _0571_ VGND VGND VPWR VPWR _0572_ sky130_fd_sc_hd__nand2_1
XFILLER_0_8_63 VGND VGND VPWR VPWR sky130_fd_sc_hd__decap_3
XFILLER_0_8_85 VGND VGND VPWR VPWR sky130_fd_sc_hd__decap_8
XTAP_TAPCELL_ROW_4_189 VGND VPWR sky130_fd_sc_hd__tapvpwrvgnd_1
X_3449_ _1877_ _1411_ _1894_ _1850_ VGND VGND VPWR VPWR _0497_ sky130_fd_sc_hd__o211ai_1
XFILLER_0_39_127 VPWR VGND VPWR VGND sky130_ef_sc_hd__decap_12
XFILLER_0_62_141 VPWR VGND VPWR VGND sky130_ef_sc_hd__decap_12
XFILLER_0_35_300 VGND VGND VPWR VPWR sky130_fd_sc_hd__decap_8
XTAP_TAPCELL_ROW_46_501 VGND VPWR sky130_fd_sc_hd__tapvpwrvgnd_1
X_2751_ net16 _1576_ _1855_ VGND VGND VPWR VPWR _1856_ sky130_fd_sc_hd__o21ai_2
X_2820_ _1924_ VGND VGND VPWR VPWR _1925_ sky130_fd_sc_hd__clkbuf_4
XFILLER_0_38_193 VGND VGND VPWR VPWR sky130_fd_sc_hd__decap_3
XFILLER_0_38_182 VGND VGND VPWR VPWR sky130_fd_sc_hd__decap_4
XFILLER_0_26_355 VGND VGND VPWR VPWR sky130_fd_sc_hd__decap_8
XFILLER_0_26_333 VPWR VGND VPWR VGND sky130_ef_sc_hd__decap_12
X_2682_ _0503_ _0514_ _0535_ _0546_ VGND VGND VPWR VPWR _1788_ sky130_fd_sc_hd__a22o_1
X_3234_ _1317_ _1891_ _1707_ _0275_ VGND VGND VPWR VPWR _0276_ sky130_fd_sc_hd__o22ai_1
X_3165_ _1556_ VGND VGND VPWR VPWR _0208_ sky130_fd_sc_hd__buf_2
X_3303_ _1577_ _1475_ _1697_ _1625_ VGND VGND VPWR VPWR _0341_ sky130_fd_sc_hd__o211ai_1
X_3096_ _1890_ _1969_ _1872_ VGND VGND VPWR VPWR _0140_ sky130_fd_sc_hd__o21ai_1
XTAP_TAPCELL_ROW_52_548 VGND VPWR sky130_fd_sc_hd__tapvpwrvgnd_1
X_2116_ net40 net8 VGND VGND VPWR VPWR _0622_ sky130_fd_sc_hd__nor2_2
X_2949_ net52 _1443_ _1446_ _2051_ VGND VGND VPWR VPWR _2052_ sky130_fd_sc_hd__o211ai_1
X_3998_ _1080_ _0256_ _1081_ _1085_ VGND VGND VPWR VPWR _1086_ sky130_fd_sc_hd__a211oi_1
XFILLER_0_36_119 VPWR VGND VPWR VGND sky130_ef_sc_hd__decap_12
XFILLER_0_17_311 VGND VGND VPWR VPWR sky130_fd_sc_hd__fill_2
XTAP_TAPCELL_ROW_9_226 VGND VPWR sky130_fd_sc_hd__tapvpwrvgnd_1
XTAP_TAPCELL_ROW_68_670 VGND VPWR sky130_fd_sc_hd__tapvpwrvgnd_1
XFILLER_0_50_188 VGND VGND VPWR VPWR sky130_fd_sc_hd__decap_8
XFILLER_0_50_166 VPWR VGND VPWR VGND sky130_ef_sc_hd__decap_12
XFILLER_0_35_152 VPWR VGND VPWR VGND sky130_ef_sc_hd__decap_12
X_3921_ _1000_ _1001_ _1002_ _1003_ VGND VGND VPWR VPWR _1004_ sky130_fd_sc_hd__o22a_1
XFILLER_0_25_87 VPWR VGND VPWR VGND sky130_ef_sc_hd__decap_12
XFILLER_0_25_21 VPWR VGND VPWR VGND sky130_ef_sc_hd__decap_12
XFILLER_0_18_108 VGND VGND VPWR VPWR sky130_fd_sc_hd__decap_3
XFILLER_0_73_258 VGND VGND VPWR VPWR sky130_fd_sc_hd__decap_4
XFILLER_0_73_225 VGND VGND VPWR VPWR sky130_fd_sc_hd__fill_2
X_2803_ _1618_ _1478_ _1855_ VGND VGND VPWR VPWR _1908_ sky130_fd_sc_hd__o21ai_2
XFILLER_0_58_277 VGND VGND VPWR VPWR sky130_fd_sc_hd__decap_8
XFILLER_0_41_53 VGND VGND VPWR VPWR sky130_fd_sc_hd__decap_3
X_3852_ _0132_ _0150_ _0929_ VGND VGND VPWR VPWR _0930_ sky130_fd_sc_hd__o21ai_1
X_2734_ _1599_ _1455_ _1838_ VGND VGND VPWR VPWR _1839_ sky130_fd_sc_hd__a21oi_2
X_3783_ _1391_ _1930_ _1672_ _1221_ VGND VGND VPWR VPWR _0856_ sky130_fd_sc_hd__o22a_1
XTAP_TAPCELL_ROW_14_261 VGND VPWR sky130_fd_sc_hd__tapvpwrvgnd_1
XFILLER_0_14_303 VGND VGND VPWR VPWR sky130_fd_sc_hd__decap_4
XFILLER_0_41_177 VGND VGND VPWR VPWR sky130_fd_sc_hd__decap_8
XFILLER_0_41_166 VGND VGND VPWR VPWR sky130_fd_sc_hd__fill_2
X_2596_ _1566_ _1585_ _1510_ _1559_ VGND VGND VPWR VPWR _1702_ sky130_fd_sc_hd__o31a_1
X_2665_ _1767_ _1746_ _1769_ _1770_ VGND VGND VPWR VPWR _1771_ sky130_fd_sc_hd__a31oi_1
XTAP_TAPCELL_ROW_6_207 VGND VPWR sky130_fd_sc_hd__tapvpwrvgnd_1
XFILLER_0_14_369 VGND VGND VPWR VPWR sky130_fd_sc_hd__fill_1
X_3148_ _0087_ _1969_ _1968_ _2048_ _1983_ _1874_ VGND VGND VPWR VPWR _0191_ sky130_fd_sc_hd__mux4_1
X_3217_ _1666_ _1867_ _1427_ VGND VGND VPWR VPWR _0259_ sky130_fd_sc_hd__o21a_1
X_4197_ clknet_2_0__leaf_clk _2062_ net120 VGND VGND VPWR VPWR net79 sky130_fd_sc_hd__dfrtp_1
XFILLER_0_64_269 VPWR VGND VPWR VGND sky130_ef_sc_hd__decap_12
X_3079_ _1423_ _1806_ VGND VGND VPWR VPWR _0124_ sky130_fd_sc_hd__nor2_1
XFILLER_0_49_277 VGND VGND VPWR VPWR sky130_fd_sc_hd__decap_3
XFILLER_0_49_244 VGND VGND VPWR VPWR sky130_fd_sc_hd__fill_2
XFILLER_0_49_222 VGND VGND VPWR VPWR sky130_fd_sc_hd__fill_2
XFILLER_0_72_280 VGND VGND VPWR VPWR sky130_fd_sc_hd__decap_8
XFILLER_0_13_391 VGND VGND VPWR VPWR sky130_fd_sc_hd__fill_1
XFILLER_0_55_258 VGND VGND VPWR VPWR sky130_fd_sc_hd__decap_4
XFILLER_0_23_100 VGND VGND VPWR VPWR sky130_fd_sc_hd__decap_6
XFILLER_0_11_34 VGND VGND VPWR VPWR sky130_fd_sc_hd__fill_1
XTAP_TAPCELL_ROW_11_242 VGND VPWR sky130_fd_sc_hd__tapvpwrvgnd_1
X_2381_ _1486_ VGND VGND VPWR VPWR _1487_ sky130_fd_sc_hd__clkbuf_4
X_2450_ net59 VGND VGND VPWR VPWR _1556_ sky130_fd_sc_hd__clkbuf_4
XFILLER_0_23_188 VGND VGND VPWR VPWR sky130_fd_sc_hd__fill_2
XFILLER_0_11_89 VGND VGND VPWR VPWR sky130_fd_sc_hd__fill_2
XFILLER_0_11_306 VGND VGND VPWR VPWR sky130_fd_sc_hd__decap_3
X_4120_ _1215_ _1489_ _1452_ VGND VGND VPWR VPWR _1216_ sky130_fd_sc_hd__a21o_1
X_4051_ _1521_ _1535_ _0643_ VGND VGND VPWR VPWR _1142_ sky130_fd_sc_hd__a21bo_1
X_3002_ _0011_ _0030_ _0045_ _0047_ VGND VGND VPWR VPWR _0048_ sky130_fd_sc_hd__and4_1
Xinput5 A[13] VGND VGND VPWR VPWR net5 sky130_fd_sc_hd__dlymetal6s2s_1
XTAP_TAPCELL_ROW_62_621 VGND VPWR sky130_fd_sc_hd__tapvpwrvgnd_1
XFILLER_0_52_96 VGND VGND VPWR VPWR sky130_fd_sc_hd__decap_4
XFILLER_0_52_85 VGND VGND VPWR VPWR sky130_fd_sc_hd__decap_4
XFILLER_0_46_258 VGND VGND VPWR VPWR sky130_fd_sc_hd__fill_1
XFILLER_0_46_236 VPWR VGND VPWR VGND sky130_ef_sc_hd__decap_12
X_3904_ _0496_ _1588_ _1842_ _0703_ VGND VGND VPWR VPWR _0985_ sky130_fd_sc_hd__o211a_1
XFILLER_0_72_3 VPWR VGND VPWR VGND sky130_ef_sc_hd__decap_12
X_3766_ _1313_ _1421_ net35 VGND VGND VPWR VPWR _0838_ sky130_fd_sc_hd__a21o_1
X_3697_ _1455_ VGND VGND VPWR VPWR _0764_ sky130_fd_sc_hd__clkbuf_4
XFILLER_0_14_111 VGND VGND VPWR VPWR sky130_fd_sc_hd__decap_4
XFILLER_0_14_177 VPWR VGND VPWR VGND sky130_ef_sc_hd__decap_12
X_3835_ _1071_ _0903_ _1772_ VGND VGND VPWR VPWR _0912_ sky130_fd_sc_hd__o21a_1
X_2717_ _1539_ net118 _1821_ VGND VGND VPWR VPWR _1822_ sky130_fd_sc_hd__a21oi_2
X_2579_ _1374_ _1635_ _1611_ _1316_ VGND VGND VPWR VPWR _1685_ sky130_fd_sc_hd__a211o_1
X_2648_ _1295_ _1512_ _1297_ VGND VGND VPWR VPWR _1754_ sky130_fd_sc_hd__o21bai_1
XFILLER_0_10_383 VGND VGND VPWR VPWR sky130_fd_sc_hd__decap_8
XTAP_TAPCELL_ROW_25_345 VGND VPWR sky130_fd_sc_hd__tapvpwrvgnd_1
XFILLER_0_60_294 VGND VGND VPWR VPWR sky130_fd_sc_hd__fill_1
XFILLER_0_60_250 VGND VGND VPWR VPWR sky130_fd_sc_hd__fill_2
XFILLER_0_20_103 VPWR VGND VPWR VGND sky130_ef_sc_hd__decap_12
XFILLER_0_73_29 VPWR VGND VPWR VGND sky130_ef_sc_hd__decap_12
XFILLER_0_28_236 VGND VGND VPWR VPWR sky130_fd_sc_hd__fill_1
XFILLER_0_28_214 VGND VGND VPWR VPWR sky130_fd_sc_hd__decap_6
XFILLER_0_22_11 VGND VGND VPWR VPWR sky130_fd_sc_hd__fill_2
X_2502_ _1607_ VGND VGND VPWR VPWR _1608_ sky130_fd_sc_hd__clkbuf_4
X_3620_ _0634_ _0635_ _0637_ _0681_ VGND VGND VPWR VPWR _2086_ sky130_fd_sc_hd__o211ai_1
XFILLER_0_3_325 VGND VGND VPWR VPWR sky130_fd_sc_hd__decap_3
X_3551_ _1300_ _1371_ _1376_ VGND VGND VPWR VPWR _0607_ sky130_fd_sc_hd__a21o_1
X_4103_ _0406_ _1153_ _1196_ _2038_ VGND VGND VPWR VPWR _1198_ sky130_fd_sc_hd__a31oi_1
X_2433_ _1538_ VGND VGND VPWR VPWR _1539_ sky130_fd_sc_hd__buf_4
X_3482_ _0243_ _0494_ _0532_ VGND VGND VPWR VPWR _0533_ sky130_fd_sc_hd__a21oi_1
X_2364_ _1467_ _1469_ VGND VGND VPWR VPWR _1470_ sky130_fd_sc_hd__nor2_1
XFILLER_0_11_158 VGND VGND VPWR VPWR sky130_fd_sc_hd__fill_1
X_4034_ _1783_ _1612_ _2009_ _1922_ net43 VGND VGND VPWR VPWR _1124_ sky130_fd_sc_hd__a32o_1
XFILLER_0_47_85 VGND VGND VPWR VPWR sky130_fd_sc_hd__fill_2
XTAP_TAPCELL_ROW_39_448 VGND VPWR sky130_fd_sc_hd__tapvpwrvgnd_1
XFILLER_0_2_65 VPWR VGND VPWR VGND sky130_ef_sc_hd__decap_12
X_2295_ _1389_ _1390_ _1394_ _1399_ _1400_ VGND VGND VPWR VPWR _1401_ sky130_fd_sc_hd__o221ai_2
XANTENNA_32 _1828_ VGND VGND VPWR VPWR sky130_fd_sc_hd__diode_2
XFILLER_0_59_372 VGND VGND VPWR VPWR sky130_fd_sc_hd__decap_8
X_3818_ _0329_ _0738_ _0330_ _0328_ _0022_ _0031_ VGND VGND VPWR VPWR _0894_ sky130_fd_sc_hd__mux4_1
XANTENNA_21 _1374_ VGND VGND VPWR VPWR sky130_fd_sc_hd__diode_2
XANTENNA_10 _0340_ VGND VGND VPWR VPWR sky130_fd_sc_hd__diode_2
XTAP_TAPCELL_ROW_22_326 VGND VPWR sky130_fd_sc_hd__tapvpwrvgnd_1
XFILLER_0_19_225 VPWR VGND VPWR VGND sky130_ef_sc_hd__decap_12
XFILLER_0_6_141 VPWR VGND VPWR VGND sky130_ef_sc_hd__decap_12
XFILLER_0_42_250 VGND VGND VPWR VPWR sky130_fd_sc_hd__fill_2
XTAP_TAPCELL_ROW_30_381 VGND VPWR sky130_fd_sc_hd__tapvpwrvgnd_1
XFILLER_0_2_391 VPWR VGND VPWR VGND sky130_ef_sc_hd__decap_12
X_3749_ _0004_ _0256_ _1168_ VGND VGND VPWR VPWR _0820_ sky130_fd_sc_hd__mux2_1
XFILLER_0_15_431 VGND VGND VPWR VPWR sky130_fd_sc_hd__fill_2
XTAP_TAPCELL_ROW_73_716 VGND VPWR sky130_fd_sc_hd__tapvpwrvgnd_1
XTAP_TAPCELL_ROW_73_705 VGND VPWR sky130_fd_sc_hd__tapvpwrvgnd_1
XFILLER_0_69_169 VGND VGND VPWR VPWR sky130_fd_sc_hd__fill_1
XFILLER_0_65_397 VGND VGND VPWR VPWR sky130_fd_sc_hd__decap_3
XFILLER_0_65_364 VPWR VGND VPWR VGND sky130_ef_sc_hd__decap_12
XFILLER_0_21_401 VPWR VGND VPWR VGND sky130_ef_sc_hd__decap_12
XFILLER_0_68_29 VGND VGND VPWR VPWR sky130_fd_sc_hd__decap_3
XFILLER_0_0_306 VGND VGND VPWR VPWR sky130_fd_sc_hd__fill_2
XFILLER_0_48_309 VGND VGND VPWR VPWR sky130_fd_sc_hd__fill_2
XTAP_TAPCELL_ROW_36_429 VGND VPWR sky130_fd_sc_hd__tapvpwrvgnd_1
XFILLER_0_71_334 VGND VGND VPWR VPWR sky130_fd_sc_hd__fill_2
XFILLER_0_68_191 VGND VGND VPWR VPWR sky130_fd_sc_hd__decap_4
XFILLER_0_56_386 VGND VGND VPWR VPWR sky130_fd_sc_hd__fill_2
XFILLER_0_33_54 VGND VGND VPWR VPWR sky130_fd_sc_hd__fill_2
X_2982_ _1721_ _0025_ _0027_ _1726_ VGND VGND VPWR VPWR _0028_ sky130_fd_sc_hd__o211ai_1
XFILLER_0_33_21 VGND VGND VPWR VPWR sky130_fd_sc_hd__decap_4
Xinput52 B[27] VGND VGND VPWR VPWR net52 sky130_fd_sc_hd__clkbuf_4
XFILLER_0_71_389 VGND VGND VPWR VPWR sky130_fd_sc_hd__decap_3
X_3534_ _1905_ _1906_ _0375_ _0374_ _0074_ _1700_ VGND VGND VPWR VPWR _0588_ sky130_fd_sc_hd__mux4_1
Xinput41 B[17] VGND VGND VPWR VPWR net41 sky130_fd_sc_hd__buf_2
XFILLER_0_24_250 VGND VGND VPWR VPWR sky130_fd_sc_hd__fill_2
X_3603_ _1465_ _1427_ _0633_ VGND VGND VPWR VPWR _0663_ sky130_fd_sc_hd__a21oi_1
X_3465_ _1295_ _1297_ _1511_ _1512_ VGND VGND VPWR VPWR _0515_ sky130_fd_sc_hd__a2bb2o_1
XFILLER_0_3_133 VGND VGND VPWR VPWR sky130_fd_sc_hd__fill_2
Xinput63 B[8] VGND VGND VPWR VPWR net63 sky130_fd_sc_hd__buf_1
Xinput30 A[7] VGND VGND VPWR VPWR net30 sky130_fd_sc_hd__dlymetal6s2s_1
XFILLER_0_12_401 VGND VGND VPWR VPWR sky130_fd_sc_hd__decap_3
XFILLER_0_35_3 VGND VGND VPWR VPWR sky130_fd_sc_hd__decap_8
X_3396_ _0436_ _0437_ _0439_ _0041_ _0242_ VGND VGND VPWR VPWR _0440_ sky130_fd_sc_hd__a221oi_1
X_2416_ _1397_ net31 VGND VGND VPWR VPWR _1522_ sky130_fd_sc_hd__and2b_1
X_2347_ net30 VGND VGND VPWR VPWR _1453_ sky130_fd_sc_hd__buf_2
X_2278_ net30 net62 VGND VGND VPWR VPWR _1384_ sky130_fd_sc_hd__or2b_1
XFILLER_0_66_139 VGND VGND VPWR VPWR sky130_fd_sc_hd__fill_1
X_4017_ _1098_ _1100_ _1103_ _1106_ VGND VGND VPWR VPWR _2067_ sky130_fd_sc_hd__nand4_1
XFILLER_0_22_209 VGND VGND VPWR VPWR sky130_fd_sc_hd__fill_1
XPHY_EDGE_ROW_35_Left_109 VGND VGND VPWR VPWR sky130_fd_sc_hd__decap_3
XFILLER_0_72_109 VPWR VGND VPWR VGND sky130_ef_sc_hd__decap_12
XFILLER_0_53_323 VGND VGND VPWR VPWR sky130_fd_sc_hd__fill_2
XTAP_TAPCELL_ROW_41_465 VGND VPWR sky130_fd_sc_hd__tapvpwrvgnd_1
XFILLER_0_38_331 VGND VGND VPWR VPWR sky130_fd_sc_hd__decap_4
XFILLER_0_53_378 VGND VGND VPWR VPWR sky130_fd_sc_hd__decap_3
XFILLER_0_53_345 VGND VGND VPWR VPWR sky130_fd_sc_hd__fill_2
XPHY_EDGE_ROW_44_Left_118 VGND VGND VPWR VPWR sky130_fd_sc_hd__decap_3
XFILLER_0_21_231 VGND VGND VPWR VPWR sky130_fd_sc_hd__fill_1
XFILLER_0_21_220 VGND VGND VPWR VPWR sky130_fd_sc_hd__decap_4
X_3250_ _1317_ _1355_ _1318_ _0281_ _0686_ VGND VGND VPWR VPWR _0290_ sky130_fd_sc_hd__o221a_1
X_2132_ _0783_ VGND VGND VPWR VPWR _0794_ sky130_fd_sc_hd__clkbuf_2
X_3181_ _0186_ _0187_ _0189_ _0223_ VGND VGND VPWR VPWR _0224_ sky130_fd_sc_hd__a211oi_1
X_2201_ net1 _1306_ VGND VGND VPWR VPWR _1307_ sky130_fd_sc_hd__or2_1
XFILLER_0_0_169 VPWR VGND VPWR VGND sky130_ef_sc_hd__decap_12
XPHY_EDGE_ROW_53_Left_127 VGND VGND VPWR VPWR sky130_fd_sc_hd__decap_3
XFILLER_0_48_117 VGND VGND VPWR VPWR sky130_fd_sc_hd__decap_4
XPHY_EDGE_ROW_62_Left_136 VGND VGND VPWR VPWR sky130_fd_sc_hd__decap_3
XFILLER_0_60_85 VGND VGND VPWR VPWR sky130_fd_sc_hd__decap_8
XFILLER_0_56_194 VGND VGND VPWR VPWR sky130_fd_sc_hd__fill_2
XFILLER_0_56_183 VGND VGND VPWR VPWR sky130_fd_sc_hd__decap_6
XFILLER_0_56_172 VGND VGND VPWR VPWR sky130_fd_sc_hd__decap_3
X_2965_ _1558_ _2057_ _0007_ _1685_ _0010_ VGND VGND VPWR VPWR _0011_ sky130_fd_sc_hd__o2111a_1
XFILLER_0_29_397 VGND VGND VPWR VPWR sky130_fd_sc_hd__fill_1
X_2896_ _1997_ _1704_ _1999_ VGND VGND VPWR VPWR _2000_ sky130_fd_sc_hd__a21oi_1
X_3517_ _1721_ _0316_ _0318_ _0570_ VGND VGND VPWR VPWR _0571_ sky130_fd_sc_hd__a31o_1
X_3448_ _1580_ _1906_ _0495_ VGND VGND VPWR VPWR _0496_ sky130_fd_sc_hd__o21a_1
XFILLER_0_8_42 VGND VGND VPWR VPWR sky130_fd_sc_hd__fill_1
XFILLER_0_12_220 VGND VGND VPWR VPWR sky130_fd_sc_hd__fill_1
XFILLER_0_12_253 VGND VGND VPWR VPWR sky130_fd_sc_hd__decap_8
XPHY_EDGE_ROW_71_Left_145 VGND VGND VPWR VPWR sky130_fd_sc_hd__decap_3
X_3379_ _0403_ _0372_ _0412_ _0421_ VGND VGND VPWR VPWR _0422_ sky130_fd_sc_hd__o211ai_2
XTAP_TAPCELL_ROW_55_568 VGND VPWR sky130_fd_sc_hd__tapvpwrvgnd_1
XFILLER_0_47_150 VGND VGND VPWR VPWR sky130_fd_sc_hd__fill_1
XFILLER_0_39_139 VGND VGND VPWR VPWR sky130_fd_sc_hd__fill_1
XFILLER_0_62_153 VPWR VGND VPWR VGND sky130_ef_sc_hd__decap_12
XFILLER_0_58_404 VGND VGND VPWR VPWR sky130_fd_sc_hd__decap_3
XTAP_TAPCELL_ROW_46_502 VGND VPWR sky130_fd_sc_hd__tapvpwrvgnd_1
X_2750_ _1341_ _1572_ VGND VGND VPWR VPWR _1855_ sky130_fd_sc_hd__nand2_1
XFILLER_0_53_164 VGND VGND VPWR VPWR sky130_fd_sc_hd__decap_4
XFILLER_0_53_142 VGND VGND VPWR VPWR sky130_fd_sc_hd__fill_1
XFILLER_0_45_109 VGND VGND VPWR VPWR sky130_fd_sc_hd__decap_3
X_2681_ net41 _1785_ _1786_ VGND VGND VPWR VPWR _1787_ sky130_fd_sc_hd__o21ai_2
XFILLER_0_38_161 VPWR VGND VPWR VGND sky130_ef_sc_hd__decap_12
XFILLER_0_26_345 VGND VGND VPWR VPWR sky130_fd_sc_hd__decap_3
XFILLER_0_39_31 VGND VGND VPWR VPWR sky130_fd_sc_hd__fill_1
X_3302_ _1456_ _1455_ _1468_ _1200_ _1618_ _1894_ VGND VGND VPWR VPWR _0340_ sky130_fd_sc_hd__mux4_2
X_3095_ _1890_ _2048_ _1870_ VGND VGND VPWR VPWR _0139_ sky130_fd_sc_hd__o21ai_1
X_3164_ _0205_ _0206_ _1960_ VGND VGND VPWR VPWR _0207_ sky130_fd_sc_hd__mux2_1
X_2115_ net40 net8 VGND VGND VPWR VPWR _0611_ sky130_fd_sc_hd__and2_2
X_3233_ _0080_ _0272_ _0274_ VGND VGND VPWR VPWR _0275_ sky130_fd_sc_hd__o21ai_2
XTAP_TAPCELL_ROW_52_549 VGND VPWR sky130_fd_sc_hd__tapvpwrvgnd_1
X_3997_ _0642_ _1666_ _1922_ net42 _1084_ VGND VGND VPWR VPWR _1085_ sky130_fd_sc_hd__a221o_1
X_2879_ _1618_ VGND VGND VPWR VPWR _1983_ sky130_fd_sc_hd__buf_4
X_2948_ _1443_ _1348_ VGND VGND VPWR VPWR _2051_ sky130_fd_sc_hd__nand2_1
XFILLER_0_44_186 VGND VGND VPWR VPWR sky130_fd_sc_hd__decap_8
XFILLER_0_29_194 VGND VGND VPWR VPWR sky130_fd_sc_hd__fill_1
XFILLER_0_17_345 VGND VGND VPWR VPWR sky130_fd_sc_hd__decap_8
XTAP_TAPCELL_ROW_9_227 VGND VPWR sky130_fd_sc_hd__tapvpwrvgnd_1
XTAP_TAPCELL_ROW_68_671 VGND VPWR sky130_fd_sc_hd__tapvpwrvgnd_1
XTAP_TAPCELL_ROW_0_160 VGND VPWR sky130_fd_sc_hd__tapvpwrvgnd_1
XFILLER_0_67_278 VGND VGND VPWR VPWR sky130_fd_sc_hd__fill_2
XFILLER_0_67_245 VGND VGND VPWR VPWR sky130_fd_sc_hd__fill_2
XFILLER_0_35_164 VGND VGND VPWR VPWR sky130_fd_sc_hd__decap_4
XFILLER_0_35_131 VGND VGND VPWR VPWR sky130_fd_sc_hd__fill_1
XFILLER_0_50_178 VGND VGND VPWR VPWR sky130_fd_sc_hd__decap_3
XFILLER_0_50_123 VGND VGND VPWR VPWR sky130_fd_sc_hd__fill_1
XFILLER_0_25_11 VGND VGND VPWR VPWR sky130_fd_sc_hd__fill_1
X_3851_ _0737_ _0927_ _0137_ _1831_ _0928_ VGND VGND VPWR VPWR _0929_ sky130_fd_sc_hd__o221ai_1
XFILLER_0_25_99 VGND VGND VPWR VPWR sky130_fd_sc_hd__decap_4
XFILLER_0_25_55 VGND VGND VPWR VPWR sky130_fd_sc_hd__fill_1
XFILLER_0_25_33 VGND VGND VPWR VPWR sky130_fd_sc_hd__decap_6
X_3920_ _1018_ _1532_ _0946_ _1545_ VGND VGND VPWR VPWR _1003_ sky130_fd_sc_hd__o31ai_1
X_2802_ net16 _1576_ _1859_ VGND VGND VPWR VPWR _1907_ sky130_fd_sc_hd__o21ai_4
XFILLER_0_41_145 VGND VGND VPWR VPWR sky130_fd_sc_hd__decap_4
XFILLER_0_41_134 VGND VGND VPWR VPWR sky130_fd_sc_hd__decap_4
X_3782_ _1645_ _0016_ _0018_ _1706_ _1914_ VGND VGND VPWR VPWR _0855_ sky130_fd_sc_hd__o2111ai_2
XFILLER_0_26_197 VPWR VGND VPWR VGND sky130_ef_sc_hd__decap_12
X_2733_ _1563_ _1456_ VGND VGND VPWR VPWR _1838_ sky130_fd_sc_hd__and2_1
X_2664_ _1157_ _1189_ _1210_ VGND VGND VPWR VPWR _1770_ sky130_fd_sc_hd__o21ai_1
XTAP_TAPCELL_ROW_14_262 VGND VPWR sky130_fd_sc_hd__tapvpwrvgnd_1
X_2595_ _1695_ _1698_ _1700_ VGND VGND VPWR VPWR _1701_ sky130_fd_sc_hd__mux2_1
X_3078_ _1450_ _1452_ _1483_ VGND VGND VPWR VPWR _0123_ sky130_fd_sc_hd__nor3_1
X_3216_ _1426_ net57 _0004_ VGND VGND VPWR VPWR _0258_ sky130_fd_sc_hd__or3_1
X_3147_ _0075_ _1980_ _1732_ _1981_ _1840_ _1874_ VGND VGND VPWR VPWR _0190_ sky130_fd_sc_hd__mux4_1
X_4196_ clknet_2_0__leaf_clk _2061_ net121 VGND VGND VPWR VPWR net78 sky130_fd_sc_hd__dfrtp_1
XFILLER_0_9_397 VPWR VGND VPWR VGND sky130_ef_sc_hd__decap_12
XFILLER_0_60_421 VPWR VGND VPWR VGND sky130_ef_sc_hd__decap_12
XFILLER_0_17_175 VGND VGND VPWR VPWR sky130_fd_sc_hd__fill_2
XTAP_TAPCELL_ROW_28_365 VGND VPWR sky130_fd_sc_hd__tapvpwrvgnd_1
XTAP_TAPCELL_ROW_71_688 VGND VPWR sky130_fd_sc_hd__tapvpwrvgnd_1
XFILLER_0_11_57 VGND VGND VPWR VPWR sky130_fd_sc_hd__fill_1
XFILLER_0_11_79 VGND VGND VPWR VPWR sky130_fd_sc_hd__decap_3
XTAP_TAPCELL_ROW_11_243 VGND VPWR sky130_fd_sc_hd__tapvpwrvgnd_1
X_2380_ _1485_ VGND VGND VPWR VPWR _1486_ sky130_fd_sc_hd__buf_2
X_3001_ _0046_ _0034_ _1592_ _1868_ VGND VGND VPWR VPWR _0047_ sky130_fd_sc_hd__a211o_1
X_4050_ _1109_ _1134_ _1141_ VGND VGND VPWR VPWR _2068_ sky130_fd_sc_hd__nand3b_1
Xinput6 A[14] VGND VGND VPWR VPWR net6 sky130_fd_sc_hd__buf_2
XTAP_TAPCELL_ROW_62_622 VGND VPWR sky130_fd_sc_hd__tapvpwrvgnd_1
XFILLER_0_46_248 VGND VGND VPWR VPWR sky130_fd_sc_hd__decap_4
X_3903_ _1954_ _0247_ _0983_ _0132_ _0249_ VGND VGND VPWR VPWR _0984_ sky130_fd_sc_hd__o2111ai_1
X_3834_ _1740_ _1741_ _1071_ _0903_ _1772_ VGND VGND VPWR VPWR _0910_ sky130_fd_sc_hd__o221a_1
XFILLER_0_65_3 VPWR VGND VPWR VGND sky130_ef_sc_hd__decap_12
XFILLER_0_54_270 VGND VGND VPWR VPWR sky130_fd_sc_hd__decap_8
XFILLER_0_42_421 VGND VGND VPWR VPWR sky130_fd_sc_hd__decap_6
X_2716_ _1820_ VGND VGND VPWR VPWR _1821_ sky130_fd_sc_hd__buf_4
X_3696_ _0728_ _0730_ _0760_ _0763_ VGND VGND VPWR VPWR _2088_ sky130_fd_sc_hd__o211ai_1
X_3765_ net35 _0426_ _0428_ _0429_ VGND VGND VPWR VPWR _0837_ sky130_fd_sc_hd__o211a_1
X_2647_ _1751_ _1304_ _1752_ VGND VGND VPWR VPWR _1753_ sky130_fd_sc_hd__o21ai_1
XFILLER_0_14_189 VGND VGND VPWR VPWR sky130_fd_sc_hd__fill_1
X_2578_ net17 net49 _1683_ VGND VGND VPWR VPWR _1684_ sky130_fd_sc_hd__a21o_1
XFILLER_0_10_362 VGND VGND VPWR VPWR sky130_fd_sc_hd__fill_2
XFILLER_0_37_215 VGND VGND VPWR VPWR sky130_fd_sc_hd__decap_8
X_4179_ _1278_ _1279_ VGND VGND VPWR VPWR _1280_ sky130_fd_sc_hd__nand2_1
XTAP_TAPCELL_ROW_25_346 VGND VPWR sky130_fd_sc_hd__tapvpwrvgnd_1
XFILLER_0_45_281 VGND VGND VPWR VPWR sky130_fd_sc_hd__fill_2
XFILLER_0_9_161 VGND VGND VPWR VPWR sky130_fd_sc_hd__decap_6
XFILLER_0_9_194 VGND VGND VPWR VPWR sky130_fd_sc_hd__decap_3
XPHY_EDGE_ROW_14_Right_14 VGND VGND VPWR VPWR sky130_fd_sc_hd__decap_3
XPHY_EDGE_ROW_23_Right_23 VGND VGND VPWR VPWR sky130_fd_sc_hd__decap_3
XFILLER_0_20_148 VGND VGND VPWR VPWR sky130_fd_sc_hd__fill_1
XFILLER_0_20_115 VGND VGND VPWR VPWR sky130_fd_sc_hd__decap_4
XFILLER_0_68_362 VGND VGND VPWR VPWR sky130_fd_sc_hd__fill_2
XPHY_EDGE_ROW_32_Right_32 VGND VGND VPWR VPWR sky130_fd_sc_hd__decap_3
XFILLER_0_51_251 VGND VGND VPWR VPWR sky130_fd_sc_hd__fill_1
X_3550_ _0601_ _0604_ _0605_ _1692_ VGND VGND VPWR VPWR _0606_ sky130_fd_sc_hd__a31o_1
X_2501_ _1537_ _1436_ _1432_ _1606_ VGND VGND VPWR VPWR _1607_ sky130_fd_sc_hd__or4_2
XFILLER_0_36_281 VGND VGND VPWR VPWR sky130_fd_sc_hd__fill_2
X_3481_ _0038_ _0505_ _0507_ _0523_ _0531_ VGND VGND VPWR VPWR _0532_ sky130_fd_sc_hd__o2111ai_1
XFILLER_0_24_421 VGND VGND VPWR VPWR sky130_fd_sc_hd__decap_6
XFILLER_0_22_78 VGND VGND VPWR VPWR sky130_fd_sc_hd__decap_6
XFILLER_0_3_304 VGND VGND VPWR VPWR sky130_fd_sc_hd__fill_1
X_4102_ _1153_ _1196_ _0406_ VGND VGND VPWR VPWR _1197_ sky130_fd_sc_hd__a21o_1
X_4033_ _1789_ _1928_ _0256_ VGND VGND VPWR VPWR _1123_ sky130_fd_sc_hd__a21oi_1
X_2432_ net67 net68 VGND VGND VPWR VPWR _1538_ sky130_fd_sc_hd__nor2_4
XPHY_EDGE_ROW_41_Right_41 VGND VGND VPWR VPWR sky130_fd_sc_hd__decap_3
X_2294_ _1200_ net35 VGND VGND VPWR VPWR _1400_ sky130_fd_sc_hd__or2b_1
X_2363_ _1468_ VGND VGND VPWR VPWR _1469_ sky130_fd_sc_hd__clkbuf_4
XPHY_EDGE_ROW_50_Right_50 VGND VGND VPWR VPWR sky130_fd_sc_hd__decap_3
XTAP_TAPCELL_ROW_39_449 VGND VPWR sky130_fd_sc_hd__tapvpwrvgnd_1
XFILLER_0_2_77 VGND VGND VPWR VPWR sky130_fd_sc_hd__decap_6
XANTENNA_22 _1374_ VGND VGND VPWR VPWR sky130_fd_sc_hd__diode_2
X_3817_ _1914_ _1867_ _0036_ VGND VGND VPWR VPWR _0893_ sky130_fd_sc_hd__or3_1
XTAP_TAPCELL_ROW_30_382 VGND VPWR sky130_fd_sc_hd__tapvpwrvgnd_1
XTAP_TAPCELL_ROW_22_327 VGND VPWR sky130_fd_sc_hd__tapvpwrvgnd_1
XFILLER_0_19_237 VGND VGND VPWR VPWR sky130_fd_sc_hd__fill_1
XANTENNA_11 _0661_ VGND VGND VPWR VPWR sky130_fd_sc_hd__diode_2
XFILLER_0_6_153 VPWR VGND VPWR VGND sky130_ef_sc_hd__decap_12
X_3748_ _1672_ _1393_ _1469_ _1674_ _1930_ VGND VGND VPWR VPWR _0819_ sky130_fd_sc_hd__o221ai_1
XANTENNA_33 _1884_ VGND VGND VPWR VPWR sky130_fd_sc_hd__diode_2
X_3679_ _1454_ _0633_ _1465_ VGND VGND VPWR VPWR _0745_ sky130_fd_sc_hd__or3_1
XFILLER_0_6_197 VGND VGND VPWR VPWR sky130_fd_sc_hd__decap_3
XTAP_TAPCELL_ROW_73_717 VGND VPWR sky130_fd_sc_hd__tapvpwrvgnd_1
XTAP_TAPCELL_ROW_73_706 VGND VPWR sky130_fd_sc_hd__tapvpwrvgnd_1
XFILLER_0_65_376 VGND VGND VPWR VPWR sky130_fd_sc_hd__decap_8
XFILLER_0_65_343 VPWR VGND VPWR VGND sky130_ef_sc_hd__decap_12
XFILLER_0_65_332 VGND VGND VPWR VPWR sky130_fd_sc_hd__decap_4
XFILLER_0_33_262 VPWR VGND VPWR VGND sky130_ef_sc_hd__decap_12
XFILLER_0_18_281 VPWR VGND VPWR VGND sky130_ef_sc_hd__decap_12
XFILLER_0_0_329 VGND VGND VPWR VPWR sky130_fd_sc_hd__decap_6
XFILLER_0_33_11 VGND VGND VPWR VPWR sky130_fd_sc_hd__fill_1
Xinput20 A[27] VGND VGND VPWR VPWR net20 sky130_fd_sc_hd__buf_1
XFILLER_0_56_365 VGND VGND VPWR VPWR sky130_fd_sc_hd__fill_1
X_2981_ _1728_ _1729_ _1853_ _1731_ _0026_ VGND VGND VPWR VPWR _0027_ sky130_fd_sc_hd__a311o_1
XTAP_TAPCELL_ROW_44_485 VGND VPWR sky130_fd_sc_hd__tapvpwrvgnd_1
X_3602_ _1607_ _2002_ _1644_ VGND VGND VPWR VPWR _0662_ sky130_fd_sc_hd__or3_1
XFILLER_0_33_99 VGND VGND VPWR VPWR sky130_fd_sc_hd__decap_6
Xinput31 A[8] VGND VGND VPWR VPWR net31 sky130_fd_sc_hd__buf_1
XFILLER_0_8_418 VGND VGND VPWR VPWR sky130_fd_sc_hd__fill_2
Xinput53 B[28] VGND VGND VPWR VPWR net53 sky130_fd_sc_hd__buf_2
XFILLER_0_58_63 VGND VGND VPWR VPWR sky130_fd_sc_hd__fill_2
Xinput42 B[18] VGND VGND VPWR VPWR net42 sky130_fd_sc_hd__buf_2
X_3533_ net60 _0304_ _0586_ VGND VGND VPWR VPWR _0587_ sky130_fd_sc_hd__o21ai_1
X_2415_ _1509_ _1515_ _1520_ VGND VGND VPWR VPWR _1521_ sky130_fd_sc_hd__o21bai_4
X_3464_ _1295_ _1297_ _1372_ VGND VGND VPWR VPWR _0513_ sky130_fd_sc_hd__or3_1
Xinput64 B[9] VGND VGND VPWR VPWR net64 sky130_fd_sc_hd__buf_2
X_2346_ _1451_ VGND VGND VPWR VPWR _1452_ sky130_fd_sc_hd__buf_2
X_4016_ _0642_ _0304_ _1105_ VGND VGND VPWR VPWR _1106_ sky130_fd_sc_hd__o21ai_1
XFILLER_0_28_3 VGND VGND VPWR VPWR sky130_fd_sc_hd__fill_1
X_3395_ _1453_ net32 _1289_ _1456_ _1585_ _1599_ VGND VGND VPWR VPWR _0439_ sky130_fd_sc_hd__mux4_1
X_2277_ net62 net30 VGND VGND VPWR VPWR _1383_ sky130_fd_sc_hd__or2b_1
XFILLER_0_59_181 VPWR VGND VPWR VGND sky130_ef_sc_hd__decap_12
XFILLER_0_65_195 VGND VGND VPWR VPWR sky130_fd_sc_hd__fill_1
XFILLER_0_57_129 VGND VGND VPWR VPWR sky130_fd_sc_hd__fill_2
XTAP_TAPCELL_ROW_41_466 VGND VPWR sky130_fd_sc_hd__tapvpwrvgnd_1
XFILLER_0_38_343 VPWR VGND VPWR VGND sky130_ef_sc_hd__decap_12
XFILLER_0_21_210 VGND VGND VPWR VPWR sky130_fd_sc_hd__fill_2
X_2131_ net54 net22 VGND VGND VPWR VPWR _0783_ sky130_fd_sc_hd__and2_1
X_3180_ _1865_ _0193_ _0204_ _0222_ VGND VGND VPWR VPWR _0223_ sky130_fd_sc_hd__o211ai_2
X_2200_ _1305_ VGND VGND VPWR VPWR _1306_ sky130_fd_sc_hd__inv_2
X_2964_ _2002_ _1726_ _2004_ _0009_ VGND VGND VPWR VPWR _0010_ sky130_fd_sc_hd__or4b_1
XTAP_TAPCELL_ROW_32_400 VGND VPWR sky130_fd_sc_hd__tapvpwrvgnd_1
XFILLER_0_71_143 VGND VGND VPWR VPWR sky130_fd_sc_hd__decap_6
XFILLER_0_60_53 VGND VGND VPWR VPWR sky130_fd_sc_hd__decap_3
XFILLER_0_4_410 VGND VGND VPWR VPWR sky130_fd_sc_hd__decap_8
XFILLER_0_4_421 VPWR VGND VPWR VGND sky130_ef_sc_hd__decap_12
X_2895_ _1998_ _1644_ _1876_ VGND VGND VPWR VPWR _1999_ sky130_fd_sc_hd__and3_1
X_3516_ _1659_ _1892_ _0074_ _1713_ _0569_ VGND VGND VPWR VPWR _0570_ sky130_fd_sc_hd__o221a_1
X_3447_ _1593_ _0986_ _1852_ _1580_ VGND VGND VPWR VPWR _0495_ sky130_fd_sc_hd__o211ai_1
X_3378_ _0078_ _1843_ _0194_ _0413_ _0420_ VGND VGND VPWR VPWR _0421_ sky130_fd_sc_hd__o41a_1
XPHY_EDGE_ROW_4_Right_4 VGND VGND VPWR VPWR sky130_fd_sc_hd__decap_3
XFILLER_0_67_405 VPWR VGND VPWR VGND sky130_ef_sc_hd__decap_12
X_2329_ net68 net67 _1434_ VGND VGND VPWR VPWR _1435_ sky130_fd_sc_hd__and3b_4
XFILLER_0_62_121 VPWR VGND VPWR VGND sky130_ef_sc_hd__decap_12
XTAP_TAPCELL_ROW_55_569 VGND VPWR sky130_fd_sc_hd__tapvpwrvgnd_1
XFILLER_0_7_270 VGND VGND VPWR VPWR sky130_fd_sc_hd__decap_8
XFILLER_0_73_408 VGND VGND VPWR VPWR sky130_fd_sc_hd__fill_1
XTAP_TAPCELL_ROW_46_503 VGND VPWR sky130_fd_sc_hd__tapvpwrvgnd_1
XTAP_TAPCELL_ROW_3_180 VGND VPWR sky130_fd_sc_hd__tapvpwrvgnd_1
XFILLER_0_73_419 VGND VGND VPWR VPWR sky130_fd_sc_hd__fill_1
XFILLER_0_53_176 VGND VGND VPWR VPWR sky130_fd_sc_hd__fill_2
XFILLER_0_53_154 VGND VGND VPWR VPWR sky130_fd_sc_hd__decap_4
XFILLER_0_38_173 VGND VGND VPWR VPWR sky130_fd_sc_hd__fill_2
X_2680_ net41 net9 net40 _1330_ VGND VGND VPWR VPWR _1786_ sky130_fd_sc_hd__a22o_1
XFILLER_0_39_65 VGND VGND VPWR VPWR sky130_fd_sc_hd__fill_1
X_3232_ _1694_ _1719_ _1649_ _1910_ _0273_ VGND VGND VPWR VPWR _0274_ sky130_fd_sc_hd__a311o_1
X_3301_ _0335_ _0336_ _0324_ _0338_ VGND VGND VPWR VPWR _0339_ sky130_fd_sc_hd__a2bb2o_1
XFILLER_0_55_31 VGND VGND VPWR VPWR sky130_fd_sc_hd__fill_1
X_3094_ _1662_ _1726_ _1652_ _1879_ VGND VGND VPWR VPWR _0138_ sky130_fd_sc_hd__or4b_1
X_2114_ _0589_ VGND VGND VPWR VPWR _0600_ sky130_fd_sc_hd__clkbuf_4
XFILLER_0_12_6 VGND VGND VPWR VPWR sky130_fd_sc_hd__decap_6
X_3163_ _1617_ _1624_ _1569_ _1620_ _1628_ _1972_ VGND VGND VPWR VPWR _0206_ sky130_fd_sc_hd__mux4_2
XFILLER_0_71_52 VGND VGND VPWR VPWR sky130_fd_sc_hd__decap_4
XFILLER_0_64_419 VGND VGND VPWR VPWR sky130_fd_sc_hd__fill_1
X_2947_ net52 _1430_ _1439_ VGND VGND VPWR VPWR _2050_ sky130_fd_sc_hd__o21ai_1
X_3996_ _0642_ _2017_ _1925_ _1083_ VGND VGND VPWR VPWR _1084_ sky130_fd_sc_hd__a2bb2o_1
XFILLER_0_29_151 VPWR VGND VPWR VGND sky130_ef_sc_hd__decap_12
XFILLER_0_17_335 VGND VGND VPWR VPWR sky130_fd_sc_hd__fill_1
X_2878_ _1980_ _1981_ _1874_ VGND VGND VPWR VPWR _1982_ sky130_fd_sc_hd__mux2_1
XFILLER_0_44_176 VGND VGND VPWR VPWR sky130_fd_sc_hd__fill_2
XFILLER_0_40_371 VPWR VGND VPWR VGND sky130_ef_sc_hd__decap_12
XFILLER_0_25_390 VGND VGND VPWR VPWR sky130_fd_sc_hd__fill_2
XTAP_TAPCELL_ROW_9_228 VGND VPWR sky130_fd_sc_hd__tapvpwrvgnd_1
XTAP_TAPCELL_ROW_68_672 VGND VPWR sky130_fd_sc_hd__tapvpwrvgnd_1
XTAP_TAPCELL_ROW_0_161 VGND VPWR sky130_fd_sc_hd__tapvpwrvgnd_1
XTAP_TAPCELL_ROW_0_150 VGND VPWR sky130_fd_sc_hd__tapvpwrvgnd_1
XFILLER_0_23_305 VGND VGND VPWR VPWR sky130_fd_sc_hd__decap_8
XFILLER_0_31_393 VGND VGND VPWR VPWR sky130_fd_sc_hd__fill_2
XFILLER_0_31_371 VGND VGND VPWR VPWR sky130_fd_sc_hd__fill_1
XFILLER_0_73_238 VGND VGND VPWR VPWR sky130_fd_sc_hd__decap_3
XFILLER_0_58_246 VGND VGND VPWR VPWR sky130_fd_sc_hd__decap_6
XFILLER_0_46_408 VPWR VGND VPWR VGND sky130_ef_sc_hd__decap_12
X_2801_ _1572_ net9 _1857_ VGND VGND VPWR VPWR _1906_ sky130_fd_sc_hd__o21ai_2
XFILLER_0_41_33 VPWR VGND VPWR VGND sky130_ef_sc_hd__decap_12
X_3850_ _1608_ _1611_ _1614_ _1830_ VGND VGND VPWR VPWR _0928_ sky130_fd_sc_hd__a31o_1
X_3781_ _0850_ _0852_ _0853_ _0211_ VGND VGND VPWR VPWR _0854_ sky130_fd_sc_hd__a31o_1
XTAP_TAPCELL_ROW_14_263 VGND VPWR sky130_fd_sc_hd__tapvpwrvgnd_1
XFILLER_0_41_113 VGND VGND VPWR VPWR sky130_fd_sc_hd__decap_6
X_2594_ _1699_ VGND VGND VPWR VPWR _1700_ sky130_fd_sc_hd__clkbuf_4
XFILLER_0_22_371 VPWR VGND VPWR VGND sky130_ef_sc_hd__decap_12
X_2663_ _1390_ _1768_ VGND VGND VPWR VPWR _1769_ sky130_fd_sc_hd__nand2_1
X_2732_ _1562_ _1453_ _1836_ VGND VGND VPWR VPWR _1837_ sky130_fd_sc_hd__a21oi_1
XFILLER_0_14_327 VPWR VGND VPWR VGND sky130_ef_sc_hd__decap_12
XFILLER_0_66_85 VGND VGND VPWR VPWR sky130_fd_sc_hd__fill_2
X_3215_ net57 _1922_ _0697_ _1445_ _0256_ VGND VGND VPWR VPWR _0257_ sky130_fd_sc_hd__a2111o_1
XFILLER_0_1_298 VGND VGND VPWR VPWR sky130_fd_sc_hd__decap_4
XFILLER_0_5_33 VGND VGND VPWR VPWR sky130_fd_sc_hd__fill_1
XFILLER_0_5_99 VGND VGND VPWR VPWR sky130_fd_sc_hd__fill_1
X_4195_ clknet_2_0__leaf_clk _2060_ net120 VGND VGND VPWR VPWR net77 sky130_fd_sc_hd__dfrtp_1
X_3077_ _0091_ _1431_ _0121_ VGND VGND VPWR VPWR _0122_ sky130_fd_sc_hd__o21ai_1
X_3146_ _0676_ _1443_ _1446_ _0188_ VGND VGND VPWR VPWR _0189_ sky130_fd_sc_hd__o211a_1
XFILLER_0_10_3 VGND VGND VPWR VPWR sky130_fd_sc_hd__fill_1
XFILLER_0_64_205 VPWR VGND VPWR VGND sky130_ef_sc_hd__decap_12
XFILLER_0_45_430 VGND VGND VPWR VPWR sky130_fd_sc_hd__fill_1
X_3979_ _2026_ _1064_ _1065_ VGND VGND VPWR VPWR _1066_ sky130_fd_sc_hd__or3_1
XFILLER_0_60_433 VGND VGND VPWR VPWR sky130_fd_sc_hd__decap_4
XFILLER_0_13_393 VGND VGND VPWR VPWR sky130_fd_sc_hd__decap_6
XTAP_TAPCELL_ROW_71_689 VGND VPWR sky130_fd_sc_hd__tapvpwrvgnd_1
XTAP_TAPCELL_ROW_28_366 VGND VPWR sky130_fd_sc_hd__tapvpwrvgnd_1
XTAP_TAPCELL_ROW_11_244 VGND VPWR sky130_fd_sc_hd__tapvpwrvgnd_1
XTAP_TAPCELL_ROW_62_623 VGND VPWR sky130_fd_sc_hd__tapvpwrvgnd_1
X_3000_ _1315_ _1510_ VGND VGND VPWR VPWR _0046_ sky130_fd_sc_hd__nand2_1
XTAP_TAPCELL_ROW_19_300 VGND VPWR sky130_fd_sc_hd__tapvpwrvgnd_1
Xinput7 A[15] VGND VGND VPWR VPWR net7 sky130_fd_sc_hd__buf_1
XFILLER_0_61_208 VGND VGND VPWR VPWR sky130_fd_sc_hd__decap_4
X_3902_ _1668_ _1613_ _0243_ VGND VGND VPWR VPWR _0983_ sky130_fd_sc_hd__a21o_1
X_3833_ _1471_ _1431_ _0478_ _0908_ VGND VGND VPWR VPWR _0909_ sky130_fd_sc_hd__o211a_1
XFILLER_0_6_335 VGND VGND VPWR VPWR sky130_fd_sc_hd__fill_2
X_3764_ _1314_ _1422_ _1467_ VGND VGND VPWR VPWR _0835_ sky130_fd_sc_hd__a21o_1
XFILLER_0_58_3 VGND VGND VPWR VPWR sky130_fd_sc_hd__decap_3
X_2577_ _1670_ net119 VGND VGND VPWR VPWR _1683_ sky130_fd_sc_hd__nand2_1
X_2715_ _1537_ _1538_ _1541_ VGND VGND VPWR VPWR _1820_ sky130_fd_sc_hd__and3_1
X_3695_ _1398_ _1314_ _1422_ _0761_ VGND VGND VPWR VPWR _0763_ sky130_fd_sc_hd__a31o_1
X_2646_ _1301_ _1302_ VGND VGND VPWR VPWR _1752_ sky130_fd_sc_hd__nand2_1
XFILLER_0_10_330 VPWR VGND VPWR VGND sky130_ef_sc_hd__decap_12
X_4178_ _0689_ _0268_ _0272_ _0865_ VGND VGND VPWR VPWR _1279_ sky130_fd_sc_hd__o2bb2a_1
X_3129_ _2030_ _0130_ _0131_ _0170_ _0172_ VGND VGND VPWR VPWR _0173_ sky130_fd_sc_hd__o311a_1
XFILLER_0_37_238 VGND VGND VPWR VPWR sky130_fd_sc_hd__fill_1
XTAP_TAPCELL_ROW_25_347 VGND VPWR sky130_fd_sc_hd__tapvpwrvgnd_1
XFILLER_0_20_138 VGND VGND VPWR VPWR sky130_fd_sc_hd__fill_2
XFILLER_0_43_208 VGND VGND VPWR VPWR sky130_fd_sc_hd__decap_8
XFILLER_0_51_285 VGND VGND VPWR VPWR sky130_fd_sc_hd__fill_1
X_2431_ _1434_ VGND VGND VPWR VPWR _1537_ sky130_fd_sc_hd__clkbuf_2
X_2500_ net67 net68 VGND VGND VPWR VPWR _1606_ sky130_fd_sc_hd__nand2_1
XFILLER_0_36_293 VPWR VGND VPWR VGND sky130_ef_sc_hd__decap_12
X_3480_ _1828_ _0526_ _0527_ _0530_ VGND VGND VPWR VPWR _0531_ sky130_fd_sc_hd__a31oi_1
X_4101_ _1145_ _1502_ VGND VGND VPWR VPWR _1196_ sky130_fd_sc_hd__nand2_1
X_4032_ _0433_ _0039_ _1121_ VGND VGND VPWR VPWR _1122_ sky130_fd_sc_hd__a21o_1
X_2293_ _1396_ _1397_ _1398_ _1125_ VGND VGND VPWR VPWR _1399_ sky130_fd_sc_hd__a31oi_1
X_2362_ net2 VGND VGND VPWR VPWR _1468_ sky130_fd_sc_hd__clkbuf_4
XFILLER_0_59_385 VGND VGND VPWR VPWR sky130_fd_sc_hd__fill_2
XANTENNA_23 _1435_ VGND VGND VPWR VPWR sky130_fd_sc_hd__diode_2
XFILLER_0_42_230 VPWR VGND VPWR VGND sky130_ef_sc_hd__decap_12
XANTENNA_34 _0166_ VGND VGND VPWR VPWR sky130_fd_sc_hd__diode_2
XTAP_TAPCELL_ROW_30_383 VGND VPWR sky130_fd_sc_hd__tapvpwrvgnd_1
X_3816_ _0889_ _0872_ _1489_ _1492_ VGND VGND VPWR VPWR _0892_ sky130_fd_sc_hd__a31o_1
XANTENNA_12 _0661_ VGND VGND VPWR VPWR sky130_fd_sc_hd__diode_2
XFILLER_0_6_165 VGND VGND VPWR VPWR sky130_fd_sc_hd__fill_2
X_3747_ _1392_ _1539_ _2010_ _1923_ net34 VGND VGND VPWR VPWR _0818_ sky130_fd_sc_hd__a32o_1
XFILLER_0_42_296 VGND VGND VPWR VPWR sky130_fd_sc_hd__decap_4
X_2629_ _1721_ _1725_ _1726_ _1734_ VGND VGND VPWR VPWR _1735_ sky130_fd_sc_hd__o211ai_1
X_3678_ _0735_ _0736_ _0737_ _0743_ VGND VGND VPWR VPWR _0744_ sky130_fd_sc_hd__o2bb2a_1
XFILLER_0_2_382 VGND VGND VPWR VPWR sky130_fd_sc_hd__decap_4
XFILLER_0_10_171 VGND VGND VPWR VPWR sky130_fd_sc_hd__fill_1
XTAP_TAPCELL_ROW_73_707 VGND VPWR sky130_fd_sc_hd__tapvpwrvgnd_1
XFILLER_0_65_355 VGND VGND VPWR VPWR sky130_fd_sc_hd__decap_4
XFILLER_0_65_300 VGND VGND VPWR VPWR sky130_fd_sc_hd__fill_1
XFILLER_0_33_274 VGND VGND VPWR VPWR sky130_fd_sc_hd__decap_6
XFILLER_0_33_252 VGND VGND VPWR VPWR sky130_fd_sc_hd__decap_3
XFILLER_0_18_293 VPWR VGND VPWR VGND sky130_ef_sc_hd__decap_12
XFILLER_0_17_24 VPWR VGND VPWR VGND sky130_ef_sc_hd__decap_12
X_2980_ _1654_ _1656_ _1858_ VGND VGND VPWR VPWR _0026_ sky130_fd_sc_hd__and3_1
Xinput54 B[29] VGND VGND VPWR VPWR net54 sky130_fd_sc_hd__clkbuf_2
Xinput21 A[28] VGND VGND VPWR VPWR net21 sky130_fd_sc_hd__buf_2
X_3601_ _0658_ _0106_ _0147_ _0660_ _0398_ VGND VGND VPWR VPWR _0661_ sky130_fd_sc_hd__a32o_1
Xinput43 B[19] VGND VGND VPWR VPWR net43 sky130_fd_sc_hd__buf_2
Xinput10 A[18] VGND VGND VPWR VPWR net10 sky130_fd_sc_hd__clkbuf_2
XTAP_TAPCELL_ROW_44_486 VGND VPWR sky130_fd_sc_hd__tapvpwrvgnd_1
XFILLER_0_24_230 VPWR VGND VPWR VGND sky130_ef_sc_hd__decap_12
Xinput32 A[9] VGND VGND VPWR VPWR net32 sky130_fd_sc_hd__clkbuf_4
Xinput65 opcode[0] VGND VGND VPWR VPWR net65 sky130_fd_sc_hd__clkbuf_2
XFILLER_0_24_274 VGND VGND VPWR VPWR sky130_fd_sc_hd__decap_3
X_3532_ _1696_ _1937_ _0428_ _0429_ VGND VGND VPWR VPWR _0586_ sky130_fd_sc_hd__o211a_1
X_2414_ _1405_ _1519_ VGND VGND VPWR VPWR _1520_ sky130_fd_sc_hd__nand2_1
X_3394_ _0251_ _1464_ _0334_ _1719_ VGND VGND VPWR VPWR _0437_ sky130_fd_sc_hd__o211ai_1
X_3463_ _0333_ _0510_ _0511_ VGND VGND VPWR VPWR _0512_ sky130_fd_sc_hd__a21bo_1
X_2345_ net15 VGND VGND VPWR VPWR _1451_ sky130_fd_sc_hd__buf_2
X_4015_ net42 _1444_ _1447_ VGND VGND VPWR VPWR _1105_ sky130_fd_sc_hd__o21a_1
X_2276_ net61 _1289_ VGND VGND VPWR VPWR _1382_ sky130_fd_sc_hd__or2b_1
XFILLER_0_59_193 VGND VGND VPWR VPWR sky130_fd_sc_hd__fill_1
XFILLER_0_47_377 VGND VGND VPWR VPWR sky130_fd_sc_hd__fill_1
XTAP_TAPCELL_ROW_35_420 VGND VPWR sky130_fd_sc_hd__tapvpwrvgnd_1
XTAP_TAPCELL_ROW_41_467 VGND VPWR sky130_fd_sc_hd__tapvpwrvgnd_1
XFILLER_0_38_355 VGND VGND VPWR VPWR sky130_fd_sc_hd__decap_4
XFILLER_0_21_277 VGND VGND VPWR VPWR sky130_fd_sc_hd__decap_3
XFILLER_0_0_149 VGND VGND VPWR VPWR sky130_fd_sc_hd__fill_1
X_2130_ net54 net22 VGND VGND VPWR VPWR _0772_ sky130_fd_sc_hd__nor2_2
XTAP_TAPCELL_ROW_49_523 VGND VPWR sky130_fd_sc_hd__tapvpwrvgnd_1
XFILLER_0_44_11 VGND VGND VPWR VPWR sky130_fd_sc_hd__fill_2
XFILLER_0_28_89 VGND VGND VPWR VPWR sky130_fd_sc_hd__fill_1
XFILLER_0_28_56 VGND VGND VPWR VPWR sky130_fd_sc_hd__fill_2
XFILLER_0_56_141 VGND VGND VPWR VPWR sky130_fd_sc_hd__decap_8
X_2963_ _1426_ _1588_ _1648_ _1876_ _0008_ VGND VGND VPWR VPWR _0009_ sky130_fd_sc_hd__a32o_1
XFILLER_0_44_99 VGND VGND VPWR VPWR sky130_fd_sc_hd__fill_1
XFILLER_0_44_66 VGND VGND VPWR VPWR sky130_fd_sc_hd__fill_1
XFILLER_0_44_55 VGND VGND VPWR VPWR sky130_fd_sc_hd__fill_2
XTAP_TAPCELL_ROW_32_401 VGND VPWR sky130_fd_sc_hd__tapvpwrvgnd_1
XFILLER_0_29_333 VGND VGND VPWR VPWR sky130_fd_sc_hd__decap_3
XFILLER_0_71_111 VGND VGND VPWR VPWR sky130_fd_sc_hd__fill_1
X_3515_ _1577_ _1330_ _1654_ _1656_ _1717_ VGND VGND VPWR VPWR _0569_ sky130_fd_sc_hd__o2111ai_1
XFILLER_0_4_433 VGND VGND VPWR VPWR sky130_fd_sc_hd__decap_4
XFILLER_0_8_55 VGND VGND VPWR VPWR sky130_fd_sc_hd__decap_8
XFILLER_0_12_244 VGND VGND VPWR VPWR sky130_fd_sc_hd__fill_1
X_2894_ _1654_ _1656_ _1957_ _1956_ _1697_ VGND VGND VPWR VPWR _1998_ sky130_fd_sc_hd__a32o_1
X_2328_ net69 VGND VGND VPWR VPWR _1434_ sky130_fd_sc_hd__buf_2
XFILLER_0_40_3 VGND VGND VPWR VPWR sky130_fd_sc_hd__decap_3
X_3446_ _0083_ _1891_ _0488_ _0493_ VGND VGND VPWR VPWR _0494_ sky130_fd_sc_hd__a31o_1
X_3377_ _1693_ _0092_ _0414_ _0415_ _0419_ VGND VGND VPWR VPWR _0420_ sky130_fd_sc_hd__o2111a_1
XFILLER_0_67_417 VPWR VGND VPWR VGND sky130_ef_sc_hd__decap_12
X_2259_ net61 _1289_ VGND VGND VPWR VPWR _1365_ sky130_fd_sc_hd__or2_1
XFILLER_0_62_177 VGND VGND VPWR VPWR sky130_fd_sc_hd__fill_1
XTAP_TAPCELL_ROW_46_504 VGND VPWR sky130_fd_sc_hd__tapvpwrvgnd_1
XFILLER_0_38_141 VGND VGND VPWR VPWR sky130_fd_sc_hd__decap_4
XTAP_TAPCELL_ROW_3_181 VGND VPWR sky130_fd_sc_hd__tapvpwrvgnd_1
XPHY_EDGE_ROW_9_Left_83 VGND VGND VPWR VPWR sky130_fd_sc_hd__decap_3
XFILLER_0_26_369 VGND VGND VPWR VPWR sky130_fd_sc_hd__decap_4
X_3300_ _0337_ _1696_ _1458_ _1454_ _1577_ _1587_ VGND VGND VPWR VPWR _0338_ sky130_fd_sc_hd__mux4_1
X_3162_ _1579_ _1309_ _1565_ _1574_ _1582_ _1604_ VGND VGND VPWR VPWR _0205_ sky130_fd_sc_hd__mux4_2
X_3231_ _0017_ _0012_ _1699_ VGND VGND VPWR VPWR _0273_ sky130_fd_sc_hd__mux2_1
XFILLER_0_55_87 VPWR VGND VPWR VGND sky130_ef_sc_hd__decap_12
X_3093_ _0133_ _0136_ _0031_ VGND VGND VPWR VPWR _0137_ sky130_fd_sc_hd__mux2_1
X_2113_ _0568_ _0579_ VGND VGND VPWR VPWR _0589_ sky130_fd_sc_hd__and2b_1
X_2946_ _1313_ _1421_ _2048_ VGND VGND VPWR VPWR _2049_ sky130_fd_sc_hd__a21oi_1
X_2877_ _1877_ _1479_ _1712_ VGND VGND VPWR VPWR _1981_ sky130_fd_sc_hd__o21a_1
X_3995_ net42 _1481_ VGND VGND VPWR VPWR _1083_ sky130_fd_sc_hd__and2_1
XFILLER_0_29_163 VGND VGND VPWR VPWR sky130_fd_sc_hd__decap_4
XTAP_TAPCELL_ROW_17_283 VGND VPWR sky130_fd_sc_hd__tapvpwrvgnd_1
XFILLER_0_17_358 VPWR VGND VPWR VGND sky130_ef_sc_hd__decap_12
XFILLER_0_40_383 VGND VGND VPWR VPWR sky130_fd_sc_hd__decap_3
XTAP_TAPCELL_ROW_9_229 VGND VPWR sky130_fd_sc_hd__tapvpwrvgnd_1
X_3429_ _0466_ _0467_ _0469_ _0475_ VGND VGND VPWR VPWR _0476_ sky130_fd_sc_hd__and4_1
XTAP_TAPCELL_ROW_51_540 VGND VPWR sky130_fd_sc_hd__tapvpwrvgnd_1
XTAP_TAPCELL_ROW_0_162 VGND VPWR sky130_fd_sc_hd__tapvpwrvgnd_1
XTAP_TAPCELL_ROW_0_151 VGND VPWR sky130_fd_sc_hd__tapvpwrvgnd_1
XFILLER_0_50_114 VGND VGND VPWR VPWR sky130_fd_sc_hd__fill_2
XFILLER_0_35_199 VPWR VGND VPWR VGND sky130_ef_sc_hd__decap_12
XFILLER_0_35_144 VGND VGND VPWR VPWR sky130_fd_sc_hd__fill_1
XFILLER_0_25_57 VGND VGND VPWR VPWR sky130_fd_sc_hd__decap_8
XFILLER_0_25_46 VGND VGND VPWR VPWR sky130_fd_sc_hd__decap_3
XFILLER_0_73_217 VGND VGND VPWR VPWR sky130_fd_sc_hd__decap_3
XFILLER_0_66_291 VGND VGND VPWR VPWR sky130_fd_sc_hd__fill_2
XFILLER_0_58_236 VGND VGND VPWR VPWR sky130_fd_sc_hd__fill_2
X_2800_ _1577_ _1789_ _1861_ VGND VGND VPWR VPWR _1905_ sky130_fd_sc_hd__o21ai_2
X_3780_ _0046_ _0034_ _0596_ _1830_ VGND VGND VPWR VPWR _0853_ sky130_fd_sc_hd__a211o_1
XFILLER_0_41_45 VGND VGND VPWR VPWR sky130_fd_sc_hd__decap_8
XFILLER_0_26_155 VPWR VGND VPWR VGND sky130_ef_sc_hd__decap_12
XFILLER_0_26_111 VGND VGND VPWR VPWR sky130_fd_sc_hd__decap_4
X_2731_ _1593_ _1289_ VGND VGND VPWR VPWR _1836_ sky130_fd_sc_hd__and2_1
XTAP_TAPCELL_ROW_14_264 VGND VPWR sky130_fd_sc_hd__tapvpwrvgnd_1
XFILLER_0_22_383 VGND VGND VPWR VPWR sky130_fd_sc_hd__decap_3
X_2662_ net34 net2 VGND VGND VPWR VPWR _1768_ sky130_fd_sc_hd__or2b_1
XFILLER_0_1_244 VGND VGND VPWR VPWR sky130_fd_sc_hd__decap_6
XFILLER_0_14_339 VPWR VGND VPWR VGND sky130_ef_sc_hd__decap_12
X_2593_ _1659_ _1660_ VGND VGND VPWR VPWR _1699_ sky130_fd_sc_hd__nor2_2
X_3145_ _1417_ _1429_ _1353_ _1948_ _1354_ VGND VGND VPWR VPWR _0188_ sky130_fd_sc_hd__o221ai_1
X_3214_ _1677_ VGND VGND VPWR VPWR _0256_ sky130_fd_sc_hd__clkbuf_4
X_4194_ clknet_2_0__leaf_clk _2059_ net120 VGND VGND VPWR VPWR net76 sky130_fd_sc_hd__dfrtp_1
X_3076_ net53 _1444_ _1447_ VGND VGND VPWR VPWR _0121_ sky130_fd_sc_hd__o21a_1
XTAP_TAPCELL_ROW_65_643 VGND VPWR sky130_fd_sc_hd__tapvpwrvgnd_1
XFILLER_0_64_217 VPWR VGND VPWR VGND sky130_ef_sc_hd__decap_12
XPHY_EDGE_ROW_59_Left_133 VGND VGND VPWR VPWR sky130_fd_sc_hd__decap_3
XFILLER_0_49_225 VPWR VGND VPWR VGND sky130_ef_sc_hd__decap_12
XFILLER_0_37_409 VGND VGND VPWR VPWR sky130_fd_sc_hd__fill_1
XFILLER_0_72_250 VGND VGND VPWR VPWR sky130_fd_sc_hd__fill_2
X_2929_ _1420_ VGND VGND VPWR VPWR _2033_ sky130_fd_sc_hd__clkbuf_4
X_3978_ _1063_ _1785_ _1489_ VGND VGND VPWR VPWR _1065_ sky130_fd_sc_hd__and3_1
XFILLER_0_9_377 VGND VGND VPWR VPWR sky130_fd_sc_hd__decap_3
XFILLER_0_17_155 VPWR VGND VPWR VGND sky130_ef_sc_hd__decap_12
XPHY_EDGE_ROW_68_Left_142 VGND VGND VPWR VPWR sky130_fd_sc_hd__decap_3
XFILLER_0_20_309 VPWR VGND VPWR VGND sky130_ef_sc_hd__decap_12
XTAP_TAPCELL_ROW_28_367 VGND VPWR sky130_fd_sc_hd__tapvpwrvgnd_1
XFILLER_0_23_136 VPWR VGND VPWR VGND sky130_ef_sc_hd__decap_12
Xinput8 A[16] VGND VGND VPWR VPWR net8 sky130_fd_sc_hd__clkbuf_2
XTAP_TAPCELL_ROW_62_624 VGND VPWR sky130_fd_sc_hd__tapvpwrvgnd_1
XFILLER_0_52_66 VGND VGND VPWR VPWR sky130_fd_sc_hd__decap_6
XFILLER_0_52_44 VGND VGND VPWR VPWR sky130_fd_sc_hd__fill_1
XFILLER_0_52_22 VGND VGND VPWR VPWR sky130_fd_sc_hd__decap_6
X_3901_ _0064_ _1646_ _0685_ _0981_ VGND VGND VPWR VPWR _0982_ sky130_fd_sc_hd__o31a_1
XTAP_TAPCELL_ROW_19_301 VGND VPWR sky130_fd_sc_hd__tapvpwrvgnd_1
X_2714_ _0869_ _1813_ VGND VGND VPWR VPWR _1819_ sky130_fd_sc_hd__nor2_1
XFILLER_0_42_412 VGND VGND VPWR VPWR sky130_fd_sc_hd__decap_8
X_3694_ _1397_ _1444_ _1447_ VGND VGND VPWR VPWR _0761_ sky130_fd_sc_hd__o21ai_1
X_3832_ _1313_ _1421_ _1050_ VGND VGND VPWR VPWR _0908_ sky130_fd_sc_hd__a21o_1
XFILLER_0_14_136 VGND VGND VPWR VPWR sky130_fd_sc_hd__decap_4
X_3763_ _0800_ _0832_ _0834_ VGND VGND VPWR VPWR _2059_ sky130_fd_sc_hd__nand3b_1
X_2576_ _1538_ net119 VGND VGND VPWR VPWR _1682_ sky130_fd_sc_hd__nand2_4
X_2645_ _1305_ net1 VGND VGND VPWR VPWR _1751_ sky130_fd_sc_hd__nand2_2
XFILLER_0_10_342 VGND VGND VPWR VPWR sky130_fd_sc_hd__decap_4
XFILLER_0_14_169 VGND VGND VPWR VPWR sky130_fd_sc_hd__fill_1
X_3128_ net54 _1441_ _0171_ VGND VGND VPWR VPWR _0172_ sky130_fd_sc_hd__o21ai_1
X_4177_ _1914_ _0070_ _0273_ _0781_ VGND VGND VPWR VPWR _1278_ sky130_fd_sc_hd__a31o_1
XTAP_TAPCELL_ROW_25_348 VGND VPWR sky130_fd_sc_hd__tapvpwrvgnd_1
X_3059_ _1461_ _1463_ net26 _1302_ _1585_ _1621_ VGND VGND VPWR VPWR _0104_ sky130_fd_sc_hd__mux4_2
XFILLER_0_9_141 VGND VGND VPWR VPWR sky130_fd_sc_hd__decap_4
XFILLER_0_9_174 VPWR VGND VPWR VGND sky130_ef_sc_hd__decap_12
XFILLER_0_60_264 VGND VGND VPWR VPWR sky130_fd_sc_hd__fill_1
XFILLER_0_60_253 VGND VGND VPWR VPWR sky130_fd_sc_hd__fill_2
XFILLER_0_60_220 VPWR VGND VPWR VGND sky130_ef_sc_hd__decap_12
XFILLER_0_52_209 VGND VGND VPWR VPWR sky130_fd_sc_hd__fill_2
XFILLER_0_33_401 VGND VGND VPWR VPWR sky130_fd_sc_hd__decap_8
XFILLER_0_68_342 VPWR VGND VPWR VGND sky130_ef_sc_hd__decap_12
XFILLER_0_36_272 VGND VGND VPWR VPWR sky130_fd_sc_hd__fill_2
XFILLER_0_24_401 VGND VGND VPWR VPWR sky130_fd_sc_hd__decap_8
X_2430_ _1521_ _1535_ _0654_ VGND VGND VPWR VPWR _1536_ sky130_fd_sc_hd__a21oi_2
X_2361_ _1200_ VGND VGND VPWR VPWR _1467_ sky130_fd_sc_hd__clkbuf_4
X_4100_ _1336_ _1337_ _0384_ _0395_ _1193_ VGND VGND VPWR VPWR _1195_ sky130_fd_sc_hd__o2111ai_1
XFILLER_0_47_77 VGND VGND VPWR VPWR sky130_fd_sc_hd__decap_8
X_4031_ _2004_ _0403_ _2054_ _1591_ _1557_ VGND VGND VPWR VPWR _1121_ sky130_fd_sc_hd__a221o_1
XPHY_EDGE_ROW_22_Left_96 VGND VGND VPWR VPWR sky130_fd_sc_hd__decap_3
X_2292_ net31 VGND VGND VPWR VPWR _1398_ sky130_fd_sc_hd__inv_2
XFILLER_0_63_65 VGND VGND VPWR VPWR sky130_fd_sc_hd__decap_3
XFILLER_0_63_54 VGND VGND VPWR VPWR sky130_fd_sc_hd__fill_2
XANTENNA_13 _0693_ VGND VGND VPWR VPWR sky130_fd_sc_hd__diode_2
XFILLER_0_70_3 VPWR VGND VPWR VGND sky130_ef_sc_hd__decap_12
XANTENNA_24 _1485_ VGND VGND VPWR VPWR sky130_fd_sc_hd__diode_2
XFILLER_0_42_242 VGND VGND VPWR VPWR sky130_fd_sc_hd__decap_8
X_3746_ _1608_ _0064_ _2000_ VGND VGND VPWR VPWR _0817_ sky130_fd_sc_hd__or3_1
XTAP_TAPCELL_ROW_30_384 VGND VPWR sky130_fd_sc_hd__tapvpwrvgnd_1
X_3815_ _0889_ _1487_ _0872_ VGND VGND VPWR VPWR _0891_ sky130_fd_sc_hd__a21oi_1
XANTENNA_35 _0267_ VGND VGND VPWR VPWR sky130_fd_sc_hd__diode_2
X_3677_ _1705_ _0413_ _0693_ _0742_ VGND VGND VPWR VPWR _0743_ sky130_fd_sc_hd__o211a_1
XFILLER_0_6_177 VPWR VGND VPWR VGND sky130_ef_sc_hd__decap_12
X_2559_ _1436_ _1432_ VGND VGND VPWR VPWR _1665_ sky130_fd_sc_hd__nand2_2
X_2628_ _1728_ _1729_ _1730_ _1731_ _1733_ VGND VGND VPWR VPWR _1734_ sky130_fd_sc_hd__a311o_1
XTAP_TAPCELL_ROW_73_708 VGND VPWR sky130_fd_sc_hd__tapvpwrvgnd_1
XTAP_TAPCELL_ROW_38_440 VGND VPWR sky130_fd_sc_hd__tapvpwrvgnd_1
XFILLER_0_25_209 VPWR VGND VPWR VGND sky130_ef_sc_hd__decap_12
XFILLER_0_0_309 VGND VGND VPWR VPWR sky130_fd_sc_hd__fill_2
XFILLER_0_17_36 VGND VGND VPWR VPWR sky130_fd_sc_hd__decap_6
XFILLER_0_56_345 VPWR VGND VPWR VGND sky130_ef_sc_hd__decap_12
XTAP_TAPCELL_ROW_44_487 VGND VPWR sky130_fd_sc_hd__tapvpwrvgnd_1
XFILLER_0_33_68 VGND VGND VPWR VPWR sky130_fd_sc_hd__decap_6
XFILLER_0_33_57 VGND VGND VPWR VPWR sky130_fd_sc_hd__decap_8
Xinput66 opcode[1] VGND VGND VPWR VPWR net66 sky130_fd_sc_hd__buf_2
Xinput22 A[29] VGND VGND VPWR VPWR net22 sky130_fd_sc_hd__buf_2
X_3600_ _0031_ _0218_ _0659_ VGND VGND VPWR VPWR _0660_ sky130_fd_sc_hd__o21ai_1
XFILLER_0_56_378 VGND VGND VPWR VPWR sky130_fd_sc_hd__decap_8
Xinput11 A[19] VGND VGND VPWR VPWR net11 sky130_fd_sc_hd__clkbuf_2
X_3531_ net60 _1938_ _0478_ VGND VGND VPWR VPWR _0585_ sky130_fd_sc_hd__o21ai_1
XFILLER_0_24_297 VGND VGND VPWR VPWR sky130_fd_sc_hd__decap_4
XFILLER_0_24_242 VGND VGND VPWR VPWR sky130_fd_sc_hd__decap_8
XFILLER_0_3_169 VGND VGND VPWR VPWR sky130_fd_sc_hd__fill_2
Xinput44 B[1] VGND VGND VPWR VPWR net44 sky130_fd_sc_hd__clkbuf_2
Xinput55 B[2] VGND VGND VPWR VPWR net55 sky130_fd_sc_hd__buf_4
Xinput33 B[0] VGND VGND VPWR VPWR net33 sky130_fd_sc_hd__clkbuf_1
X_2344_ _1449_ VGND VGND VPWR VPWR _1450_ sky130_fd_sc_hd__clkbuf_4
X_2413_ _1518_ _1114_ _1394_ VGND VGND VPWR VPWR _1519_ sky130_fd_sc_hd__nor3_1
X_3462_ _0333_ _0510_ _1435_ _1553_ VGND VGND VPWR VPWR _0511_ sky130_fd_sc_hd__o211a_1
X_3393_ _1719_ _1564_ _1578_ _1955_ _0433_ VGND VGND VPWR VPWR _0436_ sky130_fd_sc_hd__o311a_1
X_4014_ _1101_ _2026_ _1102_ VGND VGND VPWR VPWR _1103_ sky130_fd_sc_hd__or3_1
XTAP_TAPCELL_ROW_35_421 VGND VPWR sky130_fd_sc_hd__tapvpwrvgnd_1
X_2275_ net60 _1378_ _1380_ VGND VGND VPWR VPWR _1381_ sky130_fd_sc_hd__o21ai_2
XFILLER_0_62_337 VGND VGND VPWR VPWR sky130_fd_sc_hd__fill_2
XFILLER_0_59_150 VGND VGND VPWR VPWR sky130_fd_sc_hd__fill_1
XFILLER_0_47_389 VGND VGND VPWR VPWR sky130_fd_sc_hd__decap_3
X_3729_ _0765_ _0766_ _0768_ _0798_ VGND VGND VPWR VPWR _2089_ sky130_fd_sc_hd__a211o_1
XFILLER_0_65_153 VGND VGND VPWR VPWR sky130_fd_sc_hd__decap_4
XFILLER_0_53_337 VGND VGND VPWR VPWR sky130_fd_sc_hd__decap_8
XFILLER_0_53_304 VGND VGND VPWR VPWR sky130_fd_sc_hd__decap_3
XTAP_TAPCELL_ROW_41_468 VGND VPWR sky130_fd_sc_hd__tapvpwrvgnd_1
XFILLER_0_0_128 VGND VGND VPWR VPWR sky130_fd_sc_hd__fill_1
XTAP_TAPCELL_ROW_49_524 VGND VPWR sky130_fd_sc_hd__tapvpwrvgnd_1
X_2962_ _1347_ net22 net24 net21 _1632_ _1567_ VGND VGND VPWR VPWR _0008_ sky130_fd_sc_hd__mux4_1
XFILLER_0_56_197 VGND VGND VPWR VPWR sky130_fd_sc_hd__decap_6
XFILLER_0_56_164 VGND VGND VPWR VPWR sky130_fd_sc_hd__decap_8
XFILLER_0_56_131 VGND VGND VPWR VPWR sky130_fd_sc_hd__fill_1
XTAP_TAPCELL_ROW_32_402 VGND VPWR sky130_fd_sc_hd__tapvpwrvgnd_1
X_2893_ _1995_ _1996_ _1876_ VGND VGND VPWR VPWR _1997_ sky130_fd_sc_hd__mux2_1
X_3445_ _0242_ _1986_ _2055_ _0491_ VGND VGND VPWR VPWR _0493_ sky130_fd_sc_hd__o31ai_1
XPHY_EDGE_ROW_31_Left_105 VGND VGND VPWR VPWR sky130_fd_sc_hd__decap_3
X_3514_ _0552_ _0554_ _0566_ VGND VGND VPWR VPWR _0567_ sky130_fd_sc_hd__and3_1
X_2327_ _1432_ VGND VGND VPWR VPWR _1433_ sky130_fd_sc_hd__clkbuf_2
XFILLER_0_33_3 VGND VGND VPWR VPWR sky130_fd_sc_hd__decap_8
X_3376_ _0416_ _2037_ _0418_ VGND VGND VPWR VPWR _0419_ sky130_fd_sc_hd__or3_1
X_2258_ net61 _1289_ VGND VGND VPWR VPWR _1364_ sky130_fd_sc_hd__nand2_2
XFILLER_0_67_429 VGND VGND VPWR VPWR sky130_fd_sc_hd__decap_4
XPHY_EDGE_ROW_40_Left_114 VGND VGND VPWR VPWR sky130_fd_sc_hd__decap_3
X_2189_ net58 net26 VGND VGND VPWR VPWR _1295_ sky130_fd_sc_hd__nor2_4
XFILLER_0_50_318 VPWR VGND VPWR VGND sky130_ef_sc_hd__decap_12
XFILLER_0_47_175 VGND VGND VPWR VPWR sky130_fd_sc_hd__fill_1
XFILLER_0_35_337 VGND VGND VPWR VPWR sky130_fd_sc_hd__fill_2
XFILLER_0_35_315 VGND VGND VPWR VPWR sky130_fd_sc_hd__fill_1
XTAP_TAPCELL_ROW_46_505 VGND VPWR sky130_fd_sc_hd__tapvpwrvgnd_1
XTAP_TAPCELL_ROW_3_182 VGND VPWR sky130_fd_sc_hd__tapvpwrvgnd_1
XFILLER_0_58_418 VGND VGND VPWR VPWR sky130_fd_sc_hd__fill_2
XTAP_TAPCELL_ROW_54_560 VGND VPWR sky130_fd_sc_hd__tapvpwrvgnd_1
XFILLER_0_38_197 VGND VGND VPWR VPWR sky130_fd_sc_hd__decap_4
XFILLER_0_38_186 VGND VGND VPWR VPWR sky130_fd_sc_hd__fill_1
XFILLER_0_26_315 VGND VGND VPWR VPWR sky130_fd_sc_hd__decap_4
XFILLER_0_5_209 VPWR VGND VPWR VGND sky130_ef_sc_hd__decap_12
XFILLER_0_14_59 VGND VGND VPWR VPWR sky130_fd_sc_hd__decap_3
XFILLER_0_53_134 VGND VGND VPWR VPWR sky130_fd_sc_hd__decap_8
X_3161_ _0078_ _1652_ _1598_ _0194_ _0203_ VGND VGND VPWR VPWR _0204_ sky130_fd_sc_hd__o41a_1
X_2112_ net41 net9 VGND VGND VPWR VPWR _0579_ sky130_fd_sc_hd__nand2_1
X_3230_ _0068_ _0025_ _0271_ VGND VGND VPWR VPWR _0272_ sky130_fd_sc_hd__o21ai_1
XFILLER_0_55_99 VGND VGND VPWR VPWR sky130_fd_sc_hd__decap_3
X_3092_ _1972_ _1840_ _1843_ _0135_ VGND VGND VPWR VPWR _0136_ sky130_fd_sc_hd__o31a_1
XFILLER_0_72_421 VPWR VGND VPWR VGND sky130_ef_sc_hd__decap_12
X_2945_ _1347_ VGND VGND VPWR VPWR _2048_ sky130_fd_sc_hd__clkbuf_4
X_2876_ _1451_ _1877_ _1714_ VGND VGND VPWR VPWR _1980_ sky130_fd_sc_hd__o21a_1
XFILLER_0_44_123 VPWR VGND VPWR VGND sky130_ef_sc_hd__decap_12
X_3994_ _1784_ _2009_ _2010_ _0349_ _0557_ VGND VGND VPWR VPWR _1081_ sky130_fd_sc_hd__a32o_1
XFILLER_0_32_307 VGND VGND VPWR VPWR sky130_fd_sc_hd__fill_1
XFILLER_0_29_186 VGND VGND VPWR VPWR sky130_fd_sc_hd__decap_8
XFILLER_0_4_231 VPWR VGND VPWR VGND sky130_ef_sc_hd__decap_12
XTAP_TAPCELL_ROW_17_284 VGND VPWR sky130_fd_sc_hd__tapvpwrvgnd_1
XFILLER_0_17_304 VGND VGND VPWR VPWR sky130_fd_sc_hd__fill_1
XFILLER_0_17_315 VGND VGND VPWR VPWR sky130_fd_sc_hd__fill_2
XFILLER_0_40_362 VGND VGND VPWR VPWR sky130_fd_sc_hd__fill_2
XFILLER_0_4_253 VPWR VGND VPWR VGND sky130_ef_sc_hd__decap_12
X_3428_ _0472_ _0473_ _1491_ _0474_ VGND VGND VPWR VPWR _0475_ sky130_fd_sc_hd__o31a_1
XFILLER_0_20_91 VGND VGND VPWR VPWR sky130_fd_sc_hd__decap_8
X_3359_ _0399_ _0208_ _0147_ VGND VGND VPWR VPWR _0400_ sky130_fd_sc_hd__and3_1
XFILLER_0_67_237 VGND VGND VPWR VPWR sky130_fd_sc_hd__decap_8
XFILLER_0_63_421 VPWR VGND VPWR VGND sky130_ef_sc_hd__decap_12
XTAP_TAPCELL_ROW_51_541 VGND VPWR sky130_fd_sc_hd__tapvpwrvgnd_1
XFILLER_0_35_101 VGND VGND VPWR VPWR sky130_fd_sc_hd__decap_8
XTAP_TAPCELL_ROW_0_152 VGND VPWR sky130_fd_sc_hd__tapvpwrvgnd_1
XFILLER_0_41_57 VGND VGND VPWR VPWR sky130_fd_sc_hd__decap_6
XFILLER_0_26_167 VPWR VGND VPWR VGND sky130_ef_sc_hd__decap_12
X_2730_ _1570_ _1378_ _1834_ VGND VGND VPWR VPWR _1835_ sky130_fd_sc_hd__o21a_1
X_2661_ _1516_ _1766_ VGND VGND VPWR VPWR _1767_ sky130_fd_sc_hd__nor2_1
XFILLER_0_14_307 VGND VGND VPWR VPWR sky130_fd_sc_hd__fill_1
XTAP_TAPCELL_ROW_14_265 VGND VPWR sky130_fd_sc_hd__tapvpwrvgnd_1
XFILLER_0_22_395 VPWR VGND VPWR VGND sky130_ef_sc_hd__decap_12
XFILLER_0_22_362 VGND VGND VPWR VPWR sky130_fd_sc_hd__fill_2
XFILLER_0_22_351 VGND VGND VPWR VPWR sky130_fd_sc_hd__decap_3
XFILLER_0_1_201 VGND VGND VPWR VPWR sky130_fd_sc_hd__fill_1
XFILLER_0_1_234 VGND VGND VPWR VPWR sky130_fd_sc_hd__fill_2
X_2592_ _1456_ _1696_ _1458_ _1453_ _1621_ _1697_ VGND VGND VPWR VPWR _1698_ sky130_fd_sc_hd__mux4_1
X_3075_ _0091_ _1938_ _0119_ VGND VGND VPWR VPWR _0120_ sky130_fd_sc_hd__o21ai_1
X_3144_ _0676_ _1939_ _1439_ VGND VGND VPWR VPWR _0187_ sky130_fd_sc_hd__o21a_1
X_3213_ _1954_ _0254_ _1865_ VGND VGND VPWR VPWR _0255_ sky130_fd_sc_hd__a21oi_1
X_4193_ clknet_2_0__leaf_clk _2089_ net120 VGND VGND VPWR VPWR net106 sky130_fd_sc_hd__dfrtp_1
XTAP_TAPCELL_ROW_65_644 VGND VPWR sky130_fd_sc_hd__tapvpwrvgnd_1
XFILLER_0_64_229 VGND VGND VPWR VPWR sky130_fd_sc_hd__decap_6
XFILLER_0_57_281 VGND VGND VPWR VPWR sky130_fd_sc_hd__fill_2
XFILLER_0_49_237 VGND VGND VPWR VPWR sky130_fd_sc_hd__decap_4
X_3977_ _1063_ _1486_ _1785_ VGND VGND VPWR VPWR _1064_ sky130_fd_sc_hd__a21oi_1
XFILLER_0_9_312 VGND VGND VPWR VPWR sky130_fd_sc_hd__fill_2
XFILLER_0_9_334 VGND VGND VPWR VPWR sky130_fd_sc_hd__fill_2
X_2928_ _1312_ VGND VGND VPWR VPWR _2032_ sky130_fd_sc_hd__clkbuf_4
XFILLER_0_32_115 VGND VGND VPWR VPWR sky130_fd_sc_hd__decap_6
X_2859_ _1570_ _1459_ _1580_ _1578_ VGND VGND VPWR VPWR _1963_ sky130_fd_sc_hd__a211oi_1
XFILLER_0_17_123 VGND VGND VPWR VPWR sky130_fd_sc_hd__decap_3
XFILLER_0_17_167 VGND VGND VPWR VPWR sky130_fd_sc_hd__fill_1
XTAP_TAPCELL_ROW_28_368 VGND VPWR sky130_fd_sc_hd__tapvpwrvgnd_1
XFILLER_0_36_421 VPWR VGND VPWR VGND sky130_ef_sc_hd__decap_12
XFILLER_0_36_410 VGND VGND VPWR VPWR sky130_fd_sc_hd__decap_8
XFILLER_0_23_148 VGND VGND VPWR VPWR sky130_fd_sc_hd__decap_6
Xinput9 A[17] VGND VGND VPWR VPWR net9 sky130_fd_sc_hd__clkbuf_4
XFILLER_0_36_35 VPWR VGND VPWR VGND sky130_ef_sc_hd__decap_12
XTAP_TAPCELL_ROW_19_302 VGND VPWR sky130_fd_sc_hd__tapvpwrvgnd_1
XTAP_TAPCELL_ROW_62_625 VGND VPWR sky130_fd_sc_hd__tapvpwrvgnd_1
XFILLER_0_52_89 VGND VGND VPWR VPWR sky130_fd_sc_hd__fill_1
XFILLER_0_46_218 VGND VGND VPWR VPWR sky130_fd_sc_hd__decap_3
X_3900_ _1728_ _1986_ _0085_ _0682_ _0865_ VGND VGND VPWR VPWR _0981_ sky130_fd_sc_hd__o32a_1
X_3831_ _0873_ _0874_ _0876_ _0907_ VGND VGND VPWR VPWR _2061_ sky130_fd_sc_hd__a211o_1
XTAP_TAPCELL_ROW_70_680 VGND VPWR sky130_fd_sc_hd__tapvpwrvgnd_1
X_2713_ _0654_ _1817_ _1508_ VGND VGND VPWR VPWR _1818_ sky130_fd_sc_hd__o21bai_2
X_3693_ _0734_ _0744_ _0758_ _0759_ VGND VGND VPWR VPWR _0760_ sky130_fd_sc_hd__and4_1
X_2644_ _1298_ _1299_ VGND VGND VPWR VPWR _1750_ sky130_fd_sc_hd__nor2_1
XFILLER_0_6_348 VPWR VGND VPWR VGND sky130_ef_sc_hd__decap_12
X_3762_ _1524_ _1314_ _1422_ _0833_ VGND VGND VPWR VPWR _0834_ sky130_fd_sc_hd__a31o_1
X_2575_ _1423_ net49 VGND VGND VPWR VPWR _1681_ sky130_fd_sc_hd__nand2_1
XFILLER_0_10_354 VGND VGND VPWR VPWR sky130_fd_sc_hd__decap_8
X_3127_ _1357_ _1430_ _1944_ VGND VGND VPWR VPWR _0171_ sky130_fd_sc_hd__a21oi_1
X_4176_ _1592_ _1558_ _0248_ _1276_ VGND VGND VPWR VPWR _1277_ sky130_fd_sc_hd__o31a_1
X_3058_ _0101_ _0102_ _1723_ _1722_ _1627_ _1629_ VGND VGND VPWR VPWR _0103_ sky130_fd_sc_hd__mux4_2
XTAP_TAPCELL_ROW_25_349 VGND VPWR sky130_fd_sc_hd__tapvpwrvgnd_1
XFILLER_0_9_186 VGND VGND VPWR VPWR sky130_fd_sc_hd__decap_8
XFILLER_0_18_421 VGND VGND VPWR VPWR sky130_fd_sc_hd__decap_6
XFILLER_0_60_232 VGND VGND VPWR VPWR sky130_fd_sc_hd__fill_1
XFILLER_0_68_365 VPWR VGND VPWR VGND sky130_ef_sc_hd__decap_12
XFILLER_0_68_354 VGND VGND VPWR VPWR sky130_fd_sc_hd__decap_8
XFILLER_0_68_321 VPWR VGND VPWR VGND sky130_ef_sc_hd__decap_12
XFILLER_0_51_243 VGND VGND VPWR VPWR sky130_fd_sc_hd__decap_8
XFILLER_0_36_251 VGND VGND VPWR VPWR sky130_fd_sc_hd__fill_1
XFILLER_0_51_298 VPWR VGND VPWR VGND sky130_ef_sc_hd__decap_12
XFILLER_0_47_34 VGND VGND VPWR VPWR sky130_fd_sc_hd__fill_1
X_2291_ net63 VGND VGND VPWR VPWR _1397_ sky130_fd_sc_hd__buf_2
X_2360_ _1454_ _1457_ _1458_ _1465_ VGND VGND VPWR VPWR _1466_ sky130_fd_sc_hd__nor4_1
XFILLER_0_63_11 VGND VGND VPWR VPWR sky130_fd_sc_hd__fill_2
XFILLER_0_59_310 VGND VGND VPWR VPWR sky130_fd_sc_hd__decap_3
X_4030_ _0529_ _1916_ VGND VGND VPWR VPWR _1120_ sky130_fd_sc_hd__nand2_1
XPHY_EDGE_ROW_10_Right_10 VGND VGND VPWR VPWR sky130_fd_sc_hd__decap_3
XANTENNA_36 _0925_ VGND VGND VPWR VPWR sky130_fd_sc_hd__diode_2
XANTENNA_25 _1485_ VGND VGND VPWR VPWR sky130_fd_sc_hd__diode_2
X_3814_ net127 _1470_ VGND VGND VPWR VPWR _0889_ sky130_fd_sc_hd__nand2_1
XANTENNA_14 _0693_ VGND VGND VPWR VPWR sky130_fd_sc_hd__diode_2
XFILLER_0_63_3 VGND VGND VPWR VPWR sky130_fd_sc_hd__decap_8
X_3676_ _0106_ _0739_ _0741_ VGND VGND VPWR VPWR _0742_ sky130_fd_sc_hd__o21ai_4
X_2627_ _1732_ _1656_ _1654_ VGND VGND VPWR VPWR _1733_ sky130_fd_sc_hd__and3_1
X_3745_ _1592_ _1989_ _0814_ VGND VGND VPWR VPWR _0816_ sky130_fd_sc_hd__a21o_1
XTAP_TAPCELL_ROW_30_385 VGND VPWR sky130_fd_sc_hd__tapvpwrvgnd_1
XFILLER_0_6_189 VGND VGND VPWR VPWR sky130_fd_sc_hd__fill_2
X_2489_ _1348_ _1593_ _1594_ VGND VGND VPWR VPWR _1595_ sky130_fd_sc_hd__a21o_1
X_2558_ _1549_ VGND VGND VPWR VPWR _1664_ sky130_fd_sc_hd__buf_2
XFILLER_0_10_184 VPWR VGND VPWR VGND sky130_ef_sc_hd__decap_12
XTAP_TAPCELL_ROW_73_709 VGND VPWR sky130_fd_sc_hd__tapvpwrvgnd_1
X_4159_ _1452_ _1477_ _1483_ VGND VGND VPWR VPWR _1258_ sky130_fd_sc_hd__or3_1
XTAP_TAPCELL_ROW_38_441 VGND VPWR sky130_fd_sc_hd__tapvpwrvgnd_1
XFILLER_0_33_232 VPWR VGND VPWR VGND sky130_ef_sc_hd__decap_12
XFILLER_0_68_195 VGND VGND VPWR VPWR sky130_fd_sc_hd__fill_1
XFILLER_0_56_357 VGND VGND VPWR VPWR sky130_fd_sc_hd__decap_6
XTAP_TAPCELL_ROW_44_488 VGND VPWR sky130_fd_sc_hd__tapvpwrvgnd_1
Xinput56 B[30] VGND VGND VPWR VPWR net56 sky130_fd_sc_hd__clkbuf_1
Xinput45 B[20] VGND VGND VPWR VPWR net45 sky130_fd_sc_hd__buf_1
Xinput67 opcode[2] VGND VGND VPWR VPWR net67 sky130_fd_sc_hd__clkbuf_4
X_3530_ _1417_ _1429_ _1353_ _1948_ _1378_ VGND VGND VPWR VPWR _0584_ sky130_fd_sc_hd__o221a_1
Xinput34 B[10] VGND VGND VPWR VPWR net34 sky130_fd_sc_hd__buf_2
Xinput12 A[1] VGND VGND VPWR VPWR net12 sky130_fd_sc_hd__buf_1
Xinput23 A[2] VGND VGND VPWR VPWR net23 sky130_fd_sc_hd__buf_1
XFILLER_0_12_416 VGND VGND VPWR VPWR sky130_fd_sc_hd__decap_4
X_3461_ _0066_ _1693_ _0383_ _1426_ VGND VGND VPWR VPWR _0510_ sky130_fd_sc_hd__o31a_1
X_2343_ net16 VGND VGND VPWR VPWR _1449_ sky130_fd_sc_hd__buf_2
X_4013_ _1317_ _1064_ _0642_ VGND VGND VPWR VPWR _1102_ sky130_fd_sc_hd__o21ba_1
X_3392_ _0433_ _0434_ VGND VGND VPWR VPWR _0435_ sky130_fd_sc_hd__or2_1
X_2274_ _1264_ _1284_ _1379_ VGND VGND VPWR VPWR _1380_ sky130_fd_sc_hd__o21ai_1
X_2412_ _1516_ _1517_ VGND VGND VPWR VPWR _1518_ sky130_fd_sc_hd__nor2_2
XFILLER_0_59_162 VGND VGND VPWR VPWR sky130_fd_sc_hd__decap_6
XTAP_TAPCELL_ROW_35_422 VGND VPWR sky130_fd_sc_hd__tapvpwrvgnd_1
XFILLER_0_47_335 VGND VGND VPWR VPWR sky130_fd_sc_hd__fill_1
X_3728_ _0780_ _0786_ _0797_ VGND VGND VPWR VPWR _0798_ sky130_fd_sc_hd__nand3_1
X_3659_ _1828_ _0718_ _0720_ _0723_ VGND VGND VPWR VPWR _0724_ sky130_fd_sc_hd__a31oi_1
XFILLER_0_38_335 VGND VGND VPWR VPWR sky130_fd_sc_hd__fill_1
XFILLER_0_61_371 VGND VGND VPWR VPWR sky130_fd_sc_hd__fill_1
XTAP_TAPCELL_ROW_41_469 VGND VPWR sky130_fd_sc_hd__tapvpwrvgnd_1
XTAP_TAPCELL_ROW_49_525 VGND VPWR sky130_fd_sc_hd__tapvpwrvgnd_1
XFILLER_0_29_313 VPWR VGND VPWR VGND sky130_ef_sc_hd__decap_12
XFILLER_0_71_113 VPWR VGND VPWR VGND sky130_ef_sc_hd__decap_12
X_2961_ _1682_ _0901_ _0002_ _0003_ _0006_ VGND VGND VPWR VPWR _0007_ sky130_fd_sc_hd__o2111a_1
XFILLER_0_56_110 VGND VGND VPWR VPWR sky130_fd_sc_hd__decap_3
XFILLER_0_44_349 VGND VGND VPWR VPWR sky130_fd_sc_hd__fill_1
XFILLER_0_37_390 VGND VGND VPWR VPWR sky130_fd_sc_hd__fill_2
X_2892_ _1453_ net32 _1468_ _1456_ _1585_ _1599_ VGND VGND VPWR VPWR _1996_ sky130_fd_sc_hd__mux4_2
XFILLER_0_52_360 VGND VGND VPWR VPWR sky130_fd_sc_hd__decap_4
X_3444_ _0065_ _2054_ _1709_ _0490_ VGND VGND VPWR VPWR _0491_ sky130_fd_sc_hd__a211o_1
X_3513_ _1646_ _0067_ _0413_ _0558_ _0565_ VGND VGND VPWR VPWR _0566_ sky130_fd_sc_hd__o311a_1
XFILLER_0_12_279 VGND VGND VPWR VPWR sky130_fd_sc_hd__decap_3
X_2326_ net66 VGND VGND VPWR VPWR _1432_ sky130_fd_sc_hd__clkbuf_4
XFILLER_0_26_3 VPWR VGND VPWR VGND sky130_ef_sc_hd__decap_12
X_3375_ _1983_ _1308_ _1303_ _1304_ VGND VGND VPWR VPWR _0418_ sky130_fd_sc_hd__o2bb2a_1
X_2257_ _1291_ _1292_ VGND VGND VPWR VPWR _1363_ sky130_fd_sc_hd__nand2_1
X_2188_ _1264_ _1284_ _1287_ _1293_ VGND VGND VPWR VPWR _1294_ sky130_fd_sc_hd__o211a_1
XFILLER_0_62_135 VGND VGND VPWR VPWR sky130_fd_sc_hd__decap_4
XFILLER_0_47_187 VPWR VGND VPWR VGND sky130_ef_sc_hd__decap_12
XFILLER_0_7_251 VGND VGND VPWR VPWR sky130_fd_sc_hd__fill_2
XTAP_TAPCELL_ROW_46_506 VGND VPWR sky130_fd_sc_hd__tapvpwrvgnd_1
XTAP_TAPCELL_ROW_3_183 VGND VPWR sky130_fd_sc_hd__tapvpwrvgnd_1
XTAP_TAPCELL_ROW_54_561 VGND VPWR sky130_fd_sc_hd__tapvpwrvgnd_1
XFILLER_0_38_132 VGND VGND VPWR VPWR sky130_fd_sc_hd__decap_8
XFILLER_0_38_110 VGND VGND VPWR VPWR sky130_fd_sc_hd__fill_1
XFILLER_0_30_37 VGND VGND VPWR VPWR sky130_fd_sc_hd__fill_2
XFILLER_0_30_15 VPWR VGND VPWR VGND sky130_ef_sc_hd__decap_12
XFILLER_0_39_57 VGND VGND VPWR VPWR sky130_fd_sc_hd__decap_8
XFILLER_0_1_405 VPWR VGND VPWR VGND sky130_ef_sc_hd__decap_12
Xhold1 net99 VGND VGND VPWR VPWR net125 sky130_fd_sc_hd__dlygate4sd3_1
X_3160_ _1614_ _0195_ _0199_ _0202_ VGND VGND VPWR VPWR _0203_ sky130_fd_sc_hd__o211a_1
X_2111_ net41 net9 VGND VGND VPWR VPWR _0568_ sky130_fd_sc_hd__nor2_1
X_3091_ _1840_ _0134_ VGND VGND VPWR VPWR _0135_ sky130_fd_sc_hd__nand2_1
XFILLER_0_69_290 VPWR VGND VPWR VGND sky130_ef_sc_hd__decap_12
X_3993_ net42 _0642_ VGND VGND VPWR VPWR _1080_ sky130_fd_sc_hd__or2_1
XPHY_EDGE_ROW_8_Right_8 VGND VGND VPWR VPWR sky130_fd_sc_hd__decap_3
XTAP_TAPCELL_ROW_17_285 VGND VPWR sky130_fd_sc_hd__tapvpwrvgnd_1
XFILLER_0_72_433 VGND VGND VPWR VPWR sky130_fd_sc_hd__decap_4
X_2944_ _2041_ _2045_ _2046_ VGND VGND VPWR VPWR _2047_ sky130_fd_sc_hd__o21ai_1
X_2875_ _1978_ _1626_ _1624_ _1620_ _1970_ _1588_ VGND VGND VPWR VPWR _1979_ sky130_fd_sc_hd__mux4_2
XFILLER_0_44_168 VGND VGND VPWR VPWR sky130_fd_sc_hd__decap_6
XFILLER_0_44_135 VGND VGND VPWR VPWR sky130_fd_sc_hd__decap_4
XFILLER_0_40_330 VGND VGND VPWR VPWR sky130_fd_sc_hd__fill_1
XFILLER_0_4_265 VGND VGND VPWR VPWR sky130_fd_sc_hd__decap_4
XFILLER_0_4_243 VGND VGND VPWR VPWR sky130_fd_sc_hd__decap_6
X_3358_ _1917_ _1918_ _0394_ _0396_ _1840_ _1842_ VGND VGND VPWR VPWR _0399_ sky130_fd_sc_hd__mux4_2
XPHY_EDGE_ROW_39_Right_39 VGND VGND VPWR VPWR sky130_fd_sc_hd__decap_3
X_3427_ _0383_ _1928_ _1923_ _0324_ VGND VGND VPWR VPWR _0474_ sky130_fd_sc_hd__a22oi_1
X_3289_ _0066_ _1651_ _0064_ _0314_ _0326_ VGND VGND VPWR VPWR _0327_ sky130_fd_sc_hd__a221oi_2
XTAP_TAPCELL_ROW_0_153 VGND VPWR sky130_fd_sc_hd__tapvpwrvgnd_1
X_2309_ _1406_ _1407_ _1408_ _1414_ VGND VGND VPWR VPWR _1415_ sky130_fd_sc_hd__o211ai_2
XFILLER_0_63_433 VGND VGND VPWR VPWR sky130_fd_sc_hd__decap_4
XTAP_TAPCELL_ROW_51_542 VGND VPWR sky130_fd_sc_hd__tapvpwrvgnd_1
XPHY_EDGE_ROW_48_Right_48 VGND VGND VPWR VPWR sky130_fd_sc_hd__decap_3
XFILLER_0_0_91 VGND VGND VPWR VPWR sky130_fd_sc_hd__decap_8
XPHY_EDGE_ROW_57_Right_57 VGND VGND VPWR VPWR sky130_fd_sc_hd__decap_3
XFILLER_0_50_149 VGND VGND VPWR VPWR sky130_fd_sc_hd__fill_2
XFILLER_0_31_385 VGND VGND VPWR VPWR sky130_fd_sc_hd__decap_3
XTAP_TAPCELL_ROW_8_220 VGND VPWR sky130_fd_sc_hd__tapvpwrvgnd_1
XFILLER_0_16_360 VGND VGND VPWR VPWR sky130_fd_sc_hd__decap_4
XPHY_EDGE_ROW_66_Right_66 VGND VGND VPWR VPWR sky130_fd_sc_hd__decap_3
XFILLER_0_58_205 VGND VGND VPWR VPWR sky130_fd_sc_hd__fill_1
XFILLER_0_41_149 VGND VGND VPWR VPWR sky130_fd_sc_hd__fill_1
XFILLER_0_26_179 VGND VGND VPWR VPWR sky130_fd_sc_hd__decap_8
XFILLER_0_26_124 VPWR VGND VPWR VGND sky130_ef_sc_hd__decap_12
X_2660_ net64 net32 _1397_ _1456_ VGND VGND VPWR VPWR _1766_ sky130_fd_sc_hd__a22oi_1
XTAP_TAPCELL_ROW_14_266 VGND VPWR sky130_fd_sc_hd__tapvpwrvgnd_1
X_2591_ _1632_ VGND VGND VPWR VPWR _1697_ sky130_fd_sc_hd__clkbuf_4
X_3212_ _1862_ _1853_ _1856_ _1858_ _1967_ _1719_ VGND VGND VPWR VPWR _0254_ sky130_fd_sc_hd__mux4_2
XFILLER_0_5_69 VGND VGND VPWR VPWR sky130_fd_sc_hd__fill_1
XTAP_TAPCELL_ROW_65_645 VGND VPWR sky130_fd_sc_hd__tapvpwrvgnd_1
X_3074_ net53 _1939_ _1940_ _1941_ VGND VGND VPWR VPWR _0119_ sky130_fd_sc_hd__o211a_1
X_3143_ _2032_ _2033_ _0087_ VGND VGND VPWR VPWR _0186_ sky130_fd_sc_hd__a21o_1
XFILLER_0_49_205 VGND VGND VPWR VPWR sky130_fd_sc_hd__fill_2
X_4192_ clknet_2_0__leaf_clk _2088_ net120 VGND VGND VPWR VPWR net105 sky130_fd_sc_hd__dfrtp_1
XFILLER_0_72_230 VGND VGND VPWR VPWR sky130_fd_sc_hd__decap_4
X_2927_ _1946_ _1939_ VGND VGND VPWR VPWR _2031_ sky130_fd_sc_hd__nor2_1
X_3976_ _1009_ _1477_ VGND VGND VPWR VPWR _1063_ sky130_fd_sc_hd__or2_1
XFILLER_0_17_113 VGND VGND VPWR VPWR sky130_fd_sc_hd__fill_2
XFILLER_0_60_414 VGND VGND VPWR VPWR sky130_fd_sc_hd__decap_6
XFILLER_0_32_127 VPWR VGND VPWR VGND sky130_ef_sc_hd__decap_12
XFILLER_0_25_190 VGND VGND VPWR VPWR sky130_fd_sc_hd__fill_1
X_2789_ _1585_ VGND VGND VPWR VPWR _1894_ sky130_fd_sc_hd__buf_4
X_2858_ _1617_ _1627_ _1582_ _1961_ VGND VGND VPWR VPWR _1962_ sky130_fd_sc_hd__a211o_1
XFILLER_0_40_193 VGND VGND VPWR VPWR sky130_fd_sc_hd__decap_3
XTAP_TAPCELL_ROW_28_369 VGND VPWR sky130_fd_sc_hd__tapvpwrvgnd_1
XFILLER_0_51_436 VGND VGND VPWR VPWR sky130_fd_sc_hd__fill_1
XFILLER_0_48_271 VGND VGND VPWR VPWR sky130_fd_sc_hd__fill_2
XFILLER_0_16_190 VGND VGND VPWR VPWR sky130_fd_sc_hd__decap_6
XFILLER_0_36_47 VPWR VGND VPWR VGND sky130_ef_sc_hd__decap_12
XTAP_TAPCELL_ROW_19_303 VGND VPWR sky130_fd_sc_hd__tapvpwrvgnd_1
XTAP_TAPCELL_ROW_70_681 VGND VPWR sky130_fd_sc_hd__tapvpwrvgnd_1
XTAP_TAPCELL_ROW_62_626 VGND VPWR sky130_fd_sc_hd__tapvpwrvgnd_1
XFILLER_0_52_79 VGND VGND VPWR VPWR sky130_fd_sc_hd__decap_4
X_3830_ _0888_ _0906_ VGND VGND VPWR VPWR _0907_ sky130_fd_sc_hd__nand2_1
X_3761_ _1469_ _1444_ _1439_ VGND VGND VPWR VPWR _0833_ sky130_fd_sc_hd__o21ai_1
X_2574_ _1677_ _1679_ net49 VGND VGND VPWR VPWR _1680_ sky130_fd_sc_hd__o21ai_1
XFILLER_0_54_241 VGND VGND VPWR VPWR sky130_fd_sc_hd__decap_8
X_3692_ _0107_ _0403_ _1590_ VGND VGND VPWR VPWR _0759_ sky130_fd_sc_hd__or3_1
X_2712_ _1815_ _1243_ _1816_ VGND VGND VPWR VPWR _1817_ sky130_fd_sc_hd__a21oi_4
X_2643_ _1295_ _1297_ VGND VGND VPWR VPWR _1749_ sky130_fd_sc_hd__nor2_1
XFILLER_0_6_327 VGND VGND VPWR VPWR sky130_fd_sc_hd__fill_1
X_4175_ _1685_ _1273_ _1274_ VGND VGND VPWR VPWR _1276_ sky130_fd_sc_hd__and3_1
XFILLER_0_10_399 VGND VGND VPWR VPWR sky130_fd_sc_hd__decap_4
X_3126_ _1831_ _0146_ _0158_ _0169_ VGND VGND VPWR VPWR _0170_ sky130_fd_sc_hd__o211a_1
X_3057_ _1877_ _1398_ _1568_ VGND VGND VPWR VPWR _0102_ sky130_fd_sc_hd__o21ai_1
X_3959_ _0611_ _1025_ _0600_ VGND VGND VPWR VPWR _1044_ sky130_fd_sc_hd__o21ai_1
XFILLER_0_9_110 VGND VGND VPWR VPWR sky130_fd_sc_hd__fill_2
XFILLER_0_18_433 VGND VGND VPWR VPWR sky130_fd_sc_hd__decap_4
XFILLER_0_5_382 VGND VGND VPWR VPWR sky130_fd_sc_hd__fill_1
XFILLER_0_13_160 VGND VGND VPWR VPWR sky130_fd_sc_hd__decap_8
XFILLER_0_68_377 VPWR VGND VPWR VGND sky130_ef_sc_hd__decap_12
XFILLER_0_68_333 VGND VGND VPWR VPWR sky130_fd_sc_hd__fill_1
XFILLER_0_51_233 VGND VGND VPWR VPWR sky130_fd_sc_hd__fill_1
XFILLER_0_47_57 VGND VGND VPWR VPWR sky130_fd_sc_hd__decap_4
X_2290_ _1395_ net32 VGND VGND VPWR VPWR _1396_ sky130_fd_sc_hd__nand2_1
XFILLER_0_2_15 VPWR VGND VPWR VGND sky130_ef_sc_hd__decap_12
XANTENNA_26 _1491_ VGND VGND VPWR VPWR sky130_fd_sc_hd__diode_2
XANTENNA_37 _1060_ VGND VGND VPWR VPWR sky130_fd_sc_hd__diode_2
X_3813_ _1555_ _0877_ _0881_ _0243_ _0887_ VGND VGND VPWR VPWR _0888_ sky130_fd_sc_hd__a221oi_2
X_3744_ _0434_ _1960_ _0106_ VGND VGND VPWR VPWR _0814_ sky130_fd_sc_hd__a21o_1
XANTENNA_15 _0831_ VGND VGND VPWR VPWR sky130_fd_sc_hd__diode_2
XFILLER_0_12_71 VPWR VGND VPWR VGND sky130_ef_sc_hd__decap_12
X_2557_ _1601_ _1595_ _1603_ _1598_ _1658_ _1662_ VGND VGND VPWR VPWR _1663_ sky130_fd_sc_hd__mux4_2
XFILLER_0_56_3 VPWR VGND VPWR VGND sky130_ef_sc_hd__decap_12
X_3675_ _1591_ _1605_ _1557_ VGND VGND VPWR VPWR _0741_ sky130_fd_sc_hd__o21ai_1
X_2626_ _1572_ _1330_ _1625_ VGND VGND VPWR VPWR _1732_ sky130_fd_sc_hd__o21a_1
XFILLER_0_42_266 VGND VGND VPWR VPWR sky130_fd_sc_hd__decap_3
Xoutput100 net100 VGND VGND VPWR VPWR result[3] sky130_fd_sc_hd__buf_2
XTAP_TAPCELL_ROW_30_386 VGND VPWR sky130_fd_sc_hd__tapvpwrvgnd_1
X_2488_ _1563_ net19 VGND VGND VPWR VPWR _1594_ sky130_fd_sc_hd__nor2_1
X_4158_ _1450_ _1938_ _1256_ VGND VGND VPWR VPWR _1257_ sky130_fd_sc_hd__o21ai_1
XFILLER_0_10_174 VGND VGND VPWR VPWR sky130_fd_sc_hd__fill_2
X_3109_ _1969_ _1541_ _1435_ _1922_ net54 VGND VGND VPWR VPWR _0153_ sky130_fd_sc_hd__a32o_1
X_4089_ _1779_ _0094_ _0256_ _0384_ _0151_ VGND VGND VPWR VPWR _1183_ sky130_fd_sc_hd__a221o_1
XTAP_TAPCELL_ROW_38_442 VGND VPWR sky130_fd_sc_hd__tapvpwrvgnd_1
XFILLER_0_73_391 VGND VGND VPWR VPWR sky130_fd_sc_hd__fill_1
XFILLER_0_73_380 VGND VGND VPWR VPWR sky130_fd_sc_hd__fill_1
XFILLER_0_33_244 VGND VGND VPWR VPWR sky130_fd_sc_hd__fill_1
XFILLER_0_33_211 VGND VGND VPWR VPWR sky130_fd_sc_hd__decap_6
Xinput13 A[20] VGND VGND VPWR VPWR net13 sky130_fd_sc_hd__clkbuf_2
XFILLER_0_68_141 VGND VGND VPWR VPWR sky130_fd_sc_hd__decap_8
XFILLER_0_56_303 VGND VGND VPWR VPWR sky130_fd_sc_hd__decap_4
XTAP_TAPCELL_ROW_44_489 VGND VPWR sky130_fd_sc_hd__tapvpwrvgnd_1
Xinput57 B[31] VGND VGND VPWR VPWR net57 sky130_fd_sc_hd__clkbuf_4
Xinput24 A[30] VGND VGND VPWR VPWR net24 sky130_fd_sc_hd__buf_2
XFILLER_0_64_391 VPWR VGND VPWR VGND sky130_ef_sc_hd__decap_12
Xinput46 B[21] VGND VGND VPWR VPWR net46 sky130_fd_sc_hd__buf_1
Xinput68 opcode[3] VGND VGND VPWR VPWR net68 sky130_fd_sc_hd__buf_2
XFILLER_0_24_266 VGND VGND VPWR VPWR sky130_fd_sc_hd__decap_8
X_3460_ _0106_ _1986_ _2055_ _0403_ VGND VGND VPWR VPWR _0509_ sky130_fd_sc_hd__or4_1
X_3391_ _1718_ _0315_ _0317_ _0319_ _1604_ _0022_ VGND VGND VPWR VPWR _0434_ sky130_fd_sc_hd__mux4_1
Xinput35 B[11] VGND VGND VPWR VPWR net35 sky130_fd_sc_hd__buf_2
X_2411_ net64 net32 VGND VGND VPWR VPWR _1517_ sky130_fd_sc_hd__and2_1
X_2342_ net49 _1444_ _1447_ VGND VGND VPWR VPWR _1448_ sky130_fd_sc_hd__o21ai_1
X_4012_ _1785_ _1009_ _1477_ _0642_ _1489_ VGND VGND VPWR VPWR _1101_ sky130_fd_sc_hd__o311a_1
X_2273_ net59 net27 VGND VGND VPWR VPWR _1379_ sky130_fd_sc_hd__and2b_1
XTAP_TAPCELL_ROW_35_423 VGND VPWR sky130_fd_sc_hd__tapvpwrvgnd_1
XFILLER_0_70_361 VGND VGND VPWR VPWR sky130_fd_sc_hd__decap_3
XFILLER_0_55_391 VGND VGND VPWR VPWR sky130_fd_sc_hd__fill_1
X_3727_ _0787_ _0788_ _0792_ _0796_ VGND VGND VPWR VPWR _0797_ sky130_fd_sc_hd__o211a_1
XFILLER_0_15_200 VPWR VGND VPWR VGND sky130_ef_sc_hd__decap_12
X_2609_ _1593_ _1479_ _1714_ VGND VGND VPWR VPWR _1715_ sky130_fd_sc_hd__o21ai_2
X_3589_ _1954_ _0205_ _0242_ _0641_ _0647_ VGND VGND VPWR VPWR _0648_ sky130_fd_sc_hd__o311a_1
X_3658_ _1543_ _1821_ _0721_ _1363_ _0722_ VGND VGND VPWR VPWR _0723_ sky130_fd_sc_hd__o221a_1
Xclkbuf_2_2__f_clk clknet_0_clk VGND VGND VPWR VPWR clknet_2_2__leaf_clk sky130_fd_sc_hd__clkbuf_16
XFILLER_0_3_91 VGND VGND VPWR VPWR sky130_fd_sc_hd__decap_3
XFILLER_0_65_177 VGND VGND VPWR VPWR sky130_fd_sc_hd__fill_2
XFILLER_0_21_225 VGND VGND VPWR VPWR sky130_fd_sc_hd__decap_6
XTAP_TAPCELL_ROW_49_526 VGND VPWR sky130_fd_sc_hd__tapvpwrvgnd_1
XFILLER_0_28_48 VGND VGND VPWR VPWR sky130_fd_sc_hd__decap_8
X_2960_ _2048_ _2017_ _0911_ _1671_ _0005_ VGND VGND VPWR VPWR _0006_ sky130_fd_sc_hd__o221a_1
XFILLER_0_44_47 VGND VGND VPWR VPWR sky130_fd_sc_hd__decap_8
XFILLER_0_29_325 VGND VGND VPWR VPWR sky130_fd_sc_hd__decap_8
XFILLER_0_29_303 VGND VGND VPWR VPWR sky130_fd_sc_hd__fill_2
XFILLER_0_71_169 VGND VGND VPWR VPWR sky130_fd_sc_hd__decap_8
XFILLER_0_71_125 VPWR VGND VPWR VGND sky130_ef_sc_hd__decap_12
XFILLER_0_56_177 VGND VGND VPWR VPWR sky130_fd_sc_hd__fill_2
XFILLER_0_44_306 VGND VGND VPWR VPWR sky130_fd_sc_hd__fill_2
X_2891_ _1459_ _1253_ _1289_ _1461_ _1585_ _1562_ VGND VGND VPWR VPWR _1995_ sky130_fd_sc_hd__mux4_2
XFILLER_0_8_36 VGND VGND VPWR VPWR sky130_fd_sc_hd__decap_6
X_3443_ _0251_ _0267_ _1985_ _1643_ _0489_ VGND VGND VPWR VPWR _0490_ sky130_fd_sc_hd__o311a_1
X_3512_ _1955_ _1960_ _0559_ _0562_ _0564_ VGND VGND VPWR VPWR _0565_ sky130_fd_sc_hd__o311a_1
X_3374_ _1983_ _1308_ _0404_ VGND VGND VPWR VPWR _0416_ sky130_fd_sc_hd__and3_1
XFILLER_0_12_236 VGND VGND VPWR VPWR sky130_fd_sc_hd__decap_8
X_2325_ _1430_ VGND VGND VPWR VPWR _1431_ sky130_fd_sc_hd__clkbuf_4
X_2256_ _1325_ _1345_ _1361_ VGND VGND VPWR VPWR _1362_ sky130_fd_sc_hd__o21ai_2
X_2187_ _1288_ _1290_ _1291_ _1292_ VGND VGND VPWR VPWR _1293_ sky130_fd_sc_hd__a2bb2oi_2
XFILLER_0_19_3 VGND VGND VPWR VPWR sky130_fd_sc_hd__decap_6
XFILLER_0_47_166 VGND VGND VPWR VPWR sky130_fd_sc_hd__fill_2
XFILLER_0_47_144 VGND VGND VPWR VPWR sky130_fd_sc_hd__decap_6
XFILLER_0_47_111 VGND VGND VPWR VPWR sky130_fd_sc_hd__fill_1
XFILLER_0_50_309 VGND VGND VPWR VPWR sky130_fd_sc_hd__fill_1
XFILLER_0_43_361 VGND VGND VPWR VPWR sky130_fd_sc_hd__decap_6
XTAP_TAPCELL_ROW_54_562 VGND VPWR sky130_fd_sc_hd__tapvpwrvgnd_1
XTAP_TAPCELL_ROW_46_507 VGND VPWR sky130_fd_sc_hd__tapvpwrvgnd_1
XFILLER_0_38_122 VGND VGND VPWR VPWR sky130_fd_sc_hd__fill_2
XTAP_TAPCELL_ROW_3_184 VGND VPWR sky130_fd_sc_hd__tapvpwrvgnd_1
XFILLER_0_34_361 VGND VGND VPWR VPWR sky130_fd_sc_hd__decap_3
XFILLER_0_30_27 VGND VGND VPWR VPWR sky130_fd_sc_hd__fill_1
XFILLER_0_1_417 VPWR VGND VPWR VGND sky130_ef_sc_hd__decap_12
X_2110_ _0535_ _0546_ VGND VGND VPWR VPWR _0557_ sky130_fd_sc_hd__nand2_1
X_3090_ _1459_ _1463_ _1253_ _1461_ _1593_ _1580_ VGND VGND VPWR VPWR _0134_ sky130_fd_sc_hd__mux4_1
X_2943_ _1543_ _1821_ _2041_ _2045_ VGND VGND VPWR VPWR _2046_ sky130_fd_sc_hd__a2bb2oi_1
X_3992_ _0462_ _0064_ _1608_ _1077_ _1078_ VGND VGND VPWR VPWR _1079_ sky130_fd_sc_hd__a2111o_1
XFILLER_0_29_111 VGND VGND VPWR VPWR sky130_fd_sc_hd__fill_1
XTAP_TAPCELL_ROW_17_286 VGND VPWR sky130_fd_sc_hd__tapvpwrvgnd_1
X_2874_ _1570_ _1481_ _1717_ VGND VGND VPWR VPWR _1978_ sky130_fd_sc_hd__o21ai_1
XFILLER_0_44_147 VGND VGND VPWR VPWR sky130_fd_sc_hd__decap_4
XFILLER_0_40_320 VGND VGND VPWR VPWR sky130_fd_sc_hd__fill_1
XFILLER_0_32_309 VGND VGND VPWR VPWR sky130_fd_sc_hd__fill_1
XFILLER_0_25_361 VGND VGND VPWR VPWR sky130_fd_sc_hd__decap_6
X_3357_ _1556_ _1613_ net119 VGND VGND VPWR VPWR _0398_ sky130_fd_sc_hd__and3_2
XFILLER_0_40_397 VPWR VGND VPWR VGND sky130_ef_sc_hd__decap_12
X_2308_ _1403_ _1404_ _1040_ _1413_ VGND VGND VPWR VPWR _1414_ sky130_fd_sc_hd__o211ai_1
X_3426_ _1317_ _1460_ _1464_ VGND VGND VPWR VPWR _0473_ sky130_fd_sc_hd__o21a_1
XTAP_TAPCELL_ROW_68_665 VGND VPWR sky130_fd_sc_hd__tapvpwrvgnd_1
X_2239_ _0492_ _1334_ _1344_ VGND VGND VPWR VPWR _1345_ sky130_fd_sc_hd__a21oi_1
X_3288_ _1646_ _0323_ _0083_ _0325_ VGND VGND VPWR VPWR _0326_ sky130_fd_sc_hd__a211oi_1
XTAP_TAPCELL_ROW_0_154 VGND VPWR sky130_fd_sc_hd__tapvpwrvgnd_1
XTAP_TAPCELL_ROW_51_543 VGND VPWR sky130_fd_sc_hd__tapvpwrvgnd_1
XFILLER_0_16_350 VGND VGND VPWR VPWR sky130_fd_sc_hd__fill_1
XFILLER_0_8_3 VPWR VGND VPWR VGND sky130_ef_sc_hd__decap_12
XTAP_TAPCELL_ROW_8_221 VGND VPWR sky130_fd_sc_hd__tapvpwrvgnd_1
XFILLER_0_73_209 VGND VGND VPWR VPWR sky130_fd_sc_hd__decap_4
XFILLER_0_66_250 VGND VGND VPWR VPWR sky130_fd_sc_hd__fill_2
XFILLER_0_58_228 VGND VGND VPWR VPWR sky130_fd_sc_hd__decap_6
XFILLER_0_26_136 VGND VGND VPWR VPWR sky130_fd_sc_hd__decap_4
XFILLER_0_22_331 VPWR VGND VPWR VGND sky130_ef_sc_hd__decap_12
XFILLER_0_1_225 VGND VGND VPWR VPWR sky130_fd_sc_hd__fill_2
X_2590_ _1253_ VGND VGND VPWR VPWR _1696_ sky130_fd_sc_hd__clkbuf_4
XFILLER_0_14_309 VPWR VGND VPWR VGND sky130_ef_sc_hd__decap_12
XTAP_TAPCELL_ROW_14_267 VGND VPWR sky130_fd_sc_hd__tapvpwrvgnd_1
X_3142_ _0173_ _0177_ _0185_ VGND VGND VPWR VPWR _2079_ sky130_fd_sc_hd__nand3_1
X_3211_ _1634_ _0042_ _0252_ _1986_ VGND VGND VPWR VPWR _0253_ sky130_fd_sc_hd__o22a_1
X_4191_ clknet_2_0__leaf_clk _2087_ net120 VGND VGND VPWR VPWR net104 sky130_fd_sc_hd__dfrtp_1
XFILLER_0_5_15 VPWR VGND VPWR VGND sky130_ef_sc_hd__decap_12
X_3073_ _1545_ _0056_ _0057_ _0063_ _0117_ VGND VGND VPWR VPWR _0118_ sky130_fd_sc_hd__a311oi_2
XTAP_TAPCELL_ROW_65_646 VGND VPWR sky130_fd_sc_hd__tapvpwrvgnd_1
XFILLER_0_72_253 VGND VGND VPWR VPWR sky130_fd_sc_hd__decap_6
XFILLER_0_57_272 VGND VGND VPWR VPWR sky130_fd_sc_hd__decap_8
X_3975_ _1823_ _1042_ _1043_ _1046_ _1060_ VGND VGND VPWR VPWR _1062_ sky130_fd_sc_hd__o311a_1
X_2926_ _1490_ _1437_ _1433_ VGND VGND VPWR VPWR _2030_ sky130_fd_sc_hd__or3b_2
XPHY_EDGE_ROW_28_Left_102 VGND VGND VPWR VPWR sky130_fd_sc_hd__decap_3
XFILLER_0_9_369 VGND VGND VPWR VPWR sky130_fd_sc_hd__decap_8
XFILLER_0_15_93 VGND VGND VPWR VPWR sky130_fd_sc_hd__fill_1
X_2857_ _1576_ _1398_ _1568_ _1586_ VGND VGND VPWR VPWR _1961_ sky130_fd_sc_hd__o211a_1
XFILLER_0_32_139 VGND VGND VPWR VPWR sky130_fd_sc_hd__fill_1
X_2788_ _1659_ _1892_ _1658_ _1843_ VGND VGND VPWR VPWR _1893_ sky130_fd_sc_hd__or4_1
X_3409_ _1700_ _1658_ _1598_ _1644_ _2006_ VGND VGND VPWR VPWR _0454_ sky130_fd_sc_hd__o311a_1
XPHY_EDGE_ROW_37_Left_111 VGND VGND VPWR VPWR sky130_fd_sc_hd__decap_3
XFILLER_0_55_209 VPWR VGND VPWR VGND sky130_ef_sc_hd__decap_12
XPHY_EDGE_ROW_46_Left_120 VGND VGND VPWR VPWR sky130_fd_sc_hd__decap_3
XFILLER_0_63_297 VPWR VGND VPWR VGND sky130_ef_sc_hd__decap_12
XFILLER_0_51_415 VGND VGND VPWR VPWR sky130_fd_sc_hd__fill_1
XFILLER_0_48_283 VGND VGND VPWR VPWR sky130_fd_sc_hd__fill_2
XFILLER_0_23_128 VGND VGND VPWR VPWR sky130_fd_sc_hd__decap_4
XFILLER_0_36_59 VGND VGND VPWR VPWR sky130_fd_sc_hd__decap_8
XTAP_TAPCELL_ROW_19_304 VGND VPWR sky130_fd_sc_hd__tapvpwrvgnd_1
XTAP_TAPCELL_ROW_70_682 VGND VPWR sky130_fd_sc_hd__tapvpwrvgnd_1
XTAP_TAPCELL_ROW_62_627 VGND VPWR sky130_fd_sc_hd__tapvpwrvgnd_1
XFILLER_0_54_253 VGND VGND VPWR VPWR sky130_fd_sc_hd__fill_2
X_2711_ net113 _1405_ _1534_ VGND VGND VPWR VPWR _1816_ sky130_fd_sc_hd__a21o_1
X_3760_ _0805_ _0809_ _0831_ VGND VGND VPWR VPWR _0832_ sky130_fd_sc_hd__nor3_1
XFILLER_0_54_286 VGND VGND VPWR VPWR sky130_fd_sc_hd__fill_2
X_2573_ _1678_ VGND VGND VPWR VPWR _1679_ sky130_fd_sc_hd__buf_2
XFILLER_0_22_150 VGND VGND VPWR VPWR sky130_fd_sc_hd__decap_8
X_3691_ _1492_ _0746_ _0747_ _0750_ _0757_ VGND VGND VPWR VPWR _0758_ sky130_fd_sc_hd__o311a_1
X_2642_ _1745_ _1114_ _1518_ _1747_ VGND VGND VPWR VPWR _1748_ sky130_fd_sc_hd__nand4b_2
X_4174_ _1501_ _0094_ _1270_ _1929_ VGND VGND VPWR VPWR _1274_ sky130_fd_sc_hd__o2bb2a_1
X_3125_ _0168_ _1914_ VGND VGND VPWR VPWR _0169_ sky130_fd_sc_hd__nand2_1
XFILLER_0_37_209 VGND VGND VPWR VPWR sky130_fd_sc_hd__decap_3
X_3056_ _1562_ _1458_ _1564_ VGND VGND VPWR VPWR _0101_ sky130_fd_sc_hd__a21o_1
X_2909_ _1671_ _0965_ _2012_ _1925_ VGND VGND VPWR VPWR _2013_ sky130_fd_sc_hd__a2bb2o_1
XFILLER_0_60_212 VGND VGND VPWR VPWR sky130_fd_sc_hd__fill_1
XFILLER_0_45_253 VGND VGND VPWR VPWR sky130_fd_sc_hd__fill_2
XFILLER_0_42_91 VGND VGND VPWR VPWR sky130_fd_sc_hd__fill_1
X_3958_ _0632_ _1817_ _1498_ _0600_ VGND VGND VPWR VPWR _1043_ sky130_fd_sc_hd__o211a_1
X_3889_ _0939_ _1431_ _0969_ VGND VGND VPWR VPWR _0970_ sky130_fd_sc_hd__o21ai_1
XFILLER_0_5_361 VGND VGND VPWR VPWR sky130_fd_sc_hd__decap_8
XFILLER_0_6_91 VGND VGND VPWR VPWR sky130_fd_sc_hd__fill_1
XFILLER_0_68_389 VPWR VGND VPWR VGND sky130_ef_sc_hd__decap_12
XTAP_TAPCELL_ROW_24_340 VGND VPWR sky130_fd_sc_hd__tapvpwrvgnd_1
XFILLER_0_51_267 VPWR VGND VPWR VGND sky130_ef_sc_hd__decap_12
XFILLER_0_51_223 VGND VGND VPWR VPWR sky130_fd_sc_hd__fill_1
XFILLER_0_11_109 VGND VGND VPWR VPWR sky130_fd_sc_hd__decap_3
XFILLER_0_47_69 VGND VGND VPWR VPWR sky130_fd_sc_hd__fill_2
XFILLER_0_63_57 VGND VGND VPWR VPWR sky130_fd_sc_hd__decap_8
XFILLER_0_2_27 VGND VGND VPWR VPWR sky130_fd_sc_hd__fill_1
X_3674_ _0340_ _0738_ _0329_ _0328_ _1588_ _1560_ VGND VGND VPWR VPWR _0739_ sky130_fd_sc_hd__mux4_1
XANTENNA_27 _1508_ VGND VGND VPWR VPWR sky130_fd_sc_hd__diode_2
X_3743_ _0311_ _0811_ _1865_ _1966_ _0812_ VGND VGND VPWR VPWR _0813_ sky130_fd_sc_hd__o221ai_2
XTAP_TAPCELL_ROW_30_387 VGND VPWR sky130_fd_sc_hd__tapvpwrvgnd_1
X_3812_ _0883_ _0884_ _0886_ VGND VGND VPWR VPWR _0887_ sky130_fd_sc_hd__or3_1
XFILLER_0_27_242 VPWR VGND VPWR VGND sky130_ef_sc_hd__decap_12
XFILLER_0_12_83 VGND VGND VPWR VPWR sky130_fd_sc_hd__fill_1
XANTENNA_38 _1561_ VGND VGND VPWR VPWR sky130_fd_sc_hd__diode_2
XANTENNA_16 _0870_ VGND VGND VPWR VPWR sky130_fd_sc_hd__diode_2
X_2487_ _1571_ VGND VGND VPWR VPWR _1593_ sky130_fd_sc_hd__buf_4
X_2625_ _1661_ VGND VGND VPWR VPWR _1731_ sky130_fd_sc_hd__clkbuf_4
Xoutput101 net101 VGND VGND VPWR VPWR result[4] sky130_fd_sc_hd__buf_2
X_2556_ _1661_ VGND VGND VPWR VPWR _1662_ sky130_fd_sc_hd__buf_4
X_4157_ _0449_ _1939_ _1940_ _1941_ VGND VGND VPWR VPWR _1256_ sky130_fd_sc_hd__o211a_1
X_3108_ _0001_ _0772_ _1969_ _1674_ VGND VGND VPWR VPWR _0152_ sky130_fd_sc_hd__o22ai_1
X_4088_ _1338_ _1478_ _1925_ VGND VGND VPWR VPWR _1182_ sky130_fd_sc_hd__and3_1
XFILLER_0_49_3 VGND VGND VPWR VPWR sky130_fd_sc_hd__decap_8
XTAP_TAPCELL_ROW_38_443 VGND VPWR sky130_fd_sc_hd__tapvpwrvgnd_1
XFILLER_0_10_197 VGND VGND VPWR VPWR sky130_fd_sc_hd__decap_8
XFILLER_0_65_359 VGND VGND VPWR VPWR sky130_fd_sc_hd__fill_1
XFILLER_0_65_315 VPWR VGND VPWR VGND sky130_ef_sc_hd__decap_12
X_3039_ _0064_ _0072_ _0082_ _0083_ VGND VGND VPWR VPWR _0084_ sky130_fd_sc_hd__o2bb2a_1
XFILLER_0_18_253 VGND VGND VPWR VPWR sky130_fd_sc_hd__decap_4
XTAP_TAPCELL_ROW_72_700 VGND VPWR sky130_fd_sc_hd__tapvpwrvgnd_1
Xinput14 A[21] VGND VGND VPWR VPWR net14 sky130_fd_sc_hd__clkbuf_4
Xinput25 A[31] VGND VGND VPWR VPWR net25 sky130_fd_sc_hd__buf_1
Xinput36 B[12] VGND VGND VPWR VPWR net36 sky130_fd_sc_hd__clkbuf_4
Xinput47 B[22] VGND VGND VPWR VPWR net47 sky130_fd_sc_hd__clkbuf_1
Xinput69 opcode[4] VGND VGND VPWR VPWR net69 sky130_fd_sc_hd__buf_2
XFILLER_0_58_24 VGND VGND VPWR VPWR sky130_fd_sc_hd__decap_4
X_2341_ _1446_ VGND VGND VPWR VPWR _1447_ sky130_fd_sc_hd__clkbuf_4
X_3390_ _2053_ VGND VGND VPWR VPWR _0433_ sky130_fd_sc_hd__clkbuf_4
Xinput58 B[3] VGND VGND VPWR VPWR net58 sky130_fd_sc_hd__clkbuf_4
X_2410_ net64 net32 VGND VGND VPWR VPWR _1516_ sky130_fd_sc_hd__nor2_1
X_4011_ _0642_ _1938_ _1099_ VGND VGND VPWR VPWR _1100_ sky130_fd_sc_hd__o21ai_1
X_2272_ _1253_ VGND VGND VPWR VPWR _1378_ sky130_fd_sc_hd__inv_2
XFILLER_0_47_337 VPWR VGND VPWR VGND sky130_ef_sc_hd__decap_12
XFILLER_0_47_315 VPWR VGND VPWR VGND sky130_ef_sc_hd__decap_12
XTAP_TAPCELL_ROW_35_424 VGND VPWR sky130_fd_sc_hd__tapvpwrvgnd_1
XFILLER_0_23_71 VGND VGND VPWR VPWR sky130_fd_sc_hd__fill_1
XFILLER_0_70_340 VGND VGND VPWR VPWR sky130_fd_sc_hd__fill_1
XFILLER_0_30_215 VGND VGND VPWR VPWR sky130_fd_sc_hd__decap_4
X_3726_ _0793_ _0795_ _0311_ VGND VGND VPWR VPWR _0796_ sky130_fd_sc_hd__a21o_1
X_3657_ _1363_ _0721_ VGND VGND VPWR VPWR _0722_ sky130_fd_sc_hd__nand2_1
XFILLER_0_15_212 VPWR VGND VPWR VGND sky130_ef_sc_hd__decap_12
XFILLER_0_15_278 VGND VGND VPWR VPWR sky130_fd_sc_hd__fill_2
X_2608_ net14 _1575_ VGND VGND VPWR VPWR _1714_ sky130_fd_sc_hd__or2b_1
X_2539_ _1644_ VGND VGND VPWR VPWR _1645_ sky130_fd_sc_hd__clkbuf_4
X_3588_ _0065_ _0206_ _0083_ _0646_ VGND VGND VPWR VPWR _0647_ sky130_fd_sc_hd__a211o_1
X_4209_ clknet_2_3__leaf_clk _2075_ net122 VGND VGND VPWR VPWR net92 sky130_fd_sc_hd__dfrtp_1
XFILLER_0_3_81 VGND VGND VPWR VPWR sky130_fd_sc_hd__fill_2
XFILLER_0_65_189 VGND VGND VPWR VPWR sky130_fd_sc_hd__decap_6
XFILLER_0_38_359 VGND VGND VPWR VPWR sky130_fd_sc_hd__fill_1
XFILLER_0_38_315 VGND VGND VPWR VPWR sky130_fd_sc_hd__fill_1
XTAP_TAPCELL_ROW_49_527 VGND VPWR sky130_fd_sc_hd__tapvpwrvgnd_1
XFILLER_0_44_26 VGND VGND VPWR VPWR sky130_fd_sc_hd__fill_2
XFILLER_0_28_27 VGND VGND VPWR VPWR sky130_fd_sc_hd__fill_1
X_2890_ _1731_ _1991_ _1993_ _1644_ VGND VGND VPWR VPWR _1994_ sky130_fd_sc_hd__o211a_1
XFILLER_0_29_337 VPWR VGND VPWR VGND sky130_ef_sc_hd__decap_12
XFILLER_0_71_137 VGND VGND VPWR VPWR sky130_fd_sc_hd__fill_1
XFILLER_0_56_189 VGND VGND VPWR VPWR sky130_fd_sc_hd__fill_1
XTAP_TAPCELL_ROW_40_460 VGND VPWR sky130_fd_sc_hd__tapvpwrvgnd_1
XFILLER_0_37_381 VGND VGND VPWR VPWR sky130_fd_sc_hd__fill_1
XFILLER_0_8_15 VPWR VGND VPWR VGND sky130_ef_sc_hd__decap_12
X_3511_ _0337_ _1674_ _1676_ _1285_ _0563_ VGND VGND VPWR VPWR _0564_ sky130_fd_sc_hd__o221a_1
XFILLER_0_69_67 VGND VGND VPWR VPWR sky130_fd_sc_hd__decap_3
X_2324_ _1428_ _1419_ _1417_ _1429_ VGND VGND VPWR VPWR _1430_ sky130_fd_sc_hd__o2bb2ai_4
X_3442_ _0374_ _0377_ _1906_ _0375_ _1880_ _1731_ VGND VGND VPWR VPWR _0489_ sky130_fd_sc_hd__mux4_2
XFILLER_0_20_281 VGND VGND VPWR VPWR sky130_fd_sc_hd__fill_1
XFILLER_0_20_270 VGND VGND VPWR VPWR sky130_fd_sc_hd__decap_3
X_3373_ _1693_ _1928_ VGND VGND VPWR VPWR _0415_ sky130_fd_sc_hd__nand2_1
X_2255_ _0815_ _1352_ _1360_ VGND VGND VPWR VPWR _1361_ sky130_fd_sc_hd__o21a_1
X_2186_ net62 net30 VGND VGND VPWR VPWR _1292_ sky130_fd_sc_hd__or2_1
XFILLER_0_18_60 VGND VGND VPWR VPWR sky130_fd_sc_hd__decap_4
XFILLER_0_18_82 VGND VGND VPWR VPWR sky130_fd_sc_hd__fill_2
XFILLER_0_47_178 VGND VGND VPWR VPWR sky130_fd_sc_hd__fill_2
XFILLER_0_34_81 VGND VGND VPWR VPWR sky130_fd_sc_hd__decap_3
XFILLER_0_70_192 VGND VGND VPWR VPWR sky130_fd_sc_hd__decap_4
XFILLER_0_7_297 VGND VGND VPWR VPWR sky130_fd_sc_hd__decap_6
XFILLER_0_7_286 VGND VGND VPWR VPWR sky130_fd_sc_hd__fill_2
X_3709_ _1517_ _1926_ _1922_ net64 _0776_ VGND VGND VPWR VPWR _0777_ sky130_fd_sc_hd__a221o_1
XFILLER_0_66_421 VPWR VGND VPWR VGND sky130_ef_sc_hd__decap_12
XTAP_TAPCELL_ROW_54_563 VGND VPWR sky130_fd_sc_hd__tapvpwrvgnd_1
XFILLER_0_38_145 VGND VGND VPWR VPWR sky130_fd_sc_hd__fill_1
XFILLER_0_14_29 VGND VGND VPWR VPWR sky130_fd_sc_hd__decap_3
XFILLER_0_53_148 VGND VGND VPWR VPWR sky130_fd_sc_hd__fill_1
XFILLER_0_26_307 VGND VGND VPWR VPWR sky130_fd_sc_hd__fill_1
XFILLER_0_39_15 VPWR VGND VPWR VGND sky130_ef_sc_hd__decap_12
XFILLER_0_1_429 VGND VGND VPWR VPWR sky130_fd_sc_hd__decap_8
X_2942_ _1951_ _0965_ _0943_ VGND VGND VPWR VPWR _2045_ sky130_fd_sc_hd__a21oi_1
XFILLER_0_71_57 VPWR VGND VPWR VGND sky130_ef_sc_hd__decap_12
X_2873_ _1868_ _1974_ _1976_ _1615_ VGND VGND VPWR VPWR _1977_ sky130_fd_sc_hd__a211o_1
X_3991_ _0865_ _1997_ VGND VGND VPWR VPWR _1078_ sky130_fd_sc_hd__nor2_1
XFILLER_0_29_167 VGND VGND VPWR VPWR sky130_fd_sc_hd__fill_1
XTAP_TAPCELL_ROW_17_287 VGND VPWR sky130_fd_sc_hd__tapvpwrvgnd_1
XFILLER_0_52_170 VGND VGND VPWR VPWR sky130_fd_sc_hd__fill_1
XFILLER_0_20_61 VGND VGND VPWR VPWR sky130_fd_sc_hd__fill_1
X_3356_ _0148_ _1918_ _0394_ _0396_ _1955_ _1960_ VGND VGND VPWR VPWR _0397_ sky130_fd_sc_hd__mux4_2
X_2238_ _0481_ _1340_ _1343_ VGND VGND VPWR VPWR _1344_ sky130_fd_sc_hd__a21o_1
XFILLER_0_31_3 VGND VGND VPWR VPWR sky130_fd_sc_hd__decap_6
X_3287_ _0251_ _0267_ _0324_ _0032_ _1584_ VGND VGND VPWR VPWR _0325_ sky130_fd_sc_hd__o311a_1
X_2307_ _1409_ _1410_ _1412_ VGND VGND VPWR VPWR _1413_ sky130_fd_sc_hd__o21ai_1
XPHY_EDGE_ROW_13_Left_87 VGND VGND VPWR VPWR sky130_fd_sc_hd__decap_3
X_3425_ _0470_ _0383_ _1485_ VGND VGND VPWR VPWR _0472_ sky130_fd_sc_hd__and3_1
XTAP_TAPCELL_ROW_68_666 VGND VPWR sky130_fd_sc_hd__tapvpwrvgnd_1
XFILLER_0_48_421 VPWR VGND VPWR VGND sky130_ef_sc_hd__decap_12
XFILLER_0_48_410 VGND VGND VPWR VPWR sky130_fd_sc_hd__decap_8
XFILLER_0_45_80 VGND VGND VPWR VPWR sky130_fd_sc_hd__fill_1
XTAP_TAPCELL_ROW_0_155 VGND VPWR sky130_fd_sc_hd__tapvpwrvgnd_1
X_2169_ net35 net3 VGND VGND VPWR VPWR _1189_ sky130_fd_sc_hd__nor2_2
XTAP_TAPCELL_ROW_51_544 VGND VPWR sky130_fd_sc_hd__tapvpwrvgnd_1
XTAP_TAPCELL_ROW_8_222 VGND VPWR sky130_fd_sc_hd__tapvpwrvgnd_1
XTAP_TAPCELL_ROW_59_600 VGND VPWR sky130_fd_sc_hd__tapvpwrvgnd_1
XFILLER_0_25_39 VGND VGND VPWR VPWR sky130_fd_sc_hd__fill_1
XFILLER_0_58_218 VGND VGND VPWR VPWR sky130_fd_sc_hd__fill_2
XFILLER_0_39_432 VGND VGND VPWR VPWR sky130_fd_sc_hd__fill_1
XFILLER_0_26_115 VGND VGND VPWR VPWR sky130_fd_sc_hd__fill_1
XFILLER_0_22_343 VGND VGND VPWR VPWR sky130_fd_sc_hd__decap_8
X_3141_ _0179_ _0180_ _0181_ _0183_ _0184_ VGND VGND VPWR VPWR _0185_ sky130_fd_sc_hd__a32oi_2
XFILLER_0_66_46 VGND VGND VPWR VPWR sky130_fd_sc_hd__decap_4
X_3210_ _1485_ _1969_ _0087_ _1968_ _1874_ _0251_ VGND VGND VPWR VPWR _0252_ sky130_fd_sc_hd__mux4_1
X_4190_ clknet_2_0__leaf_clk _2086_ net120 VGND VGND VPWR VPWR net103 sky130_fd_sc_hd__dfrtp_1
XFILLER_0_5_27 VGND VGND VPWR VPWR sky130_fd_sc_hd__decap_6
XTAP_TAPCELL_ROW_65_647 VGND VPWR sky130_fd_sc_hd__tapvpwrvgnd_1
X_3072_ _1692_ _0084_ _0100_ _0116_ VGND VGND VPWR VPWR _0117_ sky130_fd_sc_hd__o211ai_2
XFILLER_0_72_298 VGND VGND VPWR VPWR sky130_fd_sc_hd__decap_8
XFILLER_0_72_221 VGND VGND VPWR VPWR sky130_fd_sc_hd__fill_2
X_2925_ _2024_ _2025_ _2026_ _2028_ VGND VGND VPWR VPWR _2029_ sky130_fd_sc_hd__a211o_1
X_2856_ _1842_ VGND VGND VPWR VPWR _1960_ sky130_fd_sc_hd__clkbuf_4
XFILLER_0_45_402 VPWR VGND VPWR VGND sky130_ef_sc_hd__decap_12
X_3974_ _1692_ _1047_ _1054_ _1059_ VGND VGND VPWR VPWR _1060_ sky130_fd_sc_hd__o211a_1
XFILLER_0_31_93 VGND VGND VPWR VPWR sky130_fd_sc_hd__fill_2
XFILLER_0_9_326 VGND VGND VPWR VPWR sky130_fd_sc_hd__decap_3
X_3408_ _1713_ _1715_ _1711_ _1601_ _1724_ _1731_ VGND VGND VPWR VPWR _0453_ sky130_fd_sc_hd__mux4_2
XFILLER_0_40_173 VGND VGND VPWR VPWR sky130_fd_sc_hd__fill_1
XFILLER_0_0_281 VGND VGND VPWR VPWR sky130_fd_sc_hd__fill_2
XFILLER_0_0_270 VGND VGND VPWR VPWR sky130_fd_sc_hd__decap_6
XFILLER_0_13_332 VGND VGND VPWR VPWR sky130_fd_sc_hd__decap_4
X_2787_ _1660_ VGND VGND VPWR VPWR _1892_ sky130_fd_sc_hd__buf_4
X_3339_ _1983_ _1455_ _1654_ _1656_ _1846_ VGND VGND VPWR VPWR _0378_ sky130_fd_sc_hd__o2111ai_2
XFILLER_0_48_251 VGND VGND VPWR VPWR sky130_fd_sc_hd__fill_1
XFILLER_0_63_243 VPWR VGND VPWR VGND sky130_ef_sc_hd__decap_12
XTAP_TAPCELL_ROW_11_238 VGND VPWR sky130_fd_sc_hd__tapvpwrvgnd_1
XTAP_TAPCELL_ROW_27_360 VGND VPWR sky130_fd_sc_hd__tapvpwrvgnd_1
XTAP_TAPCELL_ROW_70_683 VGND VPWR sky130_fd_sc_hd__tapvpwrvgnd_1
XFILLER_0_27_435 VGND VGND VPWR VPWR sky130_fd_sc_hd__fill_2
X_2710_ _1367_ _1377_ _1387_ VGND VGND VPWR VPWR _1815_ sky130_fd_sc_hd__o21ai_4
X_3690_ _1398_ _0752_ _0753_ _0756_ VGND VGND VPWR VPWR _0757_ sky130_fd_sc_hd__a211oi_1
X_2572_ net67 net68 _1552_ _1434_ VGND VGND VPWR VPWR _1678_ sky130_fd_sc_hd__and4b_1
XFILLER_0_22_184 VPWR VGND VPWR VGND sky130_ef_sc_hd__decap_12
X_2641_ _1746_ _1157_ _1168_ VGND VGND VPWR VPWR _1747_ sky130_fd_sc_hd__and3_1
X_4173_ _1450_ _2017_ _1269_ _1271_ _1272_ VGND VGND VPWR VPWR _1273_ sky130_fd_sc_hd__o2111a_1
X_3055_ _0090_ _0097_ _0099_ VGND VGND VPWR VPWR _0100_ sky130_fd_sc_hd__and3_1
X_3124_ _1707_ _0164_ _0167_ _0083_ VGND VGND VPWR VPWR _0168_ sky130_fd_sc_hd__o22ai_1
X_3957_ _0600_ _1041_ VGND VGND VPWR VPWR _1042_ sky130_fd_sc_hd__nor2_1
XFILLER_0_26_93 VGND VGND VPWR VPWR sky130_fd_sc_hd__fill_1
XFILLER_0_26_82 VGND VGND VPWR VPWR sky130_fd_sc_hd__fill_2
XFILLER_0_9_167 VGND VGND VPWR VPWR sky130_fd_sc_hd__fill_1
X_2908_ net51 _1945_ VGND VGND VPWR VPWR _2012_ sky130_fd_sc_hd__and2_1
X_2839_ _1812_ _1934_ _1936_ _1943_ VGND VGND VPWR VPWR _2075_ sky130_fd_sc_hd__nand4b_1
XFILLER_0_42_81 VGND VGND VPWR VPWR sky130_fd_sc_hd__decap_3
X_3888_ _1029_ _1937_ _1447_ VGND VGND VPWR VPWR _0969_ sky130_fd_sc_hd__o21a_1
Xwire1 _1133_ VGND VGND VPWR VPWR net126 sky130_fd_sc_hd__clkbuf_1
XFILLER_0_68_302 VGND VGND VPWR VPWR sky130_fd_sc_hd__decap_6
XPHY_EDGE_ROW_16_Left_90 VGND VGND VPWR VPWR sky130_fd_sc_hd__decap_3
XTAP_TAPCELL_ROW_24_341 VGND VPWR sky130_fd_sc_hd__tapvpwrvgnd_1
XFILLER_0_22_29 VGND VGND VPWR VPWR sky130_fd_sc_hd__fill_1
XFILLER_0_51_279 VGND VGND VPWR VPWR sky130_fd_sc_hd__fill_1
X_3811_ _0872_ _0885_ net36 _2014_ VGND VGND VPWR VPWR _0886_ sky130_fd_sc_hd__a2bb2o_1
XPHY_EDGE_ROW_65_Left_139 VGND VGND VPWR VPWR sky130_fd_sc_hd__decap_3
XANTENNA_39 _2022_ VGND VGND VPWR VPWR sky130_fd_sc_hd__diode_2
XANTENNA_28 _1561_ VGND VGND VPWR VPWR sky130_fd_sc_hd__diode_2
X_3742_ _0132_ _0211_ _1976_ VGND VGND VPWR VPWR _0812_ sky130_fd_sc_hd__or3_1
XFILLER_0_42_213 VGND VGND VPWR VPWR sky130_fd_sc_hd__decap_4
XFILLER_0_27_254 VPWR VGND VPWR VGND sky130_ef_sc_hd__decap_12
X_3673_ _1581_ _0315_ _0342_ VGND VGND VPWR VPWR _0738_ sky130_fd_sc_hd__o21ai_2
X_2624_ _1621_ _1475_ _1623_ VGND VGND VPWR VPWR _1730_ sky130_fd_sc_hd__o21a_1
XANTENNA_17 _0935_ VGND VGND VPWR VPWR sky130_fd_sc_hd__diode_2
X_2486_ _1591_ VGND VGND VPWR VPWR _1592_ sky130_fd_sc_hd__clkbuf_4
Xoutput102 net102 VGND VGND VPWR VPWR result[5] sky130_fd_sc_hd__buf_2
XFILLER_0_10_165 VGND VGND VPWR VPWR sky130_fd_sc_hd__decap_6
X_2555_ _1659_ _1660_ VGND VGND VPWR VPWR _1661_ sky130_fd_sc_hd__or2_1
X_4156_ _1799_ _1801_ _1214_ _1252_ _1254_ VGND VGND VPWR VPWR _1255_ sky130_fd_sc_hd__o221ai_2
X_4087_ _0395_ _2009_ net119 _1666_ _1177_ VGND VGND VPWR VPWR _1181_ sky130_fd_sc_hd__a32o_1
XTAP_TAPCELL_ROW_38_444 VGND VPWR sky130_fd_sc_hd__tapvpwrvgnd_1
X_3107_ _1426_ net59 _1867_ VGND VGND VPWR VPWR _0151_ sky130_fd_sc_hd__and3_4
X_3038_ _1709_ VGND VGND VPWR VPWR _0083_ sky130_fd_sc_hd__buf_2
XFILLER_0_65_327 VGND VGND VPWR VPWR sky130_fd_sc_hd__fill_1
XFILLER_0_5_181 VGND VGND VPWR VPWR sky130_fd_sc_hd__decap_8
XTAP_TAPCELL_ROW_72_701 VGND VPWR sky130_fd_sc_hd__tapvpwrvgnd_1
XFILLER_0_68_176 VPWR VGND VPWR VGND sky130_ef_sc_hd__decap_12
XFILLER_0_68_154 VPWR VGND VPWR VGND sky130_ef_sc_hd__decap_12
XPHY_EDGE_ROW_1_Left_75 VGND VGND VPWR VPWR sky130_fd_sc_hd__decap_3
Xinput48 B[23] VGND VGND VPWR VPWR net48 sky130_fd_sc_hd__clkbuf_1
Xinput15 A[22] VGND VGND VPWR VPWR net15 sky130_fd_sc_hd__buf_1
XFILLER_0_3_118 VGND VGND VPWR VPWR sky130_fd_sc_hd__decap_4
Xinput37 B[13] VGND VGND VPWR VPWR net37 sky130_fd_sc_hd__clkbuf_1
Xinput26 A[3] VGND VGND VPWR VPWR net26 sky130_fd_sc_hd__clkbuf_2
Xinput59 B[4] VGND VGND VPWR VPWR net59 sky130_fd_sc_hd__clkbuf_4
XFILLER_0_58_58 VGND VGND VPWR VPWR sky130_fd_sc_hd__decap_3
X_2340_ _1445_ VGND VGND VPWR VPWR _1446_ sky130_fd_sc_hd__clkbuf_4
X_2271_ _1300_ _1371_ _1376_ VGND VGND VPWR VPWR _1377_ sky130_fd_sc_hd__a21oi_2
X_4010_ net42 _1939_ _1940_ _1941_ VGND VGND VPWR VPWR _1099_ sky130_fd_sc_hd__o211a_1
XFILLER_0_59_198 VGND VGND VPWR VPWR sky130_fd_sc_hd__decap_8
XFILLER_0_59_154 VGND VGND VPWR VPWR sky130_fd_sc_hd__decap_3
XFILLER_0_47_349 VPWR VGND VPWR VGND sky130_ef_sc_hd__decap_12
XFILLER_0_47_327 VGND VGND VPWR VPWR sky130_fd_sc_hd__decap_8
XTAP_TAPCELL_ROW_43_480 VGND VPWR sky130_fd_sc_hd__tapvpwrvgnd_1
XFILLER_0_61_3 VGND VGND VPWR VPWR sky130_fd_sc_hd__decap_8
X_2607_ _1593_ _1481_ _1712_ VGND VGND VPWR VPWR _1713_ sky130_fd_sc_hd__o21ai_2
X_3725_ _1706_ _1883_ _0080_ _0208_ _1845_ VGND VGND VPWR VPWR _0795_ sky130_fd_sc_hd__o32a_1
XFILLER_0_30_249 VGND VGND VPWR VPWR sky130_fd_sc_hd__decap_3
X_3587_ _0068_ _0448_ _0645_ _1645_ VGND VGND VPWR VPWR _0646_ sky130_fd_sc_hd__o211a_1
X_3656_ _1759_ _0650_ _1382_ VGND VGND VPWR VPWR _0721_ sky130_fd_sc_hd__o21ai_1
XFILLER_0_15_257 VGND VGND VPWR VPWR sky130_fd_sc_hd__decap_4
XFILLER_0_15_268 VGND VGND VPWR VPWR sky130_fd_sc_hd__fill_2
X_4208_ clknet_2_3__leaf_clk _2074_ net122 VGND VGND VPWR VPWR net91 sky130_fd_sc_hd__dfrtp_1
X_2538_ _1567_ _1586_ _1642_ _1643_ VGND VGND VPWR VPWR _1644_ sky130_fd_sc_hd__o31a_4
X_2469_ _1305_ VGND VGND VPWR VPWR _1575_ sky130_fd_sc_hd__clkbuf_4
XFILLER_0_65_113 VGND VGND VPWR VPWR sky130_fd_sc_hd__fill_1
X_4139_ _2038_ _1213_ _1214_ _1236_ VGND VGND VPWR VPWR _1237_ sky130_fd_sc_hd__o31a_1
XFILLER_0_65_135 VPWR VGND VPWR VGND sky130_ef_sc_hd__decap_12
XFILLER_0_21_238 VPWR VGND VPWR VGND sky130_ef_sc_hd__decap_12
XFILLER_0_14_290 VGND VGND VPWR VPWR sky130_fd_sc_hd__fill_1
XTAP_TAPCELL_ROW_49_528 VGND VPWR sky130_fd_sc_hd__tapvpwrvgnd_1
XFILLER_0_71_105 VGND VGND VPWR VPWR sky130_fd_sc_hd__decap_6
XTAP_TAPCELL_ROW_57_583 VGND VPWR sky130_fd_sc_hd__tapvpwrvgnd_1
XFILLER_0_29_349 VPWR VGND VPWR VGND sky130_ef_sc_hd__decap_12
XFILLER_0_69_57 VGND VGND VPWR VPWR sky130_fd_sc_hd__decap_4
XFILLER_0_69_46 VGND VGND VPWR VPWR sky130_fd_sc_hd__decap_4
XFILLER_0_69_35 VGND VGND VPWR VPWR sky130_fd_sc_hd__fill_1
XTAP_TAPCELL_ROW_40_461 VGND VPWR sky130_fd_sc_hd__tapvpwrvgnd_1
X_3441_ _0080_ _0486_ _0487_ VGND VGND VPWR VPWR _0488_ sky130_fd_sc_hd__o21ai_1
XFILLER_0_37_393 VPWR VGND VPWR VGND sky130_ef_sc_hd__decap_12
XFILLER_0_8_27 VGND VGND VPWR VPWR sky130_fd_sc_hd__fill_1
X_3510_ _1682_ _1929_ _1286_ VGND VGND VPWR VPWR _0563_ sky130_fd_sc_hd__mux2_1
X_2254_ _1353_ _1356_ _1359_ _1319_ VGND VGND VPWR VPWR _1360_ sky130_fd_sc_hd__o22a_1
X_2323_ _1311_ VGND VGND VPWR VPWR _1429_ sky130_fd_sc_hd__buf_4
X_3372_ _1929_ _1682_ _1303_ VGND VGND VPWR VPWR _0414_ sky130_fd_sc_hd__mux2_1
XFILLER_0_47_113 VGND VGND VPWR VPWR sky130_fd_sc_hd__fill_1
X_2185_ net62 net30 VGND VGND VPWR VPWR _1291_ sky130_fd_sc_hd__nand2_2
XFILLER_0_35_308 VGND VGND VPWR VPWR sky130_fd_sc_hd__fill_2
XFILLER_0_34_93 VPWR VGND VPWR VGND sky130_ef_sc_hd__decap_12
XFILLER_0_28_371 VPWR VGND VPWR VGND sky130_ef_sc_hd__decap_12
XFILLER_0_28_360 VGND VGND VPWR VPWR sky130_fd_sc_hd__decap_4
X_3639_ _1561_ _0266_ VGND VGND VPWR VPWR _0702_ sky130_fd_sc_hd__nor2_1
XFILLER_0_11_260 VPWR VGND VPWR VGND sky130_ef_sc_hd__decap_12
X_3708_ _1517_ _1929_ _2017_ _0764_ _0775_ VGND VGND VPWR VPWR _0776_ sky130_fd_sc_hd__o221ai_1
XTAP_TAPCELL_ROW_54_564 VGND VPWR sky130_fd_sc_hd__tapvpwrvgnd_1
XFILLER_0_38_102 VGND VGND VPWR VPWR sky130_fd_sc_hd__decap_8
XFILLER_0_30_29 VGND VGND VPWR VPWR sky130_fd_sc_hd__decap_8
XFILLER_0_39_27 VGND VGND VPWR VPWR sky130_fd_sc_hd__decap_4
XFILLER_0_71_47 VGND VGND VPWR VPWR sky130_fd_sc_hd__fill_2
XFILLER_0_69_260 VGND VGND VPWR VPWR sky130_fd_sc_hd__decap_8
X_3990_ _0068_ _1991_ _1993_ _0689_ VGND VGND VPWR VPWR _1077_ sky130_fd_sc_hd__o211a_1
X_2941_ _1799_ _1801_ _2036_ _2042_ _2043_ VGND VGND VPWR VPWR _2044_ sky130_fd_sc_hd__o221ai_2
XFILLER_0_71_69 VPWR VGND VPWR VGND sky130_ef_sc_hd__decap_12
X_2872_ _1974_ _1975_ _1561_ VGND VGND VPWR VPWR _1976_ sky130_fd_sc_hd__a21o_1
XFILLER_0_44_116 VGND VGND VPWR VPWR sky130_fd_sc_hd__fill_1
XFILLER_0_29_113 VGND VGND VPWR VPWR sky130_fd_sc_hd__decap_6
XFILLER_0_4_213 VPWR VGND VPWR VGND sky130_ef_sc_hd__decap_12
XTAP_TAPCELL_ROW_17_288 VGND VPWR sky130_fd_sc_hd__tapvpwrvgnd_1
X_3424_ _1308_ _1302_ VGND VGND VPWR VPWR _0470_ sky130_fd_sc_hd__or2_1
XTAP_TAPCELL_ROW_68_667 VGND VPWR sky130_fd_sc_hd__tapvpwrvgnd_1
X_3355_ _1785_ _1481_ _1326_ _1479_ _1621_ _1697_ VGND VGND VPWR VPWR _0396_ sky130_fd_sc_hd__mux4_1
X_2237_ _1341_ _0471_ _0427_ _1342_ VGND VGND VPWR VPWR _1343_ sky130_fd_sc_hd__a31o_1
XFILLER_0_24_3 VPWR VGND VPWR VGND sky130_ef_sc_hd__decap_12
X_2306_ _1411_ _1050_ VGND VGND VPWR VPWR _1412_ sky130_fd_sc_hd__or2b_1
X_3286_ _1583_ VGND VGND VPWR VPWR _0324_ sky130_fd_sc_hd__buf_4
X_2099_ net15 _0427_ VGND VGND VPWR VPWR _0438_ sky130_fd_sc_hd__nor2_1
XFILLER_0_48_433 VGND VGND VPWR VPWR sky130_fd_sc_hd__decap_4
XTAP_TAPCELL_ROW_0_156 VGND VPWR sky130_fd_sc_hd__tapvpwrvgnd_1
X_2168_ _1157_ _1168_ VGND VGND VPWR VPWR _1178_ sky130_fd_sc_hd__nand2_1
XFILLER_0_35_138 VGND VGND VPWR VPWR sky130_fd_sc_hd__decap_6
XFILLER_0_35_127 VGND VGND VPWR VPWR sky130_fd_sc_hd__decap_4
XFILLER_0_31_333 VGND VGND VPWR VPWR sky130_fd_sc_hd__decap_3
XFILLER_0_31_300 VGND VGND VPWR VPWR sky130_fd_sc_hd__decap_8
XFILLER_0_9_92 VGND VGND VPWR VPWR sky130_fd_sc_hd__decap_3
XPHY_EDGE_ROW_17_Right_17 VGND VGND VPWR VPWR sky130_fd_sc_hd__decap_3
XTAP_TAPCELL_ROW_59_601 VGND VPWR sky130_fd_sc_hd__tapvpwrvgnd_1
XPHY_EDGE_ROW_26_Right_26 VGND VGND VPWR VPWR sky130_fd_sc_hd__decap_3
XPHY_EDGE_ROW_35_Right_35 VGND VGND VPWR VPWR sky130_fd_sc_hd__decap_3
XFILLER_0_41_108 VGND VGND VPWR VPWR sky130_fd_sc_hd__decap_4
X_3140_ _0061_ _0058_ _0762_ _0154_ VGND VGND VPWR VPWR _0184_ sky130_fd_sc_hd__a211o_1
X_3071_ _0108_ _0113_ _0115_ _1831_ VGND VGND VPWR VPWR _0116_ sky130_fd_sc_hd__a31o_1
XPHY_EDGE_ROW_44_Right_44 VGND VGND VPWR VPWR sky130_fd_sc_hd__decap_3
XTAP_TAPCELL_ROW_65_648 VGND VPWR sky130_fd_sc_hd__tapvpwrvgnd_1
XPHY_EDGE_ROW_53_Right_53 VGND VGND VPWR VPWR sky130_fd_sc_hd__decap_3
X_3973_ _1055_ _1057_ _1058_ _1831_ VGND VGND VPWR VPWR _1059_ sky130_fd_sc_hd__a31o_1
XFILLER_0_72_288 VGND VGND VPWR VPWR sky130_fd_sc_hd__fill_2
X_2924_ _2027_ _2024_ _1946_ VGND VGND VPWR VPWR _2028_ sky130_fd_sc_hd__a21oi_1
XFILLER_0_45_414 VPWR VGND VPWR VGND sky130_ef_sc_hd__decap_12
X_2786_ _1890_ _1587_ net59 _1642_ VGND VGND VPWR VPWR _1891_ sky130_fd_sc_hd__or4_4
XFILLER_0_17_138 VPWR VGND VPWR VGND sky130_ef_sc_hd__decap_12
X_2855_ _1955_ _1958_ VGND VGND VPWR VPWR _1959_ sky130_fd_sc_hd__nand2_1
XPHY_EDGE_ROW_62_Right_62 VGND VGND VPWR VPWR sky130_fd_sc_hd__decap_3
XFILLER_0_40_185 VGND VGND VPWR VPWR sky130_fd_sc_hd__decap_8
XFILLER_0_40_141 VPWR VGND VPWR VGND sky130_ef_sc_hd__decap_12
X_3407_ _0450_ _1643_ _0451_ VGND VGND VPWR VPWR _0452_ sky130_fd_sc_hd__a21o_1
X_3338_ _1570_ _1200_ _1848_ VGND VGND VPWR VPWR _0377_ sky130_fd_sc_hd__o21ai_4
XFILLER_0_13_399 VGND VGND VPWR VPWR sky130_fd_sc_hd__fill_1
X_3269_ _0066_ _1809_ VGND VGND VPWR VPWR _0307_ sky130_fd_sc_hd__or2b_1
XPHY_EDGE_ROW_71_Right_71 VGND VGND VPWR VPWR sky130_fd_sc_hd__decap_3
XFILLER_0_63_255 VPWR VGND VPWR VGND sky130_ef_sc_hd__decap_12
XFILLER_0_31_196 VPWR VGND VPWR VGND sky130_ef_sc_hd__decap_12
XTAP_TAPCELL_ROW_11_239 VGND VPWR sky130_fd_sc_hd__tapvpwrvgnd_1
XTAP_TAPCELL_ROW_27_361 VGND VPWR sky130_fd_sc_hd__tapvpwrvgnd_1
XTAP_TAPCELL_ROW_70_684 VGND VPWR sky130_fd_sc_hd__tapvpwrvgnd_1
XFILLER_0_39_296 VGND VGND VPWR VPWR sky130_fd_sc_hd__fill_1
XFILLER_0_39_285 VGND VGND VPWR VPWR sky130_fd_sc_hd__decap_6
X_2640_ _1189_ _1391_ VGND VGND VPWR VPWR _1746_ sky130_fd_sc_hd__nor2_1
X_2571_ _1540_ _1549_ _1538_ VGND VGND VPWR VPWR _1677_ sky130_fd_sc_hd__and3_1
XFILLER_0_22_130 VGND VGND VPWR VPWR sky130_fd_sc_hd__decap_8
XFILLER_0_10_303 VGND VGND VPWR VPWR sky130_fd_sc_hd__decap_4
X_3054_ net53 _2014_ _0098_ VGND VGND VPWR VPWR _0099_ sky130_fd_sc_hd__a21oi_1
X_4172_ _1449_ _0449_ _1676_ VGND VGND VPWR VPWR _1272_ sky130_fd_sc_hd__or3_1
X_3123_ _0165_ _0166_ _1704_ VGND VGND VPWR VPWR _0167_ sky130_fd_sc_hd__mux2_1
X_2907_ net51 _1946_ VGND VGND VPWR VPWR _2011_ sky130_fd_sc_hd__nand2_1
XFILLER_0_42_60 VGND VGND VPWR VPWR sky130_fd_sc_hd__fill_2
X_3956_ _0632_ _1817_ _1498_ VGND VGND VPWR VPWR _1041_ sky130_fd_sc_hd__o21a_1
XFILLER_0_9_113 VPWR VGND VPWR VGND sky130_ef_sc_hd__decap_12
X_2838_ _1806_ _1938_ _1942_ VGND VGND VPWR VPWR _1943_ sky130_fd_sc_hd__o21ai_1
X_2769_ _1697_ VGND VGND VPWR VPWR _1874_ sky130_fd_sc_hd__clkbuf_4
XFILLER_0_45_299 VGND VGND VPWR VPWR sky130_fd_sc_hd__decap_4
X_3887_ _0944_ _0947_ _0967_ VGND VGND VPWR VPWR _0968_ sky130_fd_sc_hd__nor3_1
XFILLER_0_5_374 VGND VGND VPWR VPWR sky130_fd_sc_hd__decap_8
Xwire2 _1466_ VGND VGND VPWR VPWR net127 sky130_fd_sc_hd__buf_1
XTAP_TAPCELL_ROW_24_342 VGND VPWR sky130_fd_sc_hd__tapvpwrvgnd_1
XFILLER_0_2_29 VPWR VGND VPWR VGND sky130_ef_sc_hd__decap_12
XFILLER_0_67_391 VGND VGND VPWR VPWR sky130_fd_sc_hd__fill_1
X_3741_ _1709_ _1910_ _0453_ _0810_ _2007_ VGND VGND VPWR VPWR _0811_ sky130_fd_sc_hd__o32a_1
XANTENNA_18 _0953_ VGND VGND VPWR VPWR sky130_fd_sc_hd__diode_2
XANTENNA_29 _1663_ VGND VGND VPWR VPWR sky130_fd_sc_hd__diode_2
X_3810_ net36 _0196_ _1674_ VGND VGND VPWR VPWR _0885_ sky130_fd_sc_hd__o21a_1
X_3672_ _1608_ _1611_ _1614_ VGND VGND VPWR VPWR _0737_ sky130_fd_sc_hd__and3_1
XFILLER_0_27_299 VGND VGND VPWR VPWR sky130_fd_sc_hd__fill_2
XFILLER_0_27_266 VPWR VGND VPWR VGND sky130_ef_sc_hd__decap_12
X_2623_ _1575_ _1301_ VGND VGND VPWR VPWR _1729_ sky130_fd_sc_hd__nand2_2
Xoutput103 net103 VGND VGND VPWR VPWR result[6] sky130_fd_sc_hd__buf_2
XFILLER_0_12_85 VPWR VGND VPWR VGND sky130_ef_sc_hd__decap_12
X_2554_ _1571_ _1301_ net55 VGND VGND VPWR VPWR _1660_ sky130_fd_sc_hd__nor3b_1
X_4155_ _0417_ _1214_ _1501_ VGND VGND VPWR VPWR _1254_ sky130_fd_sc_hd__o21ai_1
X_2485_ _1559_ VGND VGND VPWR VPWR _1591_ sky130_fd_sc_hd__clkbuf_4
XFILLER_0_10_155 VGND VGND VPWR VPWR sky130_fd_sc_hd__fill_1
X_3106_ _1649_ _0147_ _1917_ _0149_ _1867_ VGND VGND VPWR VPWR _0150_ sky130_fd_sc_hd__a32o_1
X_3037_ _0070_ _0073_ _0077_ _0081_ VGND VGND VPWR VPWR _0082_ sky130_fd_sc_hd__o2bb2ai_1
X_4086_ _1708_ _1891_ _1704_ _0591_ _2004_ VGND VGND VPWR VPWR _1180_ sky130_fd_sc_hd__a221o_1
XTAP_TAPCELL_ROW_38_445 VGND VPWR sky130_fd_sc_hd__tapvpwrvgnd_1
X_3939_ _1707_ _0243_ _0314_ _1019_ _1022_ VGND VGND VPWR VPWR _1023_ sky130_fd_sc_hd__a311oi_2
XTAP_TAPCELL_ROW_72_702 VGND VPWR sky130_fd_sc_hd__tapvpwrvgnd_1
XFILLER_0_68_166 VGND VGND VPWR VPWR sky130_fd_sc_hd__fill_2
Xinput49 B[24] VGND VGND VPWR VPWR net49 sky130_fd_sc_hd__clkbuf_4
Xinput16 A[23] VGND VGND VPWR VPWR net16 sky130_fd_sc_hd__clkbuf_4
XFILLER_0_64_361 VGND VGND VPWR VPWR sky130_fd_sc_hd__decap_3
XFILLER_0_24_203 VGND VGND VPWR VPWR sky130_fd_sc_hd__fill_1
Xinput27 A[4] VGND VGND VPWR VPWR net27 sky130_fd_sc_hd__dlymetal6s2s_1
Xinput38 B[14] VGND VGND VPWR VPWR net38 sky130_fd_sc_hd__buf_1
X_2270_ _1373_ _1375_ VGND VGND VPWR VPWR _1376_ sky130_fd_sc_hd__nand2_1
XFILLER_0_70_320 VGND VGND VPWR VPWR sky130_fd_sc_hd__decap_3
XTAP_TAPCELL_ROW_43_481 VGND VPWR sky130_fd_sc_hd__tapvpwrvgnd_1
X_3724_ _1709_ _1910_ _0369_ _0380_ _0731_ VGND VGND VPWR VPWR _0793_ sky130_fd_sc_hd__o32a_1
XFILLER_0_15_225 VPWR VGND VPWR VGND sky130_ef_sc_hd__decap_12
X_2606_ net11 _1571_ VGND VGND VPWR VPWR _1712_ sky130_fd_sc_hd__or2b_1
XFILLER_0_30_228 VGND VGND VPWR VPWR sky130_fd_sc_hd__decap_3
X_3586_ _1659_ _1892_ _0644_ VGND VGND VPWR VPWR _0645_ sky130_fd_sc_hd__o21ai_1
X_2537_ _1599_ _1580_ _1628_ _1374_ VGND VGND VPWR VPWR _1643_ sky130_fd_sc_hd__a31o_2
XFILLER_0_2_163 VGND VGND VPWR VPWR sky130_fd_sc_hd__fill_2
XFILLER_0_2_141 VGND VGND VPWR VPWR sky130_fd_sc_hd__fill_1
X_3655_ net61 _0633_ _1291_ _1292_ _0656_ VGND VGND VPWR VPWR _0720_ sky130_fd_sc_hd__a221o_1
X_4207_ clknet_2_3__leaf_clk _2073_ net122 VGND VGND VPWR VPWR net90 sky130_fd_sc_hd__dfrtp_1
X_4138_ _1216_ _1217_ _1235_ VGND VGND VPWR VPWR _1236_ sky130_fd_sc_hd__a21oi_1
X_2399_ _1341_ _0427_ _1342_ _0471_ VGND VGND VPWR VPWR _1505_ sky130_fd_sc_hd__o31a_1
XFILLER_0_54_3 VGND VGND VPWR VPWR sky130_fd_sc_hd__decap_4
X_2468_ _1570_ _1464_ _1573_ VGND VGND VPWR VPWR _1574_ sky130_fd_sc_hd__o21a_1
XFILLER_0_65_147 VGND VGND VPWR VPWR sky130_fd_sc_hd__fill_1
X_4069_ _1707_ _0243_ _0580_ _1161_ VGND VGND VPWR VPWR _1162_ sky130_fd_sc_hd__a31o_1
XFILLER_0_65_169 VGND VGND VPWR VPWR sky130_fd_sc_hd__decap_8
XFILLER_0_46_394 VGND VGND VPWR VPWR sky130_fd_sc_hd__fill_2
XFILLER_0_46_372 VPWR VGND VPWR VGND sky130_ef_sc_hd__decap_12
XFILLER_0_46_361 VGND VGND VPWR VPWR sky130_fd_sc_hd__decap_3
XFILLER_0_28_29 VGND VGND VPWR VPWR sky130_fd_sc_hd__decap_4
XTAP_TAPCELL_ROW_57_584 VGND VPWR sky130_fd_sc_hd__tapvpwrvgnd_1
XTAP_TAPCELL_ROW_49_529 VGND VPWR sky130_fd_sc_hd__tapvpwrvgnd_1
XFILLER_0_60_27 VGND VGND VPWR VPWR sky130_fd_sc_hd__fill_1
XFILLER_0_56_136 VGND VGND VPWR VPWR sky130_fd_sc_hd__decap_4
XFILLER_0_44_309 VPWR VGND VPWR VGND sky130_ef_sc_hd__decap_12
XTAP_TAPCELL_ROW_40_462 VGND VPWR sky130_fd_sc_hd__tapvpwrvgnd_1
X_3440_ _0009_ _0080_ VGND VGND VPWR VPWR _0487_ sky130_fd_sc_hd__nand2_1
X_3371_ _1647_ _1651_ _1913_ VGND VGND VPWR VPWR _0413_ sky130_fd_sc_hd__o21ai_4
XFILLER_0_12_228 VGND VGND VPWR VPWR sky130_fd_sc_hd__fill_2
X_2322_ _1355_ _1427_ VGND VGND VPWR VPWR _1428_ sky130_fd_sc_hd__nand2_2
X_2253_ net54 _1357_ _1358_ net53 VGND VGND VPWR VPWR _1359_ sky130_fd_sc_hd__a22oi_1
X_2184_ net61 _1289_ VGND VGND VPWR VPWR _1290_ sky130_fd_sc_hd__nor2_1
XFILLER_0_47_136 VGND VGND VPWR VPWR sky130_fd_sc_hd__fill_1
XFILLER_0_47_103 VGND VGND VPWR VPWR sky130_fd_sc_hd__decap_8
XFILLER_0_62_139 VGND VGND VPWR VPWR sky130_fd_sc_hd__fill_1
XFILLER_0_50_93 VGND VGND VPWR VPWR sky130_fd_sc_hd__decap_6
XFILLER_0_50_82 VGND VGND VPWR VPWR sky130_fd_sc_hd__fill_2
XFILLER_0_47_169 VGND VGND VPWR VPWR sky130_fd_sc_hd__decap_6
XFILLER_0_28_383 VGND VGND VPWR VPWR sky130_fd_sc_hd__decap_4
XFILLER_0_7_200 VGND VGND VPWR VPWR sky130_fd_sc_hd__fill_1
X_3707_ net64 _0764_ _0256_ VGND VGND VPWR VPWR _0775_ sky130_fd_sc_hd__o21ai_1
X_3569_ _1955_ _0031_ _0148_ _0626_ _0602_ VGND VGND VPWR VPWR _0627_ sky130_fd_sc_hd__a311o_1
XFILLER_0_43_397 VGND VGND VPWR VPWR sky130_fd_sc_hd__decap_3
X_3638_ _0633_ _1696_ _0610_ _1454_ _1485_ VGND VGND VPWR VPWR _0701_ sky130_fd_sc_hd__o311a_1
XFILLER_0_11_272 VGND VGND VPWR VPWR sky130_fd_sc_hd__decap_8
XTAP_TAPCELL_ROW_54_565 VGND VPWR sky130_fd_sc_hd__tapvpwrvgnd_1
XFILLER_0_34_353 VGND VGND VPWR VPWR sky130_fd_sc_hd__decap_8
XFILLER_0_55_27 VGND VGND VPWR VPWR sky130_fd_sc_hd__decap_4
X_2940_ _2012_ _2036_ _2041_ VGND VGND VPWR VPWR _2043_ sky130_fd_sc_hd__o21ai_1
XFILLER_0_71_15 VPWR VGND VPWR VGND sky130_ef_sc_hd__decap_12
X_2871_ _1316_ _1604_ _1840_ VGND VGND VPWR VPWR _1975_ sky130_fd_sc_hd__or3_1
XFILLER_0_44_139 VGND VGND VPWR VPWR sky130_fd_sc_hd__fill_1
XFILLER_0_29_169 VGND VGND VPWR VPWR sky130_fd_sc_hd__fill_2
XFILLER_0_4_225 VGND VGND VPWR VPWR sky130_fd_sc_hd__decap_3
XTAP_TAPCELL_ROW_17_289 VGND VPWR sky130_fd_sc_hd__tapvpwrvgnd_1
X_3354_ _1449_ net17 _1478_ _1451_ _1618_ _1627_ VGND VGND VPWR VPWR _0394_ sky130_fd_sc_hd__mux4_1
XFILLER_0_4_269 VGND VGND VPWR VPWR sky130_fd_sc_hd__fill_1
Xmax_cap113 _1526_ VGND VGND VPWR VPWR net113 sky130_fd_sc_hd__clkbuf_2
X_3423_ _1513_ _1672_ _0196_ _1511_ _0468_ VGND VGND VPWR VPWR _0469_ sky130_fd_sc_hd__o221a_1
XTAP_TAPCELL_ROW_68_668 VGND VPWR sky130_fd_sc_hd__tapvpwrvgnd_1
X_2236_ net16 _0449_ VGND VGND VPWR VPWR _1342_ sky130_fd_sc_hd__and2b_1
X_3285_ _0068_ _0316_ _0318_ _0322_ VGND VGND VPWR VPWR _0323_ sky130_fd_sc_hd__a31o_1
X_2305_ net5 VGND VGND VPWR VPWR _1411_ sky130_fd_sc_hd__buf_4
X_2167_ net34 net2 VGND VGND VPWR VPWR _1168_ sky130_fd_sc_hd__or2_1
XFILLER_0_17_3 VGND VGND VPWR VPWR sky130_fd_sc_hd__decap_8
XFILLER_0_67_209 VGND VGND VPWR VPWR sky130_fd_sc_hd__decap_6
X_2098_ net47 VGND VGND VPWR VPWR _0427_ sky130_fd_sc_hd__buf_2
XTAP_TAPCELL_ROW_0_157 VGND VPWR sky130_fd_sc_hd__tapvpwrvgnd_1
XFILLER_0_16_342 VGND VGND VPWR VPWR sky130_fd_sc_hd__decap_8
XTAP_TAPCELL_ROW_59_602 VGND VPWR sky130_fd_sc_hd__tapvpwrvgnd_1
XFILLER_0_39_401 VGND VGND VPWR VPWR sky130_fd_sc_hd__decap_8
XFILLER_0_66_242 VGND VGND VPWR VPWR sky130_fd_sc_hd__decap_8
XFILLER_0_54_426 VGND VGND VPWR VPWR sky130_fd_sc_hd__decap_4
XFILLER_0_66_15 VPWR VGND VPWR VGND sky130_ef_sc_hd__decap_12
XFILLER_0_1_206 VGND VGND VPWR VPWR sky130_fd_sc_hd__decap_8
XFILLER_0_66_37 VGND VGND VPWR VPWR sky130_fd_sc_hd__decap_3
X_3070_ _0068_ _1645_ _1652_ _0114_ VGND VGND VPWR VPWR _0115_ sky130_fd_sc_hd__or4b_1
X_2923_ _1424_ _1806_ _1484_ VGND VGND VPWR VPWR _2027_ sky130_fd_sc_hd__or3_1
XTAP_TAPCELL_ROW_65_649 VGND VPWR sky130_fd_sc_hd__tapvpwrvgnd_1
XFILLER_0_57_231 VGND VGND VPWR VPWR sky130_fd_sc_hd__fill_1
XFILLER_0_45_426 VGND VGND VPWR VPWR sky130_fd_sc_hd__decap_4
X_3972_ _0267_ _0037_ _1985_ _1843_ VGND VGND VPWR VPWR _1058_ sky130_fd_sc_hd__or4_1
XFILLER_0_72_234 VGND VGND VPWR VPWR sky130_fd_sc_hd__fill_1
X_2785_ _1567_ VGND VGND VPWR VPWR _1890_ sky130_fd_sc_hd__clkbuf_4
XFILLER_0_40_153 VPWR VGND VPWR VGND sky130_ef_sc_hd__decap_12
XFILLER_0_31_51 VGND VGND VPWR VPWR sky130_fd_sc_hd__decap_4
XFILLER_0_13_312 VGND VGND VPWR VPWR sky130_fd_sc_hd__fill_1
X_2854_ _1956_ _1957_ _1719_ VGND VGND VPWR VPWR _1958_ sky130_fd_sc_hd__mux2_1
XFILLER_0_40_197 VGND VGND VPWR VPWR sky130_fd_sc_hd__fill_1
X_3337_ _0374_ _0375_ _1658_ VGND VGND VPWR VPWR _0376_ sky130_fd_sc_hd__mux2_1
X_3406_ _1964_ _1910_ _1962_ _1709_ VGND VGND VPWR VPWR _0451_ sky130_fd_sc_hd__a31o_1
XFILLER_0_0_294 VPWR VGND VPWR VGND sky130_ef_sc_hd__decap_12
X_3199_ _0237_ _0239_ _0729_ _1823_ VGND VGND VPWR VPWR _0241_ sky130_fd_sc_hd__a31o_1
X_2219_ _1320_ _1324_ VGND VGND VPWR VPWR _1325_ sky130_fd_sc_hd__nand2_1
X_3268_ _0251_ _1439_ _0305_ VGND VGND VPWR VPWR _0306_ sky130_fd_sc_hd__a21oi_1
XFILLER_0_63_289 VGND VGND VPWR VPWR sky130_fd_sc_hd__fill_2
XFILLER_0_63_267 VPWR VGND VPWR VGND sky130_ef_sc_hd__decap_12
XFILLER_0_48_253 VGND VGND VPWR VPWR sky130_fd_sc_hd__fill_2
XFILLER_0_31_186 VGND VGND VPWR VPWR sky130_fd_sc_hd__decap_3
XFILLER_0_6_3 VPWR VGND VPWR VGND sky130_ef_sc_hd__decap_12
XTAP_TAPCELL_ROW_27_362 VGND VPWR sky130_fd_sc_hd__tapvpwrvgnd_1
XTAP_TAPCELL_ROW_70_685 VGND VPWR sky130_fd_sc_hd__tapvpwrvgnd_1
X_2570_ _1675_ VGND VGND VPWR VPWR _1676_ sky130_fd_sc_hd__clkbuf_4
XFILLER_0_6_309 VPWR VGND VPWR VGND sky130_ef_sc_hd__decap_12
X_3122_ _1908_ _1907_ _1871_ _1873_ _1894_ _1582_ VGND VGND VPWR VPWR _0166_ sky130_fd_sc_hd__mux4_2
X_4171_ _1270_ _1925_ _1666_ _1450_ VGND VGND VPWR VPWR _1271_ sky130_fd_sc_hd__a22oi_1
XFILLER_0_22_197 VPWR VGND VPWR VGND sky130_ef_sc_hd__decap_12
X_3053_ _1539_ _2010_ _0762_ _1667_ _1968_ VGND VGND VPWR VPWR _0098_ sky130_fd_sc_hd__a32o_1
XFILLER_0_26_62 VPWR VGND VPWR VGND sky130_ef_sc_hd__decap_12
XFILLER_0_60_204 VGND VGND VPWR VPWR sky130_fd_sc_hd__decap_8
X_2906_ net119 VGND VGND VPWR VPWR _2010_ sky130_fd_sc_hd__clkbuf_4
XFILLER_0_45_278 VGND VGND VPWR VPWR sky130_fd_sc_hd__fill_2
XFILLER_0_45_223 VGND VGND VPWR VPWR sky130_fd_sc_hd__fill_1
XFILLER_0_42_94 VGND VGND VPWR VPWR sky130_fd_sc_hd__fill_2
X_3886_ _0959_ _0962_ _0964_ _0966_ VGND VGND VPWR VPWR _0967_ sky130_fd_sc_hd__nand4_2
X_3955_ _1010_ _1011_ _1013_ _1039_ VGND VGND VPWR VPWR _2065_ sky130_fd_sc_hd__a211o_1
XFILLER_0_5_331 VGND VGND VPWR VPWR sky130_fd_sc_hd__decap_4
XFILLER_0_9_125 VGND VGND VPWR VPWR sky130_fd_sc_hd__fill_1
X_2768_ _1572_ _1347_ _1872_ VGND VGND VPWR VPWR _1873_ sky130_fd_sc_hd__o21ai_4
X_2837_ net50 _1939_ _1940_ _1941_ VGND VGND VPWR VPWR _1942_ sky130_fd_sc_hd__o211a_1
X_2699_ _1425_ _1440_ _1495_ _1804_ VGND VGND VPWR VPWR _2074_ sky130_fd_sc_hd__o211ai_1
XFILLER_0_33_429 VGND VGND VPWR VPWR sky130_fd_sc_hd__decap_8
XFILLER_0_6_83 VGND VGND VPWR VPWR sky130_fd_sc_hd__fill_1
XFILLER_0_24_418 VGND VGND VPWR VPWR sky130_fd_sc_hd__fill_2
XFILLER_0_8_180 VPWR VGND VPWR VGND sky130_ef_sc_hd__decap_12
XFILLER_0_47_28 VGND VGND VPWR VPWR sky130_fd_sc_hd__decap_6
XFILLER_0_59_337 VGND VGND VPWR VPWR sky130_fd_sc_hd__decap_3
XANTENNA_19 _1330_ VGND VGND VPWR VPWR sky130_fd_sc_hd__diode_2
X_3740_ _0024_ _1651_ _1644_ VGND VGND VPWR VPWR _0810_ sky130_fd_sc_hd__or3_2
XFILLER_0_27_278 VGND VGND VPWR VPWR sky130_fd_sc_hd__fill_2
XFILLER_0_27_223 VGND VGND VPWR VPWR sky130_fd_sc_hd__fill_1
XFILLER_0_6_106 VGND VGND VPWR VPWR sky130_fd_sc_hd__fill_1
XFILLER_0_6_128 VPWR VGND VPWR VGND sky130_ef_sc_hd__decap_12
XFILLER_0_42_259 VGND VGND VPWR VPWR sky130_fd_sc_hd__decap_4
Xoutput104 net104 VGND VGND VPWR VPWR result[7] sky130_fd_sc_hd__buf_2
XFILLER_0_2_301 VGND VGND VPWR VPWR sky130_fd_sc_hd__fill_2
X_3671_ _1093_ _1104_ _1765_ VGND VGND VPWR VPWR _0736_ sky130_fd_sc_hd__a21o_1
X_2622_ _1727_ VGND VGND VPWR VPWR _1728_ sky130_fd_sc_hd__buf_4
XFILLER_0_12_97 VPWR VGND VPWR VGND sky130_ef_sc_hd__decap_12
X_2553_ _1305_ _1301_ net55 VGND VGND VPWR VPWR _1659_ sky130_fd_sc_hd__o21ba_4
X_4154_ _1452_ _0427_ _1501_ VGND VGND VPWR VPWR _1252_ sky130_fd_sc_hd__a21o_1
X_3105_ _0148_ _1427_ _1642_ VGND VGND VPWR VPWR _0149_ sky130_fd_sc_hd__mux2_1
X_4085_ _1338_ _0196_ _0092_ VGND VGND VPWR VPWR _1179_ sky130_fd_sc_hd__o21a_1
X_2484_ _1561_ _1584_ _1589_ VGND VGND VPWR VPWR _1590_ sky130_fd_sc_hd__o21a_1
X_3036_ _1900_ _0079_ _0080_ VGND VGND VPWR VPWR _0081_ sky130_fd_sc_hd__o21ai_1
XTAP_TAPCELL_ROW_38_446 VGND VPWR sky130_fd_sc_hd__tapvpwrvgnd_1
XFILLER_0_73_373 VGND VGND VPWR VPWR sky130_fd_sc_hd__fill_1
XFILLER_0_58_381 VGND VGND VPWR VPWR sky130_fd_sc_hd__decap_3
X_3938_ _1916_ _0331_ _1021_ _0355_ VGND VGND VPWR VPWR _1022_ sky130_fd_sc_hd__o2bb2ai_1
XTAP_TAPCELL_ROW_21_313 VGND VPWR sky130_fd_sc_hd__tapvpwrvgnd_1
X_3869_ _1029_ _0196_ _0092_ VGND VGND VPWR VPWR _0948_ sky130_fd_sc_hd__o21a_1
XFILLER_0_18_234 VPWR VGND VPWR VGND sky130_ef_sc_hd__decap_12
XFILLER_0_56_307 VGND VGND VPWR VPWR sky130_fd_sc_hd__fill_1
XFILLER_0_49_370 VPWR VGND VPWR VGND sky130_ef_sc_hd__decap_12
Xinput17 A[24] VGND VGND VPWR VPWR net17 sky130_fd_sc_hd__buf_2
XFILLER_0_24_259 VGND VGND VPWR VPWR sky130_fd_sc_hd__decap_4
XFILLER_0_20_421 VPWR VGND VPWR VGND sky130_ef_sc_hd__decap_12
Xinput28 A[5] VGND VGND VPWR VPWR net28 sky130_fd_sc_hd__clkbuf_1
Xinput39 B[15] VGND VGND VPWR VPWR net39 sky130_fd_sc_hd__buf_2
XFILLER_0_55_362 VGND VGND VPWR VPWR sky130_fd_sc_hd__decap_6
XTAP_TAPCELL_ROW_43_482 VGND VPWR sky130_fd_sc_hd__tapvpwrvgnd_1
X_3723_ _1543_ _1821_ _0789_ _1518_ _0791_ VGND VGND VPWR VPWR _0792_ sky130_fd_sc_hd__o221ai_1
X_3654_ _1288_ _0656_ _1385_ VGND VGND VPWR VPWR _0718_ sky130_fd_sc_hd__o21ai_1
XFILLER_0_15_237 VGND VGND VPWR VPWR sky130_fd_sc_hd__decap_4
X_2605_ net16 _1599_ _1710_ VGND VGND VPWR VPWR _1711_ sky130_fd_sc_hd__o21ai_2
X_3585_ _1478_ _1789_ _0642_ _1479_ _1970_ _1694_ VGND VGND VPWR VPWR _0644_ sky130_fd_sc_hd__mux4_1
XFILLER_0_23_281 VGND VGND VPWR VPWR sky130_fd_sc_hd__fill_2
XFILLER_0_11_432 VGND VGND VPWR VPWR sky130_fd_sc_hd__fill_1
X_2467_ _1572_ _1302_ VGND VGND VPWR VPWR _1573_ sky130_fd_sc_hd__nand2_1
X_2536_ _1641_ VGND VGND VPWR VPWR _1642_ sky130_fd_sc_hd__clkbuf_4
X_4206_ clknet_2_3__leaf_clk _2072_ net123 VGND VGND VPWR VPWR net89 sky130_fd_sc_hd__dfrtp_1
X_4137_ _1692_ _1220_ _1226_ _1234_ VGND VGND VPWR VPWR _1235_ sky130_fd_sc_hd__o211ai_2
X_2398_ _0384_ _0395_ _1501_ _1502_ _1503_ VGND VGND VPWR VPWR _1504_ sky130_fd_sc_hd__a2111o_1
XFILLER_0_48_71 VPWR VGND VPWR VGND sky130_ef_sc_hd__decap_12
X_4068_ _0106_ _0574_ _1159_ _1160_ VGND VGND VPWR VPWR _1161_ sky130_fd_sc_hd__a22oi_1
X_3019_ _2002_ VGND VGND VPWR VPWR _0064_ sky130_fd_sc_hd__buf_2
XFILLER_0_61_343 VPWR VGND VPWR VGND sky130_ef_sc_hd__decap_12
XFILLER_0_61_321 VPWR VGND VPWR VGND sky130_ef_sc_hd__decap_12
XFILLER_0_46_384 VGND VGND VPWR VPWR sky130_fd_sc_hd__decap_3
XTAP_TAPCELL_ROW_57_585 VGND VPWR sky130_fd_sc_hd__tapvpwrvgnd_1
XFILLER_0_64_170 VGND VGND VPWR VPWR sky130_fd_sc_hd__fill_2
XFILLER_0_37_373 VGND VGND VPWR VPWR sky130_fd_sc_hd__decap_8
XFILLER_0_4_418 VGND VGND VPWR VPWR sky130_fd_sc_hd__fill_2
XFILLER_0_8_29 VGND VGND VPWR VPWR sky130_fd_sc_hd__fill_2
XFILLER_0_69_15 VPWR VGND VPWR VGND sky130_ef_sc_hd__decap_12
XFILLER_0_52_365 VPWR VGND VPWR VGND sky130_ef_sc_hd__decap_12
XFILLER_0_20_251 VGND VGND VPWR VPWR sky130_fd_sc_hd__fill_1
X_3370_ _0267_ _1923_ _0405_ _1545_ _0411_ VGND VGND VPWR VPWR _0412_ sky130_fd_sc_hd__a221oi_2
X_2321_ _1426_ VGND VGND VPWR VPWR _1427_ sky130_fd_sc_hd__clkbuf_4
X_2252_ net54 _1357_ net21 VGND VGND VPWR VPWR _1358_ sky130_fd_sc_hd__o21ba_1
X_2183_ net29 VGND VGND VPWR VPWR _1289_ sky130_fd_sc_hd__buf_2
XFILLER_0_18_85 VGND VGND VPWR VPWR sky130_fd_sc_hd__fill_1
XFILLER_0_18_96 VGND VGND VPWR VPWR sky130_fd_sc_hd__decap_6
XFILLER_0_7_223 VGND VGND VPWR VPWR sky130_fd_sc_hd__fill_1
XFILLER_0_43_321 VPWR VGND VPWR VGND sky130_ef_sc_hd__decap_12
X_3706_ _0242_ _0403_ _1845_ _0211_ _0773_ VGND VGND VPWR VPWR _0774_ sky130_fd_sc_hd__o32ai_2
X_3637_ _1454_ _0699_ VGND VGND VPWR VPWR _0700_ sky130_fd_sc_hd__nor2_1
XFILLER_0_7_245 VGND VGND VPWR VPWR sky130_fd_sc_hd__decap_3
XFILLER_0_7_278 VGND VGND VPWR VPWR sky130_fd_sc_hd__fill_2
X_3568_ _1426_ _1588_ _1559_ VGND VGND VPWR VPWR _0626_ sky130_fd_sc_hd__and3_1
X_2519_ _0986_ _1571_ VGND VGND VPWR VPWR _1625_ sky130_fd_sc_hd__nand2b_2
X_3499_ _1544_ _0545_ _0548_ _0549_ _0550_ VGND VGND VPWR VPWR _0551_ sky130_fd_sc_hd__a32o_1
XTAP_TAPCELL_ROW_54_566 VGND VPWR sky130_fd_sc_hd__tapvpwrvgnd_1
XFILLER_0_34_321 VPWR VGND VPWR VGND sky130_ef_sc_hd__decap_12
XFILLER_0_61_140 VGND VGND VPWR VPWR sky130_fd_sc_hd__fill_1
XFILLER_0_34_365 VPWR VGND VPWR VGND sky130_ef_sc_hd__decap_12
XFILLER_0_71_27 VPWR VGND VPWR VGND sky130_ef_sc_hd__decap_12
XFILLER_0_57_435 VGND VGND VPWR VPWR sky130_fd_sc_hd__fill_2
X_2870_ _1967_ _1971_ _1973_ VGND VGND VPWR VPWR _1974_ sky130_fd_sc_hd__o21ai_2
Xmax_cap114 net127 VGND VGND VPWR VPWR net114 sky130_fd_sc_hd__buf_1
XFILLER_0_20_53 VGND VGND VPWR VPWR sky130_fd_sc_hd__decap_8
XFILLER_0_40_346 VGND VGND VPWR VPWR sky130_fd_sc_hd__decap_6
XFILLER_0_29_51 VGND VGND VPWR VPWR sky130_fd_sc_hd__decap_4
X_3284_ _0074_ _0319_ _1721_ _0321_ VGND VGND VPWR VPWR _0322_ sky130_fd_sc_hd__o211a_1
X_3353_ _1985_ _0385_ _0386_ _1634_ _0392_ VGND VGND VPWR VPWR _0393_ sky130_fd_sc_hd__o221a_1
XFILLER_0_0_421 VPWR VGND VPWR VGND sky130_ef_sc_hd__decap_12
X_2304_ net4 net36 VGND VGND VPWR VPWR _1410_ sky130_fd_sc_hd__or2b_1
X_3422_ _0001_ _1298_ _0383_ _0092_ VGND VGND VPWR VPWR _0468_ sky130_fd_sc_hd__o22a_1
XTAP_TAPCELL_ROW_68_669 VGND VPWR sky130_fd_sc_hd__tapvpwrvgnd_1
X_2235_ net15 VGND VGND VPWR VPWR _1341_ sky130_fd_sc_hd__inv_2
X_2097_ net15 net47 VGND VGND VPWR VPWR _0417_ sky130_fd_sc_hd__and2_2
XTAP_TAPCELL_ROW_0_158 VGND VPWR sky130_fd_sc_hd__tapvpwrvgnd_1
X_2166_ net34 net2 VGND VGND VPWR VPWR _1157_ sky130_fd_sc_hd__nand2_1
X_2999_ _0032_ _0035_ _0038_ _1865_ _0044_ VGND VGND VPWR VPWR _0045_ sky130_fd_sc_hd__o32a_1
XFILLER_0_28_170 VGND VGND VPWR VPWR sky130_fd_sc_hd__decap_8
XPHY_EDGE_ROW_3_Right_3 VGND VGND VPWR VPWR sky130_fd_sc_hd__decap_3
XFILLER_0_0_85 VGND VGND VPWR VPWR sky130_fd_sc_hd__fill_2
XFILLER_0_43_184 VPWR VGND VPWR VGND sky130_ef_sc_hd__decap_12
XFILLER_0_31_324 VGND VGND VPWR VPWR sky130_fd_sc_hd__fill_1
XFILLER_0_16_365 VGND VGND VPWR VPWR sky130_fd_sc_hd__decap_6
XFILLER_0_16_387 VPWR VGND VPWR VGND sky130_ef_sc_hd__decap_12
XTAP_TAPCELL_ROW_59_603 VGND VPWR sky130_fd_sc_hd__tapvpwrvgnd_1
XFILLER_0_66_221 VGND VGND VPWR VPWR sky130_fd_sc_hd__decap_8
XFILLER_0_66_276 VGND VGND VPWR VPWR sky130_fd_sc_hd__fill_1
XFILLER_0_34_195 VGND VGND VPWR VPWR sky130_fd_sc_hd__fill_1
XFILLER_0_66_27 VGND VGND VPWR VPWR sky130_fd_sc_hd__fill_1
XFILLER_0_22_357 VGND VGND VPWR VPWR sky130_fd_sc_hd__fill_2
XFILLER_0_57_210 VGND VGND VPWR VPWR sky130_fd_sc_hd__decap_3
X_3971_ _0596_ _1841_ _1056_ VGND VGND VPWR VPWR _1057_ sky130_fd_sc_hd__a21o_1
X_2922_ _1492_ VGND VGND VPWR VPWR _2026_ sky130_fd_sc_hd__clkbuf_4
XFILLER_0_9_318 VGND VGND VPWR VPWR sky130_fd_sc_hd__decap_8
X_2853_ _1576_ _1464_ _1573_ VGND VGND VPWR VPWR _1957_ sky130_fd_sc_hd__o21ai_1
XFILLER_0_72_268 VPWR VGND VPWR VGND sky130_ef_sc_hd__decap_12
X_2784_ _1830_ _1831_ _1845_ _1866_ _1888_ VGND VGND VPWR VPWR _1889_ sky130_fd_sc_hd__o311a_1
XFILLER_0_40_165 VGND VGND VPWR VPWR sky130_fd_sc_hd__decap_8
XFILLER_0_31_85 VGND VGND VPWR VPWR sky130_fd_sc_hd__fill_2
XFILLER_0_25_195 VGND VGND VPWR VPWR sky130_fd_sc_hd__decap_6
XFILLER_0_13_368 VGND VGND VPWR VPWR sky130_fd_sc_hd__decap_3
X_3267_ _1941_ _1808_ net118 _1446_ _0066_ VGND VGND VPWR VPWR _0305_ sky130_fd_sc_hd__a32o_1
X_3405_ _0446_ _0447_ _1662_ _0448_ VGND VGND VPWR VPWR _0450_ sky130_fd_sc_hd__a2bb2o_1
X_3336_ _1567_ _0986_ _1852_ VGND VGND VPWR VPWR _0375_ sky130_fd_sc_hd__o21ai_2
X_3198_ _0237_ _0239_ _0729_ VGND VGND VPWR VPWR _0240_ sky130_fd_sc_hd__a21oi_1
X_2218_ _0879_ _0954_ _0911_ _1323_ VGND VGND VPWR VPWR _1324_ sky130_fd_sc_hd__and4_2
X_2149_ _0826_ _0847_ _0879_ _0911_ _0965_ VGND VGND VPWR VPWR _0976_ sky130_fd_sc_hd__o2111ai_4
XFILLER_0_63_279 VGND VGND VPWR VPWR sky130_fd_sc_hd__fill_1
XFILLER_0_8_362 VGND VGND VPWR VPWR sky130_fd_sc_hd__fill_2
XFILLER_0_16_162 VGND VGND VPWR VPWR sky130_fd_sc_hd__decap_8
XFILLER_0_31_121 VGND VGND VPWR VPWR sky130_fd_sc_hd__decap_4
XTAP_TAPCELL_ROW_70_686 VGND VPWR sky130_fd_sc_hd__tapvpwrvgnd_1
XFILLER_0_52_29 VGND VGND VPWR VPWR sky130_fd_sc_hd__decap_6
XFILLER_0_39_232 VPWR VGND VPWR VGND sky130_ef_sc_hd__decap_12
XTAP_TAPCELL_ROW_27_363 VGND VPWR sky130_fd_sc_hd__tapvpwrvgnd_1
XFILLER_0_22_176 VGND VGND VPWR VPWR sky130_fd_sc_hd__fill_2
XTAP_TAPCELL_ROW_10_230 VGND VPWR sky130_fd_sc_hd__tapvpwrvgnd_1
X_4170_ _1449_ _0449_ VGND VGND VPWR VPWR _1270_ sky130_fd_sc_hd__and2_1
X_3121_ _1853_ _1851_ _1862_ _1858_ _1724_ _1700_ VGND VGND VPWR VPWR _0165_ sky130_fd_sc_hd__mux4_1
X_3052_ _0091_ _0092_ _0093_ _0089_ _0096_ VGND VGND VPWR VPWR _0097_ sky130_fd_sc_hd__o221a_1
XFILLER_0_26_85 VGND VGND VPWR VPWR sky130_fd_sc_hd__decap_8
XFILLER_0_26_74 VGND VGND VPWR VPWR sky130_fd_sc_hd__decap_8
XFILLER_0_60_238 VPWR VGND VPWR VGND sky130_ef_sc_hd__decap_12
X_2836_ _1809_ VGND VGND VPWR VPWR _1941_ sky130_fd_sc_hd__clkbuf_4
X_3885_ _1646_ _0213_ _0413_ _0215_ VGND VGND VPWR VPWR _0966_ sky130_fd_sc_hd__a211o_1
X_3954_ _1023_ _1035_ _1038_ VGND VGND VPWR VPWR _1039_ sky130_fd_sc_hd__nand3_1
X_2905_ _1670_ VGND VGND VPWR VPWR _2009_ sky130_fd_sc_hd__clkbuf_4
X_2767_ net21 _1571_ VGND VGND VPWR VPWR _1872_ sky130_fd_sc_hd__or2b_1
X_2698_ _1547_ _1691_ _1738_ _1803_ VGND VGND VPWR VPWR _1804_ sky130_fd_sc_hd__and4b_1
XFILLER_0_13_121 VGND VGND VPWR VPWR sky130_fd_sc_hd__fill_2
X_3319_ _0256_ _0356_ _0066_ VGND VGND VPWR VPWR _0357_ sky130_fd_sc_hd__o21a_1
XFILLER_0_8_192 VGND VGND VPWR VPWR sky130_fd_sc_hd__decap_4
XFILLER_0_63_39 VGND VGND VPWR VPWR sky130_fd_sc_hd__decap_3
XFILLER_0_59_349 VGND VGND VPWR VPWR sky130_fd_sc_hd__fill_1
XFILLER_0_67_393 VPWR VGND VPWR VGND sky130_ef_sc_hd__decap_12
X_3670_ _1765_ _1093_ _1104_ _2037_ VGND VGND VPWR VPWR _0735_ sky130_fd_sc_hd__a31oi_1
XFILLER_0_15_408 VGND VGND VPWR VPWR sky130_fd_sc_hd__decap_3
X_2552_ _1657_ VGND VGND VPWR VPWR _1658_ sky130_fd_sc_hd__buf_4
XPHY_EDGE_ROW_34_Left_108 VGND VGND VPWR VPWR sky130_fd_sc_hd__decap_3
X_2483_ _1587_ _1588_ _1374_ _1309_ VGND VGND VPWR VPWR _1589_ sky130_fd_sc_hd__or4_1
XFILLER_0_2_324 VGND VGND VPWR VPWR sky130_fd_sc_hd__decap_4
X_2621_ _1305_ net44 VGND VGND VPWR VPWR _1727_ sky130_fd_sc_hd__or2_1
Xoutput105 net105 VGND VGND VPWR VPWR result[8] sky130_fd_sc_hd__buf_2
X_3104_ _1972_ _1869_ _1878_ VGND VGND VPWR VPWR _0148_ sky130_fd_sc_hd__o21ai_2
X_4153_ _1249_ _1250_ VGND VGND VPWR VPWR _1251_ sky130_fd_sc_hd__nand2_1
X_4084_ _1478_ VGND VGND VPWR VPWR _1177_ sky130_fd_sc_hd__buf_2
X_3035_ _1726_ VGND VGND VPWR VPWR _0080_ sky130_fd_sc_hd__clkbuf_4
XFILLER_0_65_308 VGND VGND VPWR VPWR sky130_fd_sc_hd__decap_4
XPHY_EDGE_ROW_43_Left_117 VGND VGND VPWR VPWR sky130_fd_sc_hd__decap_3
XTAP_TAPCELL_ROW_38_447 VGND VPWR sky130_fd_sc_hd__tapvpwrvgnd_1
X_3937_ _1608_ _1020_ _0413_ _0345_ VGND VGND VPWR VPWR _1021_ sky130_fd_sc_hd__o22a_1
XFILLER_0_73_352 VGND VGND VPWR VPWR sky130_fd_sc_hd__fill_1
XPHY_EDGE_ROW_52_Left_126 VGND VGND VPWR VPWR sky130_fd_sc_hd__decap_3
X_2819_ _1434_ _1436_ _1432_ _1538_ VGND VGND VPWR VPWR _1924_ sky130_fd_sc_hd__and4bb_1
X_3799_ _1314_ _1422_ _0872_ VGND VGND VPWR VPWR _0873_ sky130_fd_sc_hd__a21o_1
XTAP_TAPCELL_ROW_21_314 VGND VPWR sky130_fd_sc_hd__tapvpwrvgnd_1
XFILLER_0_5_140 VGND VGND VPWR VPWR sky130_fd_sc_hd__fill_2
X_3868_ _1529_ _1531_ _0945_ _0946_ _1823_ VGND VGND VPWR VPWR _0947_ sky130_fd_sc_hd__a311oi_2
XFILLER_0_18_246 VGND VGND VPWR VPWR sky130_fd_sc_hd__decap_6
XFILLER_0_68_135 VGND VGND VPWR VPWR sky130_fd_sc_hd__decap_4
XPHY_EDGE_ROW_61_Left_135 VGND VGND VPWR VPWR sky130_fd_sc_hd__decap_3
Xinput18 A[25] VGND VGND VPWR VPWR net18 sky130_fd_sc_hd__buf_2
XFILLER_0_64_341 VPWR VGND VPWR VGND sky130_ef_sc_hd__decap_12
XFILLER_0_49_382 VGND VGND VPWR VPWR sky130_fd_sc_hd__decap_6
XFILLER_0_24_216 VGND VGND VPWR VPWR sky130_fd_sc_hd__decap_6
XPHY_EDGE_ROW_70_Left_144 VGND VGND VPWR VPWR sky130_fd_sc_hd__decap_3
XFILLER_0_32_271 VPWR VGND VPWR VGND sky130_ef_sc_hd__decap_12
Xinput29 A[6] VGND VGND VPWR VPWR net29 sky130_fd_sc_hd__clkbuf_1
XFILLER_0_59_146 VGND VGND VPWR VPWR sky130_fd_sc_hd__decap_4
XFILLER_0_47_308 VGND VGND VPWR VPWR sky130_fd_sc_hd__fill_1
X_2604_ _1451_ _1575_ VGND VGND VPWR VPWR _1710_ sky130_fd_sc_hd__or2_1
XTAP_TAPCELL_ROW_43_483 VGND VPWR sky130_fd_sc_hd__tapvpwrvgnd_1
X_3653_ net62 _1441_ VGND VGND VPWR VPWR _0717_ sky130_fd_sc_hd__nor2_1
X_3722_ _1516_ _1517_ _1522_ _0790_ VGND VGND VPWR VPWR _0791_ sky130_fd_sc_hd__or4_1
X_2466_ _1571_ VGND VGND VPWR VPWR _1572_ sky130_fd_sc_hd__buf_4
X_3584_ _1481_ VGND VGND VPWR VPWR _0642_ sky130_fd_sc_hd__clkbuf_4
XFILLER_0_48_83 VGND VGND VPWR VPWR sky130_fd_sc_hd__fill_1
X_4205_ clknet_2_3__leaf_clk _2071_ net123 VGND VGND VPWR VPWR net88 sky130_fd_sc_hd__dfrtp_1
XFILLER_0_23_293 VPWR VGND VPWR VGND sky130_ef_sc_hd__decap_12
X_2535_ net55 net58 VGND VGND VPWR VPWR _1641_ sky130_fd_sc_hd__or2_1
X_3018_ _1799_ _1801_ _0058_ _0061_ _0062_ VGND VGND VPWR VPWR _0063_ sky130_fd_sc_hd__o221a_1
X_4136_ _1916_ _0658_ _1233_ VGND VGND VPWR VPWR _1234_ sky130_fd_sc_hd__a21oi_1
X_2397_ _0417_ _0438_ VGND VGND VPWR VPWR _1503_ sky130_fd_sc_hd__nor2_1
X_4067_ _0103_ _0031_ VGND VGND VPWR VPWR _1160_ sky130_fd_sc_hd__nand2_1
XFILLER_0_38_319 VPWR VGND VPWR VGND sky130_ef_sc_hd__decap_12
XFILLER_0_61_355 VPWR VGND VPWR VGND sky130_ef_sc_hd__decap_12
XFILLER_0_61_333 VGND VGND VPWR VPWR sky130_fd_sc_hd__decap_3
XPHY_EDGE_ROW_5_Left_79 VGND VGND VPWR VPWR sky130_fd_sc_hd__decap_3
XFILLER_0_14_282 VGND VGND VPWR VPWR sky130_fd_sc_hd__decap_8
XFILLER_0_14_293 VGND VGND VPWR VPWR sky130_fd_sc_hd__fill_2
XTAP_TAPCELL_ROW_57_586 VGND VPWR sky130_fd_sc_hd__tapvpwrvgnd_1
XFILLER_0_69_27 VGND VGND VPWR VPWR sky130_fd_sc_hd__decap_8
XFILLER_0_60_29 VGND VGND VPWR VPWR sky130_fd_sc_hd__decap_6
XFILLER_0_52_377 VPWR VGND VPWR VGND sky130_ef_sc_hd__decap_12
XFILLER_0_37_352 VGND VGND VPWR VPWR sky130_fd_sc_hd__decap_3
XFILLER_0_37_330 VGND VGND VPWR VPWR sky130_fd_sc_hd__decap_6
X_2251_ net22 VGND VGND VPWR VPWR _1357_ sky130_fd_sc_hd__inv_2
X_2320_ _1315_ VGND VGND VPWR VPWR _1426_ sky130_fd_sc_hd__clkbuf_4
XTAP_TAPCELL_ROW_48_520 VGND VPWR sky130_fd_sc_hd__tapvpwrvgnd_1
X_2182_ net61 net29 VGND VGND VPWR VPWR _1288_ sky130_fd_sc_hd__and2_1
XFILLER_0_18_64 VGND VGND VPWR VPWR sky130_fd_sc_hd__fill_1
XFILLER_0_34_85 VGND VGND VPWR VPWR sky130_fd_sc_hd__decap_4
XFILLER_0_34_41 VGND VGND VPWR VPWR sky130_fd_sc_hd__fill_2
XFILLER_0_70_152 VGND VGND VPWR VPWR sky130_fd_sc_hd__decap_3
XFILLER_0_70_141 VGND VGND VPWR VPWR sky130_fd_sc_hd__decap_4
XFILLER_0_55_182 VGND VGND VPWR VPWR sky130_fd_sc_hd__decap_4
X_3705_ _1954_ _0132_ _1875_ _0770_ VGND VGND VPWR VPWR _0773_ sky130_fd_sc_hd__o31a_1
XFILLER_0_43_333 VGND VGND VPWR VPWR sky130_fd_sc_hd__decap_3
X_3567_ _0601_ _0604_ _1614_ VGND VGND VPWR VPWR _0625_ sky130_fd_sc_hd__a21o_1
X_3636_ _0633_ _1696_ _0610_ _1485_ VGND VGND VPWR VPWR _0699_ sky130_fd_sc_hd__o31a_1
X_2449_ _1554_ VGND VGND VPWR VPWR _1555_ sky130_fd_sc_hd__clkbuf_4
X_2518_ _1621_ _1475_ _1623_ VGND VGND VPWR VPWR _1624_ sky130_fd_sc_hd__o21ai_2
X_3498_ _1799_ _1801_ _0547_ _1755_ VGND VGND VPWR VPWR _0550_ sky130_fd_sc_hd__o22a_1
X_4119_ _1177_ _1482_ _1480_ _1477_ VGND VGND VPWR VPWR _1215_ sky130_fd_sc_hd__or4_1
XTAP_TAPCELL_ROW_54_567 VGND VPWR sky130_fd_sc_hd__tapvpwrvgnd_1
XTAP_TAPCELL_ROW_3_178 VGND VPWR sky130_fd_sc_hd__tapvpwrvgnd_1
XFILLER_0_46_160 VPWR VGND VPWR VGND sky130_ef_sc_hd__decap_12
XFILLER_0_34_377 VGND VGND VPWR VPWR sky130_fd_sc_hd__decap_3
XFILLER_0_34_333 VPWR VGND VPWR VGND sky130_ef_sc_hd__decap_12
XFILLER_0_34_399 VGND VGND VPWR VPWR sky130_fd_sc_hd__fill_1
XFILLER_0_72_406 VPWR VGND VPWR VGND sky130_ef_sc_hd__decap_12
XFILLER_0_71_39 VGND VGND VPWR VPWR sky130_fd_sc_hd__decap_8
XFILLER_0_57_403 VPWR VGND VPWR VGND sky130_ef_sc_hd__decap_12
XFILLER_0_29_127 VPWR VGND VPWR VGND sky130_ef_sc_hd__decap_12
Xmax_cap115 _0643_ VGND VGND VPWR VPWR net115 sky130_fd_sc_hd__buf_1
XFILLER_0_52_141 VGND VGND VPWR VPWR sky130_fd_sc_hd__decap_3
XFILLER_0_52_130 VGND VGND VPWR VPWR sky130_fd_sc_hd__decap_8
XFILLER_0_25_333 VGND VGND VPWR VPWR sky130_fd_sc_hd__decap_3
X_3421_ _0032_ _0208_ _0403_ _1959_ VGND VGND VPWR VPWR _0467_ sky130_fd_sc_hd__or4_1
XFILLER_0_20_76 VGND VGND VPWR VPWR sky130_fd_sc_hd__decap_8
X_2234_ _1335_ _1336_ _1337_ _1339_ VGND VGND VPWR VPWR _1340_ sky130_fd_sc_hd__a31o_1
X_3283_ _0074_ _0320_ VGND VGND VPWR VPWR _0321_ sky130_fd_sc_hd__nand2_1
XFILLER_0_0_433 VGND VGND VPWR VPWR sky130_fd_sc_hd__decap_4
X_2303_ _1050_ net5 VGND VGND VPWR VPWR _1409_ sky130_fd_sc_hd__and2b_1
X_3352_ _1967_ _0388_ _0391_ _0142_ VGND VGND VPWR VPWR _0392_ sky130_fd_sc_hd__o211ai_1
X_2096_ _0384_ _0395_ VGND VGND VPWR VPWR _0406_ sky130_fd_sc_hd__nand2_1
XTAP_TAPCELL_ROW_0_159 VGND VPWR sky130_fd_sc_hd__tapvpwrvgnd_1
XTAP_TAPCELL_ROW_0_148 VGND VPWR sky130_fd_sc_hd__tapvpwrvgnd_1
X_2165_ _1125_ _1136_ VGND VGND VPWR VPWR _1146_ sky130_fd_sc_hd__nor2_1
X_2998_ _1591_ _0039_ _0040_ _0041_ _0043_ VGND VGND VPWR VPWR _0044_ sky130_fd_sc_hd__a221o_1
XFILLER_0_43_141 VPWR VGND VPWR VGND sky130_ef_sc_hd__decap_12
XTAP_TAPCELL_ROW_16_280 VGND VPWR sky130_fd_sc_hd__tapvpwrvgnd_1
XFILLER_0_43_196 VGND VGND VPWR VPWR sky130_fd_sc_hd__decap_8
X_3619_ _0311_ _0648_ _0652_ _0680_ VGND VGND VPWR VPWR _0681_ sky130_fd_sc_hd__o211a_1
XTAP_TAPCELL_ROW_8_215 VGND VPWR sky130_fd_sc_hd__tapvpwrvgnd_1
XFILLER_0_9_73 VGND VGND VPWR VPWR sky130_fd_sc_hd__fill_1
XFILLER_0_16_399 VPWR VGND VPWR VGND sky130_ef_sc_hd__decap_12
XTAP_TAPCELL_ROW_59_604 VGND VPWR sky130_fd_sc_hd__tapvpwrvgnd_1
XFILLER_0_34_141 VGND VGND VPWR VPWR sky130_fd_sc_hd__fill_1
XPHY_EDGE_ROW_8_Left_82 VGND VGND VPWR VPWR sky130_fd_sc_hd__decap_3
X_3970_ _1854_ _2053_ _1557_ VGND VGND VPWR VPWR _1056_ sky130_fd_sc_hd__a21o_1
XPHY_EDGE_ROW_13_Right_13 VGND VGND VPWR VPWR sky130_fd_sc_hd__decap_3
X_2921_ _1424_ _1806_ _1484_ _1946_ VGND VGND VPWR VPWR _2025_ sky130_fd_sc_hd__o31a_1
X_2783_ _1561_ _1868_ _1875_ _1887_ VGND VGND VPWR VPWR _1888_ sky130_fd_sc_hd__o31a_1
XFILLER_0_25_152 VGND VGND VPWR VPWR sky130_fd_sc_hd__fill_2
XPHY_EDGE_ROW_22_Right_22 VGND VGND VPWR VPWR sky130_fd_sc_hd__decap_3
XFILLER_0_9_308 VGND VGND VPWR VPWR sky130_fd_sc_hd__fill_2
X_2852_ _1599_ _1308_ VGND VGND VPWR VPWR _1956_ sky130_fd_sc_hd__and2_1
XFILLER_0_40_122 VGND VGND VPWR VPWR sky130_fd_sc_hd__fill_1
X_3404_ _0315_ _1718_ _1724_ VGND VGND VPWR VPWR _0448_ sky130_fd_sc_hd__mux2_1
XFILLER_0_25_174 VGND VGND VPWR VPWR sky130_fd_sc_hd__decap_4
XFILLER_0_13_347 VGND VGND VPWR VPWR sky130_fd_sc_hd__decap_3
X_3197_ _0676_ _1354_ VGND VGND VPWR VPWR _0239_ sky130_fd_sc_hd__or2_1
X_2217_ _1321_ _1322_ VGND VGND VPWR VPWR _1323_ sky130_fd_sc_hd__nor2_2
XPHY_EDGE_ROW_31_Right_31 VGND VGND VPWR VPWR sky130_fd_sc_hd__decap_3
X_3266_ _1441_ VGND VGND VPWR VPWR _0304_ sky130_fd_sc_hd__clkbuf_4
XFILLER_0_22_3 VGND VGND VPWR VPWR sky130_fd_sc_hd__decap_8
X_3335_ _1577_ _1411_ _1850_ VGND VGND VPWR VPWR _0374_ sky130_fd_sc_hd__o21ai_2
X_2148_ _0954_ VGND VGND VPWR VPWR _0965_ sky130_fd_sc_hd__clkbuf_4
XTAP_TAPCELL_ROW_64_640 VGND VPWR sky130_fd_sc_hd__tapvpwrvgnd_1
XFILLER_0_63_225 VPWR VGND VPWR VGND sky130_ef_sc_hd__decap_12
XFILLER_0_48_288 VGND VGND VPWR VPWR sky130_fd_sc_hd__fill_2
XPHY_EDGE_ROW_40_Right_40 VGND VGND VPWR VPWR sky130_fd_sc_hd__decap_3
XFILLER_0_31_166 VGND VGND VPWR VPWR sky130_fd_sc_hd__fill_2
XTAP_TAPCELL_ROW_70_687 VGND VPWR sky130_fd_sc_hd__tapvpwrvgnd_1
XFILLER_0_54_214 VGND VGND VPWR VPWR sky130_fd_sc_hd__decap_3
XFILLER_0_39_244 VGND VGND VPWR VPWR sky130_fd_sc_hd__fill_2
XTAP_TAPCELL_ROW_27_364 VGND VPWR sky130_fd_sc_hd__tapvpwrvgnd_1
XTAP_TAPCELL_ROW_10_231 VGND VPWR sky130_fd_sc_hd__tapvpwrvgnd_1
X_3051_ net53 _1968_ _1676_ _0095_ VGND VGND VPWR VPWR _0096_ sky130_fd_sc_hd__o31a_1
X_3120_ _0080_ _0160_ _0163_ VGND VGND VPWR VPWR _0164_ sky130_fd_sc_hd__o21ai_2
XFILLER_0_26_20 VGND VGND VPWR VPWR sky130_fd_sc_hd__decap_8
X_3953_ _2026_ _1036_ _1037_ VGND VGND VPWR VPWR _1038_ sky130_fd_sc_hd__or3_1
XFILLER_0_9_149 VPWR VGND VPWR VGND sky130_ef_sc_hd__decap_12
X_2766_ _1576_ _1805_ _1870_ VGND VGND VPWR VPWR _1871_ sky130_fd_sc_hd__o21ai_2
X_2904_ _2002_ _1726_ _2004_ _2007_ VGND VGND VPWR VPWR _2008_ sky130_fd_sc_hd__or4_1
XFILLER_0_45_225 VGND VGND VPWR VPWR sky130_fd_sc_hd__decap_8
X_3884_ _0850_ _0956_ _0963_ _0211_ VGND VGND VPWR VPWR _0964_ sky130_fd_sc_hd__a31o_1
XFILLER_0_42_85 VGND VGND VPWR VPWR sky130_fd_sc_hd__decap_6
X_2835_ _1433_ _1808_ _1537_ _1437_ VGND VGND VPWR VPWR _1940_ sky130_fd_sc_hd__and4bb_4
XFILLER_0_5_388 VGND VGND VPWR VPWR sky130_fd_sc_hd__decap_4
XFILLER_0_13_111 VGND VGND VPWR VPWR sky130_fd_sc_hd__fill_1
X_2697_ _1496_ _1797_ _1802_ VGND VGND VPWR VPWR _1803_ sky130_fd_sc_hd__o21ai_1
X_3318_ _1553_ _1541_ _1435_ VGND VGND VPWR VPWR _0356_ sky130_fd_sc_hd__o21a_1
XFILLER_0_6_85 VGND VGND VPWR VPWR sky130_fd_sc_hd__decap_6
XFILLER_0_13_188 VGND VGND VPWR VPWR sky130_fd_sc_hd__fill_1
X_3249_ _0285_ _0286_ _0289_ VGND VGND VPWR VPWR _2090_ sky130_fd_sc_hd__o21ai_1
XFILLER_0_24_409 VGND VGND VPWR VPWR sky130_fd_sc_hd__decap_3
XFILLER_0_59_328 VGND VGND VPWR VPWR sky130_fd_sc_hd__fill_2
X_2620_ _1644_ VGND VGND VPWR VPWR _1726_ sky130_fd_sc_hd__clkbuf_4
XFILLER_0_27_225 VGND VGND VPWR VPWR sky130_fd_sc_hd__decap_8
XFILLER_0_12_33 VGND VGND VPWR VPWR sky130_fd_sc_hd__fill_1
X_2551_ _1654_ _1656_ VGND VGND VPWR VPWR _1657_ sky130_fd_sc_hd__nand2_2
X_2482_ _1510_ VGND VGND VPWR VPWR _1588_ sky130_fd_sc_hd__clkbuf_4
Xoutput106 net106 VGND VGND VPWR VPWR result[9] sky130_fd_sc_hd__buf_2
X_4152_ _1248_ _1246_ _1501_ VGND VGND VPWR VPWR _1250_ sky130_fd_sc_hd__a21o_1
X_3103_ _1809_ _1808_ _1668_ _0036_ VGND VGND VPWR VPWR _0147_ sky130_fd_sc_hd__a31o_2
X_4083_ _1174_ _1175_ _1692_ VGND VGND VPWR VPWR _1176_ sky130_fd_sc_hd__a21o_1
X_3034_ _0078_ _1730_ _1733_ VGND VGND VPWR VPWR _0079_ sky130_fd_sc_hd__a21oi_1
XFILLER_0_37_85 VGND VGND VPWR VPWR sky130_fd_sc_hd__decap_3
XFILLER_0_53_51 VGND VGND VPWR VPWR sky130_fd_sc_hd__decap_4
X_3936_ _0267_ _0324_ _0142_ _1309_ VGND VGND VPWR VPWR _1020_ sky130_fd_sc_hd__or4_1
XTAP_TAPCELL_ROW_21_315 VGND VPWR sky130_fd_sc_hd__tapvpwrvgnd_1
XFILLER_0_18_225 VGND VGND VPWR VPWR sky130_fd_sc_hd__fill_1
XFILLER_0_18_269 VPWR VGND VPWR VGND sky130_ef_sc_hd__decap_12
X_2749_ _1847_ _1849_ _1851_ _1853_ _1627_ _1629_ VGND VGND VPWR VPWR _1854_ sky130_fd_sc_hd__mux4_1
X_3798_ _1472_ VGND VGND VPWR VPWR _0872_ sky130_fd_sc_hd__buf_2
XFILLER_0_5_152 VPWR VGND VPWR VGND sky130_ef_sc_hd__decap_12
X_3867_ _1531_ _0945_ _1529_ VGND VGND VPWR VPWR _0946_ sky130_fd_sc_hd__a21oi_2
X_2818_ _1922_ VGND VGND VPWR VPWR _1923_ sky130_fd_sc_hd__buf_4
XFILLER_0_1_391 VGND VGND VPWR VPWR sky130_fd_sc_hd__fill_1
Xinput19 A[26] VGND VGND VPWR VPWR net19 sky130_fd_sc_hd__clkbuf_2
XFILLER_0_64_375 VPWR VGND VPWR VGND sky130_ef_sc_hd__decap_12
XFILLER_0_64_353 VGND VGND VPWR VPWR sky130_fd_sc_hd__decap_8
XFILLER_0_32_283 VPWR VGND VPWR VGND sky130_ef_sc_hd__decap_12
XFILLER_0_59_103 VGND VGND VPWR VPWR sky130_fd_sc_hd__decap_3
XFILLER_0_59_169 VPWR VGND VPWR VGND sky130_ef_sc_hd__decap_12
XFILLER_0_55_353 VGND VGND VPWR VPWR sky130_fd_sc_hd__decap_4
XTAP_TAPCELL_ROW_43_484 VGND VPWR sky130_fd_sc_hd__tapvpwrvgnd_1
XTAP_TAPCELL_ROW_35_418 VGND VPWR sky130_fd_sc_hd__tapvpwrvgnd_1
XFILLER_0_23_87 VGND VGND VPWR VPWR sky130_fd_sc_hd__decap_6
XFILLER_0_23_65 VGND VGND VPWR VPWR sky130_fd_sc_hd__fill_2
XFILLER_0_23_54 VGND VGND VPWR VPWR sky130_fd_sc_hd__fill_2
XFILLER_0_7_417 VPWR VGND VPWR VGND sky130_ef_sc_hd__decap_12
XFILLER_0_70_301 VGND VGND VPWR VPWR sky130_fd_sc_hd__fill_1
XFILLER_0_55_375 VPWR VGND VPWR VGND sky130_ef_sc_hd__decap_12
X_2534_ _1592_ _1605_ _1615_ _1639_ VGND VGND VPWR VPWR _1640_ sky130_fd_sc_hd__o31a_1
X_2603_ _1708_ VGND VGND VPWR VPWR _1709_ sky130_fd_sc_hd__buf_2
X_3583_ _1646_ _0639_ _0640_ _0083_ _1891_ VGND VGND VPWR VPWR _0641_ sky130_fd_sc_hd__o2111ai_2
X_3652_ _2032_ _2033_ _1454_ VGND VGND VPWR VPWR _0716_ sky130_fd_sc_hd__a21oi_1
XFILLER_0_23_261 VPWR VGND VPWR VGND sky130_ef_sc_hd__decap_12
XPHY_EDGE_ROW_21_Left_95 VGND VGND VPWR VPWR sky130_fd_sc_hd__decap_3
X_3721_ _1397_ _1398_ _0748_ _1387_ VGND VGND VPWR VPWR _0790_ sky130_fd_sc_hd__a22oi_2
X_4135_ _0660_ _1032_ _1229_ _1231_ VGND VGND VPWR VPWR _1233_ sky130_fd_sc_hd__a211o_1
X_4204_ clknet_2_3__leaf_clk _2070_ net123 VGND VGND VPWR VPWR net87 sky130_fd_sc_hd__dfrtp_1
X_2396_ _0363_ _0373_ VGND VGND VPWR VPWR _1502_ sky130_fd_sc_hd__nor2_2
XFILLER_0_2_188 VGND VGND VPWR VPWR sky130_fd_sc_hd__decap_3
X_2465_ _1305_ VGND VGND VPWR VPWR _1571_ sky130_fd_sc_hd__clkbuf_4
X_3017_ _0061_ _0058_ VGND VGND VPWR VPWR _0062_ sky130_fd_sc_hd__nand2_1
XFILLER_0_64_94 VGND VGND VPWR VPWR sky130_fd_sc_hd__decap_4
X_4066_ _1560_ _0110_ _0037_ VGND VGND VPWR VPWR _1159_ sky130_fd_sc_hd__o21a_1
XFILLER_0_38_309 VGND VGND VPWR VPWR sky130_fd_sc_hd__decap_6
XFILLER_0_3_42 VGND VGND VPWR VPWR sky130_fd_sc_hd__fill_2
XFILLER_0_73_183 VGND VGND VPWR VPWR sky130_fd_sc_hd__fill_2
X_3919_ _1403_ _1404_ _1532_ _0946_ VGND VGND VPWR VPWR _1002_ sky130_fd_sc_hd__o22a_1
XFILLER_0_61_367 VGND VGND VPWR VPWR sky130_fd_sc_hd__decap_4
XFILLER_0_14_272 VGND VGND VPWR VPWR sky130_fd_sc_hd__fill_2
XPHY_EDGE_ROW_69_Right_69 VGND VGND VPWR VPWR sky130_fd_sc_hd__decap_3
XTAP_TAPCELL_ROW_57_587 VGND VPWR sky130_fd_sc_hd__tapvpwrvgnd_1
XFILLER_0_56_106 VGND VGND VPWR VPWR sky130_fd_sc_hd__fill_2
XFILLER_0_52_389 VPWR VGND VPWR VGND sky130_ef_sc_hd__decap_12
XFILLER_0_12_209 VGND VGND VPWR VPWR sky130_fd_sc_hd__fill_2
X_2250_ _0676_ _1354_ _1355_ _1315_ VGND VGND VPWR VPWR _1356_ sky130_fd_sc_hd__o2bb2a_1
XFILLER_0_20_253 VGND VGND VPWR VPWR sky130_fd_sc_hd__decap_6
XTAP_TAPCELL_ROW_48_521 VGND VPWR sky130_fd_sc_hd__tapvpwrvgnd_1
X_2181_ _1285_ _1286_ VGND VGND VPWR VPWR _1287_ sky130_fd_sc_hd__nand2_2
XFILLER_0_62_109 VPWR VGND VPWR VGND sky130_ef_sc_hd__decap_12
X_3704_ _0242_ _1920_ _0770_ VGND VGND VPWR VPWR _0771_ sky130_fd_sc_hd__a21bo_1
XFILLER_0_28_342 VGND VGND VPWR VPWR sky130_fd_sc_hd__decap_3
XFILLER_0_70_197 VGND VGND VPWR VPWR sky130_fd_sc_hd__fill_1
XFILLER_0_43_367 VGND VGND VPWR VPWR sky130_fd_sc_hd__fill_1
X_3635_ _1954_ _1865_ _0248_ _0692_ _0696_ VGND VGND VPWR VPWR _0698_ sky130_fd_sc_hd__o311a_1
X_2517_ _1622_ _1572_ VGND VGND VPWR VPWR _1623_ sky130_fd_sc_hd__nand2_1
X_3497_ _1755_ _0547_ VGND VGND VPWR VPWR _0549_ sky130_fd_sc_hd__nand2_1
XFILLER_0_11_220 VGND VGND VPWR VPWR sky130_fd_sc_hd__decap_4
X_3566_ _1822_ _0609_ _0619_ _0623_ VGND VGND VPWR VPWR _0624_ sky130_fd_sc_hd__o211a_1
X_4118_ _1211_ _1212_ _1209_ VGND VGND VPWR VPWR _1214_ sky130_fd_sc_hd__a21oi_2
X_2448_ _1548_ _1549_ _1553_ VGND VGND VPWR VPWR _1554_ sky130_fd_sc_hd__and3_1
XFILLER_0_11_286 VPWR VGND VPWR VGND sky130_ef_sc_hd__decap_12
X_2379_ _1426_ VGND VGND VPWR VPWR _1485_ sky130_fd_sc_hd__clkbuf_4
XFILLER_0_66_415 VGND VGND VPWR VPWR sky130_fd_sc_hd__decap_4
X_4049_ _1137_ _1138_ _1139_ _1140_ VGND VGND VPWR VPWR _1141_ sky130_fd_sc_hd__o22a_1
XTAP_TAPCELL_ROW_3_179 VGND VPWR sky130_fd_sc_hd__tapvpwrvgnd_1
XFILLER_0_61_120 VPWR VGND VPWR VGND sky130_ef_sc_hd__decap_12
XFILLER_0_53_109 VGND VGND VPWR VPWR sky130_fd_sc_hd__decap_3
XFILLER_0_46_194 VGND VGND VPWR VPWR sky130_fd_sc_hd__fill_2
XFILLER_0_34_345 VGND VGND VPWR VPWR sky130_fd_sc_hd__fill_2
XFILLER_0_72_418 VGND VGND VPWR VPWR sky130_fd_sc_hd__fill_2
XFILLER_0_57_415 VPWR VGND VPWR VGND sky130_ef_sc_hd__decap_12
XFILLER_0_29_139 VPWR VGND VPWR VGND sky130_ef_sc_hd__decap_12
Xmax_cap116 _0182_ VGND VGND VPWR VPWR net116 sky130_fd_sc_hd__clkbuf_1
XFILLER_0_52_197 VPWR VGND VPWR VGND sky130_ef_sc_hd__decap_12
XFILLER_0_40_326 VGND VGND VPWR VPWR sky130_fd_sc_hd__decap_4
XFILLER_0_29_20 VPWR VGND VPWR VGND sky130_ef_sc_hd__decap_12
XFILLER_0_25_367 VGND VGND VPWR VPWR sky130_fd_sc_hd__fill_1
X_3420_ _1930_ _1682_ _1299_ VGND VGND VPWR VPWR _0466_ sky130_fd_sc_hd__mux2_1
X_3351_ _1587_ _0389_ _0390_ _1583_ VGND VGND VPWR VPWR _0391_ sky130_fd_sc_hd__o211ai_2
XFILLER_0_20_11 VGND VGND VPWR VPWR sky130_fd_sc_hd__fill_1
XFILLER_0_20_99 VGND VGND VPWR VPWR sky130_fd_sc_hd__fill_1
X_2233_ net14 _1338_ VGND VGND VPWR VPWR _1339_ sky130_fd_sc_hd__and2b_1
XFILLER_0_29_86 VGND VGND VPWR VPWR sky130_fd_sc_hd__decap_8
X_2164_ net64 net32 VGND VGND VPWR VPWR _1136_ sky130_fd_sc_hd__and2b_1
X_3282_ _1694_ _0245_ _1616_ VGND VGND VPWR VPWR _0320_ sky130_fd_sc_hd__a21o_1
X_2302_ _0986_ net39 VGND VGND VPWR VPWR _1408_ sky130_fd_sc_hd__or2b_1
X_2095_ net46 net14 VGND VGND VPWR VPWR _0395_ sky130_fd_sc_hd__nand2_2
XFILLER_0_45_74 VGND VGND VPWR VPWR sky130_fd_sc_hd__decap_6
XTAP_TAPCELL_ROW_0_149 VGND VPWR sky130_fd_sc_hd__tapvpwrvgnd_1
X_2997_ _1985_ _0042_ VGND VGND VPWR VPWR _0043_ sky130_fd_sc_hd__nor2_1
XTAP_TAPCELL_ROW_51_538 VGND VPWR sky130_fd_sc_hd__tapvpwrvgnd_1
XFILLER_0_43_175 VGND VGND VPWR VPWR sky130_fd_sc_hd__fill_1
XFILLER_0_43_153 VGND VGND VPWR VPWR sky130_fd_sc_hd__fill_1
XFILLER_0_35_109 VGND VGND VPWR VPWR sky130_fd_sc_hd__decap_3
XFILLER_0_31_315 VGND VGND VPWR VPWR sky130_fd_sc_hd__fill_2
XTAP_TAPCELL_ROW_16_281 VGND VPWR sky130_fd_sc_hd__tapvpwrvgnd_1
X_3549_ _0064_ _0080_ _0162_ VGND VGND VPWR VPWR _0605_ sky130_fd_sc_hd__or3_1
XTAP_TAPCELL_ROW_8_216 VGND VPWR sky130_fd_sc_hd__tapvpwrvgnd_1
X_3618_ _2038_ _0653_ _0656_ _0679_ VGND VGND VPWR VPWR _0680_ sky130_fd_sc_hd__o31a_1
XTAP_TAPCELL_ROW_67_660 VGND VPWR sky130_fd_sc_hd__tapvpwrvgnd_1
XFILLER_0_19_194 VGND VGND VPWR VPWR sky130_fd_sc_hd__fill_1
XFILLER_0_66_29 VGND VGND VPWR VPWR sky130_fd_sc_hd__decap_8
Xclkbuf_2_3__f_clk clknet_0_clk VGND VGND VPWR VPWR clknet_2_3__leaf_clk sky130_fd_sc_hd__clkbuf_16
X_2920_ _1486_ VGND VGND VPWR VPWR _2024_ sky130_fd_sc_hd__clkbuf_4
XFILLER_0_15_11 VGND VGND VPWR VPWR sky130_fd_sc_hd__fill_1
XFILLER_0_15_44 VPWR VGND VPWR VGND sky130_ef_sc_hd__decap_12
X_2851_ _1840_ VGND VGND VPWR VPWR _1955_ sky130_fd_sc_hd__clkbuf_4
XFILLER_0_57_256 VGND VGND VPWR VPWR sky130_fd_sc_hd__fill_1
X_2782_ _1644_ _1652_ _1883_ _1886_ VGND VGND VPWR VPWR _1887_ sky130_fd_sc_hd__o31a_1
XFILLER_0_25_131 VGND VGND VPWR VPWR sky130_fd_sc_hd__fill_1
XFILLER_0_17_109 VGND VGND VPWR VPWR sky130_fd_sc_hd__decap_3
X_3403_ _0074_ _0317_ _1721_ VGND VGND VPWR VPWR _0447_ sky130_fd_sc_hd__o21ai_1
X_3334_ _0267_ _0106_ _1986_ _1843_ VGND VGND VPWR VPWR _0372_ sky130_fd_sc_hd__or4_1
XFILLER_0_0_286 VGND VGND VPWR VPWR sky130_fd_sc_hd__decap_4
XFILLER_0_13_337 VGND VGND VPWR VPWR sky130_fd_sc_hd__fill_2
X_3196_ _0224_ _0232_ _0238_ VGND VGND VPWR VPWR _2081_ sky130_fd_sc_hd__nand3_1
X_2216_ net50 net18 VGND VGND VPWR VPWR _1322_ sky130_fd_sc_hd__and2b_1
X_2147_ _0933_ _0943_ VGND VGND VPWR VPWR _0954_ sky130_fd_sc_hd__nor2_1
X_3265_ _0298_ _0303_ VGND VGND VPWR VPWR _0000_ sky130_fd_sc_hd__nor2_1
XFILLER_0_15_3 VGND VGND VPWR VPWR sky130_fd_sc_hd__decap_8
XFILLER_0_72_83 VGND VGND VPWR VPWR sky130_fd_sc_hd__fill_1
XTAP_TAPCELL_ROW_64_641 VGND VPWR sky130_fd_sc_hd__tapvpwrvgnd_1
XFILLER_0_63_237 VGND VGND VPWR VPWR sky130_fd_sc_hd__fill_1
XFILLER_0_36_418 VGND VGND VPWR VPWR sky130_fd_sc_hd__fill_2
XFILLER_0_71_281 VGND VGND VPWR VPWR sky130_fd_sc_hd__decap_3
XFILLER_0_16_197 VGND VGND VPWR VPWR sky130_fd_sc_hd__fill_2
XTAP_TAPCELL_ROW_10_232 VGND VPWR sky130_fd_sc_hd__tapvpwrvgnd_1
XFILLER_0_62_292 VGND VGND VPWR VPWR sky130_fd_sc_hd__decap_6
XFILLER_0_50_421 VGND VGND VPWR VPWR sky130_fd_sc_hd__decap_4
XFILLER_0_10_307 VGND VGND VPWR VPWR sky130_fd_sc_hd__fill_1
XFILLER_0_10_318 VPWR VGND VPWR VGND sky130_ef_sc_hd__decap_12
X_3050_ _0094_ _0058_ _0762_ _1929_ VGND VGND VPWR VPWR _0095_ sky130_fd_sc_hd__o2bb2a_1
X_2903_ _1700_ _1658_ _1598_ _2006_ VGND VGND VPWR VPWR _2007_ sky130_fd_sc_hd__o31a_1
X_3883_ _0596_ _1830_ _0209_ VGND VGND VPWR VPWR _0963_ sky130_fd_sc_hd__or3_1
XFILLER_0_42_53 VGND VGND VPWR VPWR sky130_fd_sc_hd__decap_4
XFILLER_0_42_20 VGND VGND VPWR VPWR sky130_fd_sc_hd__decap_8
X_3952_ _1474_ _0939_ _0941_ _1009_ _1486_ VGND VGND VPWR VPWR _1037_ sky130_fd_sc_hd__o311a_1
X_2765_ net19 _1571_ VGND VGND VPWR VPWR _1870_ sky130_fd_sc_hd__or2b_1
X_2834_ _1430_ VGND VGND VPWR VPWR _1939_ sky130_fd_sc_hd__clkbuf_4
X_2696_ _1496_ _1797_ _1799_ _1801_ VGND VGND VPWR VPWR _1802_ sky130_fd_sc_hd__o2bb2a_1
XFILLER_0_45_259 VGND VGND VPWR VPWR sky130_fd_sc_hd__fill_2
XFILLER_0_41_432 VGND VGND VPWR VPWR sky130_fd_sc_hd__fill_1
XFILLER_0_5_301 VGND VGND VPWR VPWR sky130_fd_sc_hd__fill_1
X_3317_ _0354_ _1719_ _1956_ VGND VGND VPWR VPWR _0355_ sky130_fd_sc_hd__and3_1
XFILLER_0_6_53 VGND VGND VPWR VPWR sky130_fd_sc_hd__decap_4
X_3248_ _1353_ _0287_ _1543_ _0288_ VGND VGND VPWR VPWR _0289_ sky130_fd_sc_hd__o211ai_1
X_3179_ _1558_ _0207_ _0210_ _0211_ _0221_ VGND VGND VPWR VPWR _0222_ sky130_fd_sc_hd__o221a_1
XFILLER_0_51_229 VGND VGND VPWR VPWR sky130_fd_sc_hd__decap_4
XTAP_TAPCELL_ROW_24_335 VGND VPWR sky130_fd_sc_hd__tapvpwrvgnd_1
XFILLER_0_32_421 VPWR VGND VPWR VGND sky130_ef_sc_hd__decap_12
XFILLER_0_4_3 VPWR VGND VPWR VGND sky130_ef_sc_hd__decap_12
XFILLER_0_12_12 VGND VGND VPWR VPWR sky130_fd_sc_hd__fill_1
XFILLER_0_50_251 VGND VGND VPWR VPWR sky130_fd_sc_hd__fill_1
X_2550_ _1655_ VGND VGND VPWR VPWR _1656_ sky130_fd_sc_hd__clkbuf_4
Xoutput107 net107 VGND VGND VPWR VPWR valid_out sky130_fd_sc_hd__buf_2
X_2481_ _1586_ VGND VGND VPWR VPWR _1587_ sky130_fd_sc_hd__buf_4
X_4151_ _1501_ _1248_ _1246_ _1823_ VGND VGND VPWR VPWR _1249_ sky130_fd_sc_hd__a31oi_1
XFILLER_0_10_126 VPWR VGND VPWR VGND sky130_ef_sc_hd__decap_12
X_4220_ clknet_2_0__leaf_clk net71 net120 VGND VGND VPWR VPWR net107 sky130_fd_sc_hd__dfrtp_1
X_3102_ _0132_ _0137_ _0138_ _0145_ VGND VGND VPWR VPWR _0146_ sky130_fd_sc_hd__o211a_1
X_4082_ _1900_ _1901_ _0159_ _0865_ VGND VGND VPWR VPWR _1175_ sky130_fd_sc_hd__a211o_1
X_3033_ _1724_ VGND VGND VPWR VPWR _0078_ sky130_fd_sc_hd__buf_4
XFILLER_0_73_387 VGND VGND VPWR VPWR sky130_fd_sc_hd__decap_4
XFILLER_0_73_365 VGND VGND VPWR VPWR sky130_fd_sc_hd__fill_2
XFILLER_0_73_321 VGND VGND VPWR VPWR sky130_fd_sc_hd__decap_4
XFILLER_0_58_373 VGND VGND VPWR VPWR sky130_fd_sc_hd__decap_8
XFILLER_0_58_362 VGND VGND VPWR VPWR sky130_fd_sc_hd__fill_2
X_3935_ _1014_ _1016_ _1017_ VGND VGND VPWR VPWR _1019_ sky130_fd_sc_hd__or3b_1
XTAP_TAPCELL_ROW_21_316 VGND VPWR sky130_fd_sc_hd__tapvpwrvgnd_1
X_3866_ _1740_ _1741_ net113 _0898_ _1071_ VGND VGND VPWR VPWR _0945_ sky130_fd_sc_hd__o221ai_4
X_2817_ _1679_ VGND VGND VPWR VPWR _1922_ sky130_fd_sc_hd__clkbuf_4
X_2679_ net9 VGND VGND VPWR VPWR _1785_ sky130_fd_sc_hd__buf_4
X_2748_ _1618_ _1785_ _1852_ VGND VGND VPWR VPWR _1853_ sky130_fd_sc_hd__o21ai_4
XFILLER_0_41_240 VGND VGND VPWR VPWR sky130_fd_sc_hd__decap_4
X_3797_ _0835_ _0837_ _0839_ _0871_ VGND VGND VPWR VPWR _2060_ sky130_fd_sc_hd__a211o_1
XFILLER_0_5_164 VGND VGND VPWR VPWR sky130_fd_sc_hd__decap_4
XFILLER_0_5_197 VGND VGND VPWR VPWR sky130_fd_sc_hd__decap_8
XFILLER_0_14_421 VPWR VGND VPWR VGND sky130_ef_sc_hd__decap_12
XFILLER_0_49_362 VGND VGND VPWR VPWR sky130_fd_sc_hd__fill_1
XFILLER_0_64_321 VGND VGND VPWR VPWR sky130_fd_sc_hd__decap_8
XFILLER_0_32_295 VPWR VGND VPWR VGND sky130_ef_sc_hd__decap_12
XTAP_TAPCELL_ROW_35_419 VGND VPWR sky130_fd_sc_hd__tapvpwrvgnd_1
XFILLER_0_55_387 VGND VGND VPWR VPWR sky130_fd_sc_hd__decap_4
X_3720_ _1104_ _1815_ _1522_ VGND VGND VPWR VPWR _0789_ sky130_fd_sc_hd__a21oi_1
XFILLER_0_7_429 VGND VGND VPWR VPWR sky130_fd_sc_hd__decap_4
X_2533_ _1561_ _1630_ _1638_ VGND VGND VPWR VPWR _1639_ sky130_fd_sc_hd__a21bo_1
X_2602_ _1649_ _1581_ _1694_ _1635_ VGND VGND VPWR VPWR _1708_ sky130_fd_sc_hd__a31o_1
X_3582_ _0078_ _1598_ _0068_ _1726_ VGND VGND VPWR VPWR _0640_ sky130_fd_sc_hd__o31ai_2
X_3651_ _0311_ _0688_ _0714_ VGND VGND VPWR VPWR _0715_ sky130_fd_sc_hd__o21ai_1
XFILLER_0_23_273 VGND VGND VPWR VPWR sky130_fd_sc_hd__decap_6
X_2395_ _0460_ _0471_ VGND VGND VPWR VPWR _1501_ sky130_fd_sc_hd__nand2_4
X_4134_ _0417_ _1926_ _1666_ _1452_ _1230_ VGND VGND VPWR VPWR _1231_ sky130_fd_sc_hd__a221o_1
XFILLER_0_54_7 VGND VGND VPWR VPWR sky130_fd_sc_hd__fill_1
XFILLER_0_48_85 VPWR VGND VPWR VGND sky130_ef_sc_hd__decap_12
X_4203_ clknet_2_1__leaf_clk _2068_ net124 VGND VGND VPWR VPWR net85 sky130_fd_sc_hd__dfrtp_1
X_2464_ _1566_ VGND VGND VPWR VPWR _1570_ sky130_fd_sc_hd__buf_4
X_3016_ _0890_ _0059_ _0060_ _1797_ VGND VGND VPWR VPWR _0061_ sky130_fd_sc_hd__o22ai_4
XFILLER_0_64_62 VGND VGND VPWR VPWR sky130_fd_sc_hd__fill_1
X_4065_ _0540_ _0541_ _0151_ _1150_ _1156_ VGND VGND VPWR VPWR _1158_ sky130_fd_sc_hd__a2111oi_1
XFILLER_0_73_195 VGND VGND VPWR VPWR sky130_fd_sc_hd__fill_1
XFILLER_0_46_365 VGND VGND VPWR VPWR sky130_fd_sc_hd__fill_1
X_3849_ _0166_ _0597_ _2053_ VGND VGND VPWR VPWR _0927_ sky130_fd_sc_hd__mux2_1
X_3918_ net39 _1937_ _1446_ VGND VGND VPWR VPWR _1001_ sky130_fd_sc_hd__o21ai_1
Xfanout120 net121 VGND VGND VPWR VPWR net120 sky130_fd_sc_hd__clkbuf_4
XFILLER_0_14_251 VGND VGND VPWR VPWR sky130_fd_sc_hd__fill_1
XFILLER_0_69_413 VPWR VGND VPWR VGND sky130_ef_sc_hd__decap_12
XTAP_TAPCELL_ROW_57_588 VGND VPWR sky130_fd_sc_hd__tapvpwrvgnd_1
XFILLER_0_52_324 VPWR VGND VPWR VGND sky130_ef_sc_hd__decap_12
XTAP_TAPCELL_ROW_40_455 VGND VPWR sky130_fd_sc_hd__tapvpwrvgnd_1
XFILLER_0_20_243 VGND VGND VPWR VPWR sky130_fd_sc_hd__decap_8
X_2180_ net59 net27 VGND VGND VPWR VPWR _1286_ sky130_fd_sc_hd__nand2_2
XTAP_TAPCELL_ROW_48_522 VGND VPWR sky130_fd_sc_hd__tapvpwrvgnd_1
XFILLER_0_34_65 VGND VGND VPWR VPWR sky130_fd_sc_hd__fill_1
X_3703_ _1909_ _0596_ _0106_ _0769_ VGND VGND VPWR VPWR _0770_ sky130_fd_sc_hd__a211o_1
XFILLER_0_43_313 VGND VGND VPWR VPWR sky130_fd_sc_hd__decap_3
XFILLER_0_28_398 VGND VGND VPWR VPWR sky130_fd_sc_hd__fill_2
XFILLER_0_28_365 VGND VGND VPWR VPWR sky130_fd_sc_hd__fill_2
X_3634_ _1291_ _1682_ _0693_ _0694_ _0695_ VGND VGND VPWR VPWR _0696_ sky130_fd_sc_hd__o2111a_1
XFILLER_0_7_215 VGND VGND VPWR VPWR sky130_fd_sc_hd__decap_8
XFILLER_0_59_95 VGND VGND VPWR VPWR sky130_fd_sc_hd__decap_8
XFILLER_0_51_390 VGND VGND VPWR VPWR sky130_fd_sc_hd__fill_2
X_2447_ _1552_ VGND VGND VPWR VPWR _1553_ sky130_fd_sc_hd__clkbuf_4
X_2516_ _1411_ VGND VGND VPWR VPWR _1622_ sky130_fd_sc_hd__inv_2
X_3496_ _1514_ _1373_ _1375_ _0547_ VGND VGND VPWR VPWR _0548_ sky130_fd_sc_hd__a31o_1
X_3565_ _1756_ _0620_ _0621_ VGND VGND VPWR VPWR _0623_ sky130_fd_sc_hd__a21o_1
XFILLER_0_11_298 VGND VGND VPWR VPWR sky130_fd_sc_hd__decap_8
X_2378_ _1450_ _1452_ _1477_ _1483_ VGND VGND VPWR VPWR _1484_ sky130_fd_sc_hd__or4_2
X_4117_ _1209_ _1211_ _1212_ VGND VGND VPWR VPWR _1213_ sky130_fd_sc_hd__and3_1
XFILLER_0_45_3 VGND VGND VPWR VPWR sky130_fd_sc_hd__decap_8
X_4048_ _1789_ _1441_ _0478_ VGND VGND VPWR VPWR _1140_ sky130_fd_sc_hd__o21ai_1
XPHY_EDGE_ROW_49_Left_123 VGND VGND VPWR VPWR sky130_fd_sc_hd__decap_3
XFILLER_0_19_365 VPWR VGND VPWR VGND sky130_ef_sc_hd__decap_12
XFILLER_0_19_332 VGND VGND VPWR VPWR sky130_fd_sc_hd__decap_4
XFILLER_0_19_321 VGND VGND VPWR VPWR sky130_fd_sc_hd__decap_3
XFILLER_0_61_132 VGND VGND VPWR VPWR sky130_fd_sc_hd__decap_8
XPHY_EDGE_ROW_58_Left_132 VGND VGND VPWR VPWR sky130_fd_sc_hd__decap_3
XFILLER_0_57_427 VGND VGND VPWR VPWR sky130_fd_sc_hd__decap_8
XPHY_EDGE_ROW_67_Left_141 VGND VGND VPWR VPWR sky130_fd_sc_hd__decap_3
XFILLER_0_25_313 VPWR VGND VPWR VGND sky130_ef_sc_hd__decap_12
Xmax_cap117 _1668_ VGND VGND VPWR VPWR net117 sky130_fd_sc_hd__buf_2
XFILLER_0_40_316 VGND VGND VPWR VPWR sky130_fd_sc_hd__decap_4
XFILLER_0_29_32 VGND VGND VPWR VPWR sky130_fd_sc_hd__decap_3
X_2301_ net39 _0986_ VGND VGND VPWR VPWR _1407_ sky130_fd_sc_hd__and2b_1
X_3350_ _0375_ _1970_ VGND VGND VPWR VPWR _0390_ sky130_fd_sc_hd__nand2_1
X_2232_ net46 VGND VGND VPWR VPWR _1338_ sky130_fd_sc_hd__clkbuf_4
XFILLER_0_45_53 VGND VGND VPWR VPWR sky130_fd_sc_hd__decap_3
XFILLER_0_29_65 VGND VGND VPWR VPWR sky130_fd_sc_hd__fill_2
X_2163_ net32 net64 VGND VGND VPWR VPWR _1125_ sky130_fd_sc_hd__nor2b_2
X_3281_ _1983_ _1468_ _1619_ VGND VGND VPWR VPWR _0319_ sky130_fd_sc_hd__o21ai_1
X_2094_ net46 net14 VGND VGND VPWR VPWR _0384_ sky130_fd_sc_hd__or2_2
XTAP_TAPCELL_ROW_51_539 VGND VPWR sky130_fd_sc_hd__tapvpwrvgnd_1
XFILLER_0_0_44 VPWR VGND VPWR VGND sky130_ef_sc_hd__decap_12
XFILLER_0_0_77 VGND VGND VPWR VPWR sky130_fd_sc_hd__decap_3
XFILLER_0_0_99 VGND VGND VPWR VPWR sky130_fd_sc_hd__fill_2
XTAP_TAPCELL_ROW_16_282 VGND VPWR sky130_fd_sc_hd__tapvpwrvgnd_1
X_2996_ _2048_ _1945_ _1805_ _1423_ _1577_ _1587_ VGND VGND VPWR VPWR _0042_ sky130_fd_sc_hd__mux4_1
XFILLER_0_43_132 VGND VGND VPWR VPWR sky130_fd_sc_hd__decap_3
X_3617_ _0661_ _0671_ _0677_ _0678_ VGND VGND VPWR VPWR _0679_ sky130_fd_sc_hd__and4b_1
X_3548_ _0603_ _0208_ VGND VGND VPWR VPWR _0604_ sky130_fd_sc_hd__nand2_1
X_3479_ _0529_ _0107_ _0147_ VGND VGND VPWR VPWR _0530_ sky130_fd_sc_hd__and3_1
XTAP_TAPCELL_ROW_8_217 VGND VPWR sky130_fd_sc_hd__tapvpwrvgnd_1
XTAP_TAPCELL_ROW_67_661 VGND VPWR sky130_fd_sc_hd__tapvpwrvgnd_1
XFILLER_0_34_187 VGND VGND VPWR VPWR sky130_fd_sc_hd__decap_8
XFILLER_0_34_176 VGND VGND VPWR VPWR sky130_fd_sc_hd__decap_6
XFILLER_0_30_382 VGND VGND VPWR VPWR sky130_fd_sc_hd__fill_2
XFILLER_0_15_390 VGND VGND VPWR VPWR sky130_fd_sc_hd__fill_2
XFILLER_0_57_202 VGND VGND VPWR VPWR sky130_fd_sc_hd__decap_8
X_2850_ _1561_ VGND VGND VPWR VPWR _1954_ sky130_fd_sc_hd__clkbuf_4
XFILLER_0_15_89 VGND VGND VPWR VPWR sky130_fd_sc_hd__decap_4
XFILLER_0_72_238 VPWR VGND VPWR VGND sky130_ef_sc_hd__decap_12
X_2781_ _1806_ _1673_ _1323_ _1671_ _1885_ VGND VGND VPWR VPWR _1886_ sky130_fd_sc_hd__o221a_1
XFILLER_0_31_55 VGND VGND VPWR VPWR sky130_fd_sc_hd__fill_1
XFILLER_0_25_110 VGND VGND VPWR VPWR sky130_fd_sc_hd__fill_2
X_3333_ _0065_ _0369_ _1707_ _0370_ VGND VGND VPWR VPWR _0371_ sky130_fd_sc_hd__a211o_1
X_3264_ _0299_ _0300_ _0301_ _0302_ VGND VGND VPWR VPWR _0303_ sky130_fd_sc_hd__or4_1
XFILLER_0_21_393 VGND VGND VPWR VPWR sky130_fd_sc_hd__fill_2
XPHY_EDGE_ROW_7_Right_7 VGND VGND VPWR VPWR sky130_fd_sc_hd__decap_3
X_3402_ _1890_ _1469_ _0074_ _1619_ VGND VGND VPWR VPWR _0446_ sky130_fd_sc_hd__o211a_1
X_3195_ _0236_ _0237_ VGND VGND VPWR VPWR _0238_ sky130_fd_sc_hd__nand2_1
X_2146_ net51 net19 VGND VGND VPWR VPWR _0943_ sky130_fd_sc_hd__and2b_1
X_2215_ net18 net50 VGND VGND VPWR VPWR _1321_ sky130_fd_sc_hd__and2b_1
XTAP_TAPCELL_ROW_64_642 VGND VPWR sky130_fd_sc_hd__tapvpwrvgnd_1
XFILLER_0_63_216 VGND VGND VPWR VPWR sky130_fd_sc_hd__decap_8
XFILLER_0_63_205 VGND VGND VPWR VPWR sky130_fd_sc_hd__decap_6
X_2979_ _1851_ _1849_ _1658_ VGND VGND VPWR VPWR _0025_ sky130_fd_sc_hd__mux2_1
XFILLER_0_8_365 VGND VGND VPWR VPWR sky130_fd_sc_hd__fill_1
XFILLER_0_39_268 VPWR VGND VPWR VGND sky130_ef_sc_hd__decap_12
XFILLER_0_54_249 VGND VGND VPWR VPWR sky130_fd_sc_hd__decap_3
XFILLER_0_22_124 VGND VGND VPWR VPWR sky130_fd_sc_hd__fill_2
XTAP_TAPCELL_ROW_10_233 VGND VPWR sky130_fd_sc_hd__tapvpwrvgnd_1
X_2902_ _1876_ _2005_ VGND VGND VPWR VPWR _2006_ sky130_fd_sc_hd__nand2_1
X_3882_ _0961_ _0243_ VGND VGND VPWR VPWR _0962_ sky130_fd_sc_hd__nand2_1
X_3951_ _1477_ _1489_ _1009_ VGND VGND VPWR VPWR _1036_ sky130_fd_sc_hd__a21oi_1
X_2833_ _1937_ VGND VGND VPWR VPWR _1938_ sky130_fd_sc_hd__clkbuf_4
XFILLER_0_9_129 VPWR VGND VPWR VGND sky130_ef_sc_hd__decap_12
X_2764_ _1357_ _1354_ _1575_ VGND VGND VPWR VPWR _1869_ sky130_fd_sc_hd__mux2_4
XFILLER_0_53_271 VGND VGND VPWR VPWR sky130_fd_sc_hd__fill_2
XFILLER_0_5_335 VGND VGND VPWR VPWR sky130_fd_sc_hd__fill_1
XFILLER_0_6_21 VGND VGND VPWR VPWR sky130_fd_sc_hd__fill_1
XFILLER_0_13_113 VGND VGND VPWR VPWR sky130_fd_sc_hd__decap_8
XFILLER_0_13_135 VGND VGND VPWR VPWR sky130_fd_sc_hd__fill_1
X_2695_ _1800_ VGND VGND VPWR VPWR _1801_ sky130_fd_sc_hd__buf_4
X_3247_ _0237_ _0239_ _2024_ _1355_ VGND VGND VPWR VPWR _0288_ sky130_fd_sc_hd__o2bb2ai_1
X_3316_ _1629_ _1374_ _1635_ VGND VGND VPWR VPWR _0354_ sky130_fd_sc_hd__and3_1
XFILLER_0_6_98 VGND VGND VPWR VPWR sky130_fd_sc_hd__decap_8
X_2129_ _0751_ VGND VGND VPWR VPWR _0762_ sky130_fd_sc_hd__buf_2
X_3178_ _0216_ _0195_ _0220_ _1608_ VGND VGND VPWR VPWR _0221_ sky130_fd_sc_hd__a31o_1
XFILLER_0_51_219 VGND VGND VPWR VPWR sky130_fd_sc_hd__decap_4
XFILLER_0_36_205 VGND VGND VPWR VPWR sky130_fd_sc_hd__decap_6
XTAP_TAPCELL_ROW_24_336 VGND VPWR sky130_fd_sc_hd__tapvpwrvgnd_1
X_2480_ _1585_ VGND VGND VPWR VPWR _1586_ sky130_fd_sc_hd__buf_4
Xoutput108 net108 VGND VGND VPWR VPWR zero sky130_fd_sc_hd__buf_2
X_4150_ _0427_ _1341_ VGND VGND VPWR VPWR _1248_ sky130_fd_sc_hd__or2_1
X_3101_ _1960_ _0141_ _0144_ VGND VGND VPWR VPWR _0145_ sky130_fd_sc_hd__a21o_1
Xoutput90 net90 VGND VGND VPWR VPWR result[23] sky130_fd_sc_hd__buf_2
X_4081_ _0162_ _0810_ _0165_ _0731_ VGND VGND VPWR VPWR _1174_ sky130_fd_sc_hd__o22a_1
XFILLER_0_37_32 VGND VGND VPWR VPWR sky130_fd_sc_hd__decap_3
XFILLER_0_10_138 VGND VGND VPWR VPWR sky130_fd_sc_hd__fill_2
XFILLER_0_10_149 VGND VGND VPWR VPWR sky130_fd_sc_hd__decap_6
X_3032_ _0074_ _0075_ _1900_ _0076_ VGND VGND VPWR VPWR _0077_ sky130_fd_sc_hd__o211a_1
XFILLER_0_73_399 VGND VGND VPWR VPWR sky130_fd_sc_hd__decap_3
XFILLER_0_58_396 VGND VGND VPWR VPWR sky130_fd_sc_hd__fill_1
X_2816_ _1916_ _1920_ VGND VGND VPWR VPWR _1921_ sky130_fd_sc_hd__nand2_1
X_3934_ _1930_ _0611_ _1009_ _0092_ VGND VGND VPWR VPWR _1017_ sky130_fd_sc_hd__o22a_1
X_3865_ _0940_ _1553_ _0942_ _1435_ VGND VGND VPWR VPWR _0944_ sky130_fd_sc_hd__and4b_1
XTAP_TAPCELL_ROW_21_317 VGND VPWR sky130_fd_sc_hd__tapvpwrvgnd_1
XFILLER_0_5_110 VGND VGND VPWR VPWR sky130_fd_sc_hd__fill_2
XFILLER_0_14_400 VPWR VGND VPWR VGND sky130_ef_sc_hd__decap_12
X_3796_ _0842_ _0845_ _0849_ _0870_ VGND VGND VPWR VPWR _0871_ sky130_fd_sc_hd__nand4_1
X_2678_ net42 _1481_ VGND VGND VPWR VPWR _1784_ sky130_fd_sc_hd__nand2_1
X_2747_ net8 _1571_ VGND VGND VPWR VPWR _1852_ sky130_fd_sc_hd__or2b_2
XFILLER_0_1_393 VPWR VGND VPWR VGND sky130_ef_sc_hd__decap_12
XFILLER_0_1_371 VPWR VGND VPWR VGND sky130_ef_sc_hd__decap_12
XFILLER_0_14_433 VGND VGND VPWR VPWR sky130_fd_sc_hd__fill_1
XPHY_EDGE_ROW_30_Left_104 VGND VGND VPWR VPWR sky130_fd_sc_hd__decap_3
X_3650_ _0690_ _0698_ _0710_ _0713_ VGND VGND VPWR VPWR _0714_ sky130_fd_sc_hd__and4b_1
XFILLER_0_23_78 VGND VGND VPWR VPWR sky130_fd_sc_hd__fill_2
X_3581_ _0638_ _2005_ _1731_ VGND VGND VPWR VPWR _0639_ sky130_fd_sc_hd__mux2_1
X_2532_ _1583_ _1560_ _1631_ _1637_ VGND VGND VPWR VPWR _1638_ sky130_fd_sc_hd__o31a_1
X_4202_ clknet_2_1__leaf_clk _2067_ net124 VGND VGND VPWR VPWR net84 sky130_fd_sc_hd__dfrtp_1
X_2601_ _1706_ VGND VGND VPWR VPWR _1707_ sky130_fd_sc_hd__clkbuf_4
XFILLER_0_2_102 VGND VGND VPWR VPWR sky130_fd_sc_hd__fill_2
XFILLER_0_11_403 VGND VGND VPWR VPWR sky130_fd_sc_hd__fill_2
X_2463_ _1567_ _1398_ _1568_ VGND VGND VPWR VPWR _1569_ sky130_fd_sc_hd__o21a_1
X_3015_ _0911_ _1323_ _1496_ _0965_ VGND VGND VPWR VPWR _0060_ sky130_fd_sc_hd__or4_1
X_4133_ _1452_ _2017_ _1679_ _0427_ VGND VGND VPWR VPWR _1230_ sky130_fd_sc_hd__a2bb2o_1
X_4064_ _1152_ _1155_ VGND VGND VPWR VPWR _1156_ sky130_fd_sc_hd__nand2_1
X_2394_ _1497_ _0546_ _1328_ _1499_ _0514_ VGND VGND VPWR VPWR _1500_ sky130_fd_sc_hd__o221a_2
XFILLER_0_3_22 VPWR VGND VPWR VGND sky130_ef_sc_hd__decap_12
XFILLER_0_46_333 VPWR VGND VPWR VGND sky130_ef_sc_hd__decap_12
XFILLER_0_73_141 VGND VGND VPWR VPWR sky130_fd_sc_hd__decap_8
XFILLER_0_61_314 VGND VGND VPWR VPWR sky130_fd_sc_hd__fill_1
X_3779_ _0433_ _0023_ _0851_ VGND VGND VPWR VPWR _0852_ sky130_fd_sc_hd__o21ai_1
X_3848_ _0164_ _0413_ _2004_ _0919_ _0925_ VGND VGND VPWR VPWR _0926_ sky130_fd_sc_hd__o221a_1
X_3917_ _1474_ _1939_ VGND VGND VPWR VPWR _1000_ sky130_fd_sc_hd__nor2_1
Xfanout121 net124 VGND VGND VPWR VPWR net121 sky130_fd_sc_hd__clkbuf_4
XFILLER_0_69_425 VPWR VGND VPWR VGND sky130_ef_sc_hd__decap_12
XTAP_TAPCELL_ROW_57_589 VGND VPWR sky130_fd_sc_hd__tapvpwrvgnd_1
XFILLER_0_56_119 VPWR VGND VPWR VGND sky130_ef_sc_hd__decap_12
XFILLER_0_52_336 VPWR VGND VPWR VGND sky130_ef_sc_hd__decap_12
XFILLER_0_52_314 VGND VGND VPWR VPWR sky130_fd_sc_hd__fill_2
XFILLER_0_52_303 VGND VGND VPWR VPWR sky130_fd_sc_hd__decap_4
XFILLER_0_49_182 VGND VGND VPWR VPWR sky130_fd_sc_hd__fill_1
XFILLER_0_49_160 VGND VGND VPWR VPWR sky130_fd_sc_hd__decap_8
XTAP_TAPCELL_ROW_40_456 VGND VPWR sky130_fd_sc_hd__tapvpwrvgnd_1
XFILLER_0_37_344 VGND VGND VPWR VPWR sky130_fd_sc_hd__decap_8
XFILLER_0_18_34 VGND VGND VPWR VPWR sky130_fd_sc_hd__decap_6
X_3633_ _1809_ _1808_ _1762_ _0347_ VGND VGND VPWR VPWR _0695_ sky130_fd_sc_hd__or4_1
XFILLER_0_7_238 VGND VGND VPWR VPWR sky130_fd_sc_hd__decap_3
X_3702_ _1967_ _0388_ _0391_ _2053_ VGND VGND VPWR VPWR _0769_ sky130_fd_sc_hd__o211a_1
XFILLER_0_59_41 VGND VGND VPWR VPWR sky130_fd_sc_hd__fill_1
X_2446_ net65 net66 VGND VGND VPWR VPWR _1552_ sky130_fd_sc_hd__nor2_1
X_2515_ _1563_ VGND VGND VPWR VPWR _1621_ sky130_fd_sc_hd__buf_4
X_3495_ _1285_ _1286_ VGND VGND VPWR VPWR _0547_ sky130_fd_sc_hd__and2_1
X_3564_ _1756_ _0620_ _1828_ VGND VGND VPWR VPWR _0621_ sky130_fd_sc_hd__o21ai_1
X_2377_ _1478_ _1480_ _1482_ VGND VGND VPWR VPWR _1483_ sky130_fd_sc_hd__or3_1
X_4116_ _1338_ _1177_ _1502_ _1145_ VGND VGND VPWR VPWR _1212_ sky130_fd_sc_hd__o211ai_2
X_4047_ _2032_ _2033_ net43 VGND VGND VPWR VPWR _1139_ sky130_fd_sc_hd__a21oi_1
XFILLER_0_38_3 VGND VGND VPWR VPWR sky130_fd_sc_hd__decap_6
XFILLER_0_46_185 VGND VGND VPWR VPWR sky130_fd_sc_hd__fill_2
XFILLER_0_46_141 VGND VGND VPWR VPWR sky130_fd_sc_hd__fill_1
XFILLER_0_19_377 VGND VGND VPWR VPWR sky130_fd_sc_hd__fill_2
XFILLER_0_6_260 VGND VGND VPWR VPWR sky130_fd_sc_hd__decap_8
XFILLER_0_6_293 VGND VGND VPWR VPWR sky130_fd_sc_hd__decap_3
XFILLER_0_69_233 VGND VGND VPWR VPWR sky130_fd_sc_hd__decap_3
XTAP_TAPCELL_ROW_2_170 VGND VPWR sky130_fd_sc_hd__tapvpwrvgnd_1
XFILLER_0_52_177 VGND VGND VPWR VPWR sky130_fd_sc_hd__decap_6
XFILLER_0_52_100 VGND VGND VPWR VPWR sky130_fd_sc_hd__fill_1
XFILLER_0_37_185 VGND VGND VPWR VPWR sky130_fd_sc_hd__decap_4
XFILLER_0_25_325 VGND VGND VPWR VPWR sky130_fd_sc_hd__decap_8
X_2231_ net13 VGND VGND VPWR VPWR _1337_ sky130_fd_sc_hd__inv_2
Xmax_cap118 _1612_ VGND VGND VPWR VPWR net118 sky130_fd_sc_hd__clkbuf_2
XFILLER_0_33_391 VGND VGND VPWR VPWR sky130_fd_sc_hd__fill_1
XFILLER_0_29_55 VGND VGND VPWR VPWR sky130_fd_sc_hd__fill_1
XFILLER_0_29_11 VGND VGND VPWR VPWR sky130_fd_sc_hd__fill_2
X_3280_ _1728_ _1729_ _0317_ VGND VGND VPWR VPWR _0318_ sky130_fd_sc_hd__a21o_1
X_2300_ net6 net38 VGND VGND VPWR VPWR _1406_ sky130_fd_sc_hd__or2b_1
X_2093_ net45 net13 VGND VGND VPWR VPWR _0373_ sky130_fd_sc_hd__and2_1
XFILLER_0_45_21 VPWR VGND VPWR VGND sky130_ef_sc_hd__decap_12
X_2162_ _1093_ _1104_ VGND VGND VPWR VPWR _1114_ sky130_fd_sc_hd__nand2_2
XFILLER_0_61_86 VGND VGND VPWR VPWR sky130_fd_sc_hd__decap_3
XFILLER_0_61_31 VGND VGND VPWR VPWR sky130_fd_sc_hd__decap_4
X_2995_ _1559_ _0022_ VGND VGND VPWR VPWR _0041_ sky130_fd_sc_hd__nor2_2
XFILLER_0_28_141 VGND VGND VPWR VPWR sky130_fd_sc_hd__fill_1
XFILLER_0_0_23 VGND VGND VPWR VPWR sky130_fd_sc_hd__decap_4
X_3547_ _1955_ _0031_ _1917_ _0602_ VGND VGND VPWR VPWR _0603_ sky130_fd_sc_hd__a31o_1
X_3616_ _0142_ _1557_ _0402_ _0205_ VGND VGND VPWR VPWR _0678_ sky130_fd_sc_hd__or4_1
XTAP_TAPCELL_ROW_8_218 VGND VPWR sky130_fd_sc_hd__tapvpwrvgnd_1
XFILLER_0_9_98 VPWR VGND VPWR VGND sky130_ef_sc_hd__decap_12
X_3478_ _0020_ _0528_ _0021_ _0033_ _1560_ _1955_ VGND VGND VPWR VPWR _0529_ sky130_fd_sc_hd__mux4_2
X_2429_ _1526_ _1405_ _1534_ VGND VGND VPWR VPWR _1535_ sky130_fd_sc_hd__a21oi_4
XTAP_TAPCELL_ROW_67_662 VGND VPWR sky130_fd_sc_hd__tapvpwrvgnd_1
XFILLER_0_66_269 VGND VGND VPWR VPWR sky130_fd_sc_hd__fill_1
XFILLER_0_34_133 VGND VGND VPWR VPWR sky130_fd_sc_hd__fill_1
XFILLER_0_19_174 VPWR VGND VPWR VGND sky130_ef_sc_hd__decap_12
XFILLER_0_57_225 VGND VGND VPWR VPWR sky130_fd_sc_hd__decap_6
XFILLER_0_15_57 VPWR VGND VPWR VGND sky130_ef_sc_hd__decap_12
XFILLER_0_53_420 VPWR VGND VPWR VGND sky130_ef_sc_hd__decap_12
X_2780_ _1884_ _1675_ _0826_ VGND VGND VPWR VPWR _1885_ sky130_fd_sc_hd__mux2_1
XFILLER_0_25_166 VGND VGND VPWR VPWR sky130_fd_sc_hd__fill_2
X_3401_ _0242_ _0432_ _0435_ _0440_ _0444_ VGND VGND VPWR VPWR _0445_ sky130_fd_sc_hd__a221o_1
XTAP_TAPCELL_ROW_13_253 VGND VPWR sky130_fd_sc_hd__tapvpwrvgnd_1
X_3194_ _0197_ _0200_ _0234_ _0235_ VGND VGND VPWR VPWR _0237_ sky130_fd_sc_hd__o22ai_4
X_2214_ _0804_ _1319_ VGND VGND VPWR VPWR _1320_ sky130_fd_sc_hd__nor2_1
X_3332_ _1890_ _1874_ _1642_ _1643_ _1883_ VGND VGND VPWR VPWR _0370_ sky130_fd_sc_hd__o311a_1
X_3263_ net79 net78 net81 net80 VGND VGND VPWR VPWR _0302_ sky130_fd_sc_hd__or4_1
XFILLER_0_0_244 VGND VGND VPWR VPWR sky130_fd_sc_hd__decap_8
XFILLER_0_0_233 VGND VGND VPWR VPWR sky130_fd_sc_hd__fill_1
XFILLER_0_72_85 VPWR VGND VPWR VGND sky130_ef_sc_hd__decap_12
XFILLER_0_72_41 VPWR VGND VPWR VGND sky130_ef_sc_hd__decap_12
X_2145_ net19 _0922_ VGND VGND VPWR VPWR _0933_ sky130_fd_sc_hd__nor2_1
XFILLER_0_48_247 VGND VGND VPWR VPWR sky130_fd_sc_hd__decap_4
X_2978_ _1647_ VGND VGND VPWR VPWR _0024_ sky130_fd_sc_hd__clkbuf_4
XFILLER_0_8_344 VGND VGND VPWR VPWR sky130_fd_sc_hd__fill_1
XFILLER_0_31_169 VGND VGND VPWR VPWR sky130_fd_sc_hd__fill_1
XFILLER_0_31_125 VGND VGND VPWR VPWR sky130_fd_sc_hd__fill_1
XFILLER_0_12_361 VGND VGND VPWR VPWR sky130_fd_sc_hd__decap_3
XFILLER_0_54_206 VGND VGND VPWR VPWR sky130_fd_sc_hd__decap_8
XFILLER_0_62_272 VGND VGND VPWR VPWR sky130_fd_sc_hd__fill_2
XTAP_TAPCELL_ROW_10_234 VGND VPWR sky130_fd_sc_hd__tapvpwrvgnd_1
X_3950_ _1025_ _1026_ _1027_ _1028_ _1034_ VGND VGND VPWR VPWR _1035_ sky130_fd_sc_hd__o221a_1
X_2901_ _1945_ net21 net22 _1347_ _1632_ _1570_ VGND VGND VPWR VPWR _2005_ sky130_fd_sc_hd__mux4_1
XTAP_TAPCELL_ROW_61_613 VGND VPWR sky130_fd_sc_hd__tapvpwrvgnd_1
X_2763_ _1867_ _1636_ VGND VGND VPWR VPWR _1868_ sky130_fd_sc_hd__nand2_2
X_3881_ _0107_ _0207_ _0083_ _0193_ _0960_ VGND VGND VPWR VPWR _0961_ sky130_fd_sc_hd__o221ai_1
X_2832_ _1443_ VGND VGND VPWR VPWR _1937_ sky130_fd_sc_hd__clkbuf_4
XFILLER_0_53_261 VGND VGND VPWR VPWR sky130_fd_sc_hd__fill_2
XFILLER_0_41_412 VPWR VGND VPWR VGND sky130_ef_sc_hd__decap_12
XFILLER_0_41_401 VGND VGND VPWR VPWR sky130_fd_sc_hd__fill_1
X_2694_ _1436_ _1432_ _1538_ _1434_ VGND VGND VPWR VPWR _1800_ sky130_fd_sc_hd__and4b_2
XFILLER_0_5_369 VGND VGND VPWR VPWR sky130_fd_sc_hd__fill_1
X_3246_ _0676_ _1354_ _0237_ VGND VGND VPWR VPWR _0287_ sky130_fd_sc_hd__o21ai_1
X_3177_ _0070_ _0217_ _0219_ VGND VGND VPWR VPWR _0220_ sky130_fd_sc_hd__o21ai_1
X_3315_ _1537_ _1437_ _1433_ _1670_ VGND VGND VPWR VPWR _0353_ sky130_fd_sc_hd__and4bb_2
XFILLER_0_20_3 VGND VGND VPWR VPWR sky130_fd_sc_hd__decap_8
X_2128_ net53 net21 VGND VGND VPWR VPWR _0751_ sky130_fd_sc_hd__and2_1
XFILLER_0_68_309 VPWR VGND VPWR VGND sky130_ef_sc_hd__decap_12
XTAP_TAPCELL_ROW_24_337 VGND VPWR sky130_fd_sc_hd__tapvpwrvgnd_1
XFILLER_0_36_239 VPWR VGND VPWR VGND sky130_ef_sc_hd__decap_12
XFILLER_0_27_217 VGND VGND VPWR VPWR sky130_fd_sc_hd__decap_6
XFILLER_0_12_25 VGND VGND VPWR VPWR sky130_fd_sc_hd__decap_3
Xoutput91 net91 VGND VGND VPWR VPWR result[24] sky130_fd_sc_hd__buf_2
X_3100_ _0142_ _0143_ _1557_ VGND VGND VPWR VPWR _0144_ sky130_fd_sc_hd__a21o_1
X_4080_ _1165_ _1167_ _1170_ _1173_ VGND VGND VPWR VPWR _2070_ sky130_fd_sc_hd__nand4_1
X_3031_ _1728_ _1729_ _1981_ VGND VGND VPWR VPWR _0076_ sky130_fd_sc_hd__a21o_1
XFILLER_0_37_11 VGND VGND VPWR VPWR sky130_fd_sc_hd__fill_2
Xoutput80 net80 VGND VGND VPWR VPWR result[14] sky130_fd_sc_hd__buf_2
XFILLER_0_73_301 VGND VGND VPWR VPWR sky130_fd_sc_hd__decap_3
X_3933_ _1009_ _1928_ _1923_ net40 _1015_ VGND VGND VPWR VPWR _1016_ sky130_fd_sc_hd__a221o_1
X_2815_ _1842_ _1919_ VGND VGND VPWR VPWR _1920_ sky130_fd_sc_hd__and2_1
X_3795_ _0854_ _0862_ _0864_ _0868_ VGND VGND VPWR VPWR _0870_ sky130_fd_sc_hd__and4_1
X_3864_ _0941_ _1486_ _0939_ VGND VGND VPWR VPWR _0942_ sky130_fd_sc_hd__a21o_1
XFILLER_0_26_261 VGND VGND VPWR VPWR sky130_fd_sc_hd__fill_1
X_2746_ _1621_ _0986_ _1850_ VGND VGND VPWR VPWR _1851_ sky130_fd_sc_hd__o21ai_2
XTAP_TAPCELL_ROW_21_318 VGND VPWR sky130_fd_sc_hd__tapvpwrvgnd_1
XFILLER_0_14_412 VGND VGND VPWR VPWR sky130_fd_sc_hd__decap_8
XFILLER_0_68_3 VPWR VGND VPWR VGND sky130_ef_sc_hd__decap_12
X_2677_ net43 _1326_ VGND VGND VPWR VPWR _1783_ sky130_fd_sc_hd__nor2_1
XFILLER_0_41_297 VGND VGND VPWR VPWR sky130_fd_sc_hd__fill_1
XFILLER_0_1_383 VGND VGND VPWR VPWR sky130_fd_sc_hd__decap_8
XFILLER_0_68_106 VGND VGND VPWR VPWR sky130_fd_sc_hd__decap_8
X_3229_ _1659_ _1892_ _0078_ _0013_ _0014_ VGND VGND VPWR VPWR _0271_ sky130_fd_sc_hd__o221ai_2
XFILLER_0_68_139 VGND VGND VPWR VPWR sky130_fd_sc_hd__fill_1
XFILLER_0_32_253 VPWR VGND VPWR VGND sky130_ef_sc_hd__decap_12
XFILLER_0_17_272 VGND VGND VPWR VPWR sky130_fd_sc_hd__decap_8
X_3580_ _1451_ _1423_ _1805_ _1449_ _1894_ _1983_ VGND VGND VPWR VPWR _0638_ sky130_fd_sc_hd__mux4_1
X_2600_ _1647_ _1651_ VGND VGND VPWR VPWR _1706_ sky130_fd_sc_hd__or2_4
XFILLER_0_23_57 VGND VGND VPWR VPWR sky130_fd_sc_hd__decap_8
X_2531_ _1551_ _1555_ _1633_ _1634_ _1636_ VGND VGND VPWR VPWR _1637_ sky130_fd_sc_hd__o221a_1
X_4201_ clknet_2_1__leaf_clk _2066_ net121 VGND VGND VPWR VPWR net83 sky130_fd_sc_hd__dfrtp_1
X_2393_ _1332_ _1498_ _1329_ VGND VGND VPWR VPWR _1499_ sky130_fd_sc_hd__a21o_1
X_2462_ _1566_ _1453_ VGND VGND VPWR VPWR _1568_ sky130_fd_sc_hd__nand2_1
X_3014_ _0965_ _2035_ _2011_ _0901_ VGND VGND VPWR VPWR _0059_ sky130_fd_sc_hd__o211a_1
XFILLER_0_64_42 VGND VGND VPWR VPWR sky130_fd_sc_hd__decap_8
X_4132_ _0417_ _1930_ _0559_ _1227_ _1228_ VGND VGND VPWR VPWR _1229_ sky130_fd_sc_hd__o2111ai_2
X_4063_ _1336_ _1480_ _1682_ _1154_ VGND VGND VPWR VPWR _1155_ sky130_fd_sc_hd__a31o_1
XFILLER_0_3_34 VGND VGND VPWR VPWR sky130_fd_sc_hd__decap_8
XTAP_TAPCELL_ROW_34_410 VGND VPWR sky130_fd_sc_hd__tapvpwrvgnd_1
X_3916_ net39 _1431_ _0998_ VGND VGND VPWR VPWR _0999_ sky130_fd_sc_hd__o21ai_1
XFILLER_0_73_197 VPWR VGND VPWR VGND sky130_ef_sc_hd__decap_12
XFILLER_0_73_175 VGND VGND VPWR VPWR sky130_fd_sc_hd__decap_8
XFILLER_0_61_337 VGND VGND VPWR VPWR sky130_fd_sc_hd__fill_2
X_3778_ _1591_ _0499_ _0037_ VGND VGND VPWR VPWR _0851_ sky130_fd_sc_hd__o21a_1
X_2729_ _1618_ _1461_ VGND VGND VPWR VPWR _1834_ sky130_fd_sc_hd__nand2_1
XFILLER_0_14_231 VGND VGND VPWR VPWR sky130_fd_sc_hd__decap_8
XFILLER_0_14_253 VGND VGND VPWR VPWR sky130_fd_sc_hd__decap_6
X_3847_ _1471_ _0920_ _0924_ VGND VGND VPWR VPWR _0925_ sky130_fd_sc_hd__o21a_1
Xfanout122 net123 VGND VGND VPWR VPWR net122 sky130_fd_sc_hd__clkbuf_4
XPHY_EDGE_ROW_29_Right_29 VGND VGND VPWR VPWR sky130_fd_sc_hd__decap_3
XFILLER_0_52_348 VGND VGND VPWR VPWR sky130_fd_sc_hd__fill_1
XTAP_TAPCELL_ROW_40_457 VGND VPWR sky130_fd_sc_hd__tapvpwrvgnd_1
XPHY_EDGE_ROW_38_Right_38 VGND VGND VPWR VPWR sky130_fd_sc_hd__decap_3
XFILLER_0_37_301 VGND VGND VPWR VPWR sky130_fd_sc_hd__decap_8
XFILLER_0_20_289 VGND VGND VPWR VPWR sky130_fd_sc_hd__decap_6
XPHY_EDGE_ROW_47_Right_47 VGND VGND VPWR VPWR sky130_fd_sc_hd__decap_3
XPHY_EDGE_ROW_25_Left_99 VGND VGND VPWR VPWR sky130_fd_sc_hd__decap_3
XPHY_EDGE_ROW_56_Right_56 VGND VGND VPWR VPWR sky130_fd_sc_hd__decap_3
XFILLER_0_28_334 VGND VGND VPWR VPWR sky130_fd_sc_hd__decap_8
XFILLER_0_70_145 VGND VGND VPWR VPWR sky130_fd_sc_hd__fill_1
XFILLER_0_50_99 VGND VGND VPWR VPWR sky130_fd_sc_hd__fill_1
XFILLER_0_50_55 VGND VGND VPWR VPWR sky130_fd_sc_hd__decap_3
XFILLER_0_43_337 VPWR VGND VPWR VGND sky130_ef_sc_hd__decap_12
X_3701_ _0764_ _0426_ _0478_ _0767_ VGND VGND VPWR VPWR _0768_ sky130_fd_sc_hd__o211a_1
X_3632_ _1674_ _0615_ _1454_ VGND VGND VPWR VPWR _0694_ sky130_fd_sc_hd__mux2_1
X_3563_ _1286_ _0549_ VGND VGND VPWR VPWR _0620_ sky130_fd_sc_hd__nand2_1
XPHY_EDGE_ROW_65_Right_65 VGND VGND VPWR VPWR sky130_fd_sc_hd__decap_3
X_4115_ _1338_ _1177_ _1792_ VGND VGND VPWR VPWR _1211_ sky130_fd_sc_hd__o21ai_1
X_2376_ _1326_ _1481_ net9 _1330_ VGND VGND VPWR VPWR _1482_ sky130_fd_sc_hd__or4_2
X_2445_ _1550_ VGND VGND VPWR VPWR _1551_ sky130_fd_sc_hd__buf_4
X_3494_ _1371_ _1300_ _1287_ _1376_ VGND VGND VPWR VPWR _0545_ sky130_fd_sc_hd__a211o_1
X_2514_ _1618_ _1472_ _1619_ VGND VGND VPWR VPWR _1620_ sky130_fd_sc_hd__o21ai_2
X_4046_ _1135_ _1789_ _2024_ _2026_ VGND VGND VPWR VPWR _1138_ sky130_fd_sc_hd__a31o_1
XFILLER_0_46_197 VGND VGND VPWR VPWR sky130_fd_sc_hd__fill_2
XFILLER_0_19_389 VGND VGND VPWR VPWR sky130_fd_sc_hd__decap_3
XFILLER_0_61_189 VGND VGND VPWR VPWR sky130_fd_sc_hd__fill_2
XFILLER_0_61_178 VGND VGND VPWR VPWR sky130_fd_sc_hd__decap_3
XFILLER_0_61_167 VGND VGND VPWR VPWR sky130_fd_sc_hd__fill_1
XFILLER_0_69_278 VGND VGND VPWR VPWR sky130_fd_sc_hd__fill_2
XFILLER_0_69_223 VGND VGND VPWR VPWR sky130_fd_sc_hd__fill_1
XTAP_TAPCELL_ROW_2_171 VGND VPWR sky130_fd_sc_hd__tapvpwrvgnd_1
Xmax_cap119 _1609_ VGND VGND VPWR VPWR net119 sky130_fd_sc_hd__buf_2
XFILLER_0_37_197 VPWR VGND VPWR VGND sky130_ef_sc_hd__decap_12
XFILLER_0_25_337 VPWR VGND VPWR VGND sky130_ef_sc_hd__decap_12
XFILLER_0_20_25 VGND VGND VPWR VPWR sky130_fd_sc_hd__decap_3
X_2230_ net45 VGND VGND VPWR VPWR _1336_ sky130_fd_sc_hd__buf_2
X_2092_ net45 net13 VGND VGND VPWR VPWR _0363_ sky130_fd_sc_hd__nor2_1
XFILLER_0_48_418 VGND VGND VPWR VPWR sky130_fd_sc_hd__fill_2
XFILLER_0_45_33 VGND VGND VPWR VPWR sky130_fd_sc_hd__fill_1
XFILLER_0_45_11 VGND VGND VPWR VPWR sky130_fd_sc_hd__fill_2
X_2161_ net31 net63 VGND VGND VPWR VPWR _1104_ sky130_fd_sc_hd__nand2b_2
X_2994_ _1856_ _1862_ _1972_ VGND VGND VPWR VPWR _0040_ sky130_fd_sc_hd__mux2_1
XFILLER_0_28_186 VGND VGND VPWR VPWR sky130_fd_sc_hd__decap_4
XFILLER_0_0_57 VPWR VGND VPWR VGND sky130_ef_sc_hd__decap_12
XFILLER_0_9_22 VGND VGND VPWR VPWR sky130_fd_sc_hd__fill_2
X_3546_ _1560_ _0166_ VGND VGND VPWR VPWR _0602_ sky130_fd_sc_hd__nor2_1
X_3615_ _1608_ _1611_ _1614_ _0675_ VGND VGND VPWR VPWR _0677_ sky130_fd_sc_hd__a31o_1
XFILLER_0_3_220 VGND VGND VPWR VPWR sky130_fd_sc_hd__decap_4
XTAP_TAPCELL_ROW_8_219 VGND VPWR sky130_fd_sc_hd__tapvpwrvgnd_1
X_3477_ _1694_ _1604_ _1426_ VGND VGND VPWR VPWR _0528_ sky130_fd_sc_hd__and3_1
XFILLER_0_50_3 VPWR VGND VPWR VGND sky130_ef_sc_hd__decap_12
X_2428_ _1527_ _1529_ _1531_ _1533_ VGND VGND VPWR VPWR _1534_ sky130_fd_sc_hd__o31ai_4
X_2359_ _1459_ _1460_ _1462_ _1464_ VGND VGND VPWR VPWR _1465_ sky130_fd_sc_hd__nand4b_4
XTAP_TAPCELL_ROW_67_663 VGND VPWR sky130_fd_sc_hd__tapvpwrvgnd_1
XFILLER_0_66_259 VGND VGND VPWR VPWR sky130_fd_sc_hd__fill_2
X_4029_ _1117_ _1118_ _1831_ VGND VGND VPWR VPWR _1119_ sky130_fd_sc_hd__a21oi_1
XFILLER_0_62_421 VPWR VGND VPWR VGND sky130_ef_sc_hd__decap_12
XTAP_TAPCELL_ROW_50_530 VGND VPWR sky130_fd_sc_hd__tapvpwrvgnd_1
XFILLER_0_34_156 VGND VGND VPWR VPWR sky130_fd_sc_hd__decap_3
XFILLER_0_22_307 VGND VGND VPWR VPWR sky130_fd_sc_hd__fill_1
XFILLER_0_19_186 VGND VGND VPWR VPWR sky130_fd_sc_hd__decap_8
XFILLER_0_19_164 VGND VGND VPWR VPWR sky130_fd_sc_hd__decap_4
XFILLER_0_65_270 VGND VGND VPWR VPWR sky130_fd_sc_hd__decap_4
XFILLER_0_57_259 VGND VGND VPWR VPWR sky130_fd_sc_hd__fill_2
XFILLER_0_57_248 VGND VGND VPWR VPWR sky130_fd_sc_hd__decap_8
XFILLER_0_53_432 VGND VGND VPWR VPWR sky130_fd_sc_hd__fill_1
XFILLER_0_31_68 VPWR VGND VPWR VGND sky130_ef_sc_hd__decap_12
XFILLER_0_31_57 VGND VGND VPWR VPWR sky130_fd_sc_hd__decap_4
XTAP_TAPCELL_ROW_13_254 VGND VPWR sky130_fd_sc_hd__tapvpwrvgnd_1
X_3331_ _1908_ _1907_ _1906_ _1905_ _1658_ _1700_ VGND VGND VPWR VPWR _0369_ sky130_fd_sc_hd__mux4_2
XFILLER_0_40_126 VPWR VGND VPWR VGND sky130_ef_sc_hd__decap_12
X_3400_ _0211_ _0038_ _0443_ VGND VGND VPWR VPWR _0444_ sky130_fd_sc_hd__and3_1
XFILLER_0_25_178 VGND VGND VPWR VPWR sky130_fd_sc_hd__fill_1
XFILLER_0_21_362 VPWR VGND VPWR VGND sky130_ef_sc_hd__decap_12
XFILLER_0_0_212 VPWR VGND VPWR VGND sky130_ef_sc_hd__decap_12
X_3193_ _1318_ _0234_ _0235_ _1543_ _1821_ VGND VGND VPWR VPWR _0236_ sky130_fd_sc_hd__o32a_1
X_2144_ net51 VGND VGND VPWR VPWR _0922_ sky130_fd_sc_hd__inv_2
X_2213_ _0697_ _0719_ _1318_ VGND VGND VPWR VPWR _1319_ sky130_fd_sc_hd__o21ai_1
XFILLER_0_56_21 VGND VGND VPWR VPWR sky130_fd_sc_hd__fill_1
X_3262_ net106 net105 net77 net76 VGND VGND VPWR VPWR _0301_ sky130_fd_sc_hd__or4_1
XFILLER_0_72_97 VPWR VGND VPWR VGND sky130_ef_sc_hd__decap_12
XFILLER_0_72_53 VPWR VGND VPWR VGND sky130_ef_sc_hd__decap_12
XFILLER_0_48_226 VGND VGND VPWR VPWR sky130_fd_sc_hd__decap_3
XFILLER_0_71_295 VGND VGND VPWR VPWR sky130_fd_sc_hd__decap_3
X_2977_ _0020_ _0021_ _0022_ VGND VGND VPWR VPWR _0023_ sky130_fd_sc_hd__mux2_1
XFILLER_0_56_281 VGND VGND VPWR VPWR sky130_fd_sc_hd__fill_1
XFILLER_0_44_421 VPWR VGND VPWR VGND sky130_ef_sc_hd__decap_12
XFILLER_0_31_104 VGND VGND VPWR VPWR sky130_fd_sc_hd__decap_8
XPHY_EDGE_ROW_12_Left_86 VGND VGND VPWR VPWR sky130_fd_sc_hd__decap_3
XFILLER_0_16_178 VPWR VGND VPWR VGND sky130_ef_sc_hd__decap_12
X_3529_ _0534_ _0536_ _0583_ VGND VGND VPWR VPWR _2084_ sky130_fd_sc_hd__o21ai_1
XFILLER_0_12_351 VGND VGND VPWR VPWR sky130_fd_sc_hd__decap_3
XFILLER_0_54_229 VPWR VGND VPWR VGND sky130_ef_sc_hd__decap_12
XTAP_TAPCELL_ROW_10_235 VGND VPWR sky130_fd_sc_hd__tapvpwrvgnd_1
XTAP_TAPCELL_ROW_61_614 VGND VPWR sky130_fd_sc_hd__tapvpwrvgnd_1
X_2900_ _2003_ VGND VGND VPWR VPWR _2004_ sky130_fd_sc_hd__buf_2
X_2831_ _1806_ _1431_ _1935_ VGND VGND VPWR VPWR _1936_ sky130_fd_sc_hd__o21ai_1
XFILLER_0_53_284 VGND VGND VPWR VPWR sky130_fd_sc_hd__decap_3
XFILLER_0_53_251 VGND VGND VPWR VPWR sky130_fd_sc_hd__fill_1
XFILLER_0_45_207 VGND VGND VPWR VPWR sky130_fd_sc_hd__decap_4
X_3880_ _0068_ _0078_ _1598_ _0810_ VGND VGND VPWR VPWR _0960_ sky130_fd_sc_hd__or4_1
XFILLER_0_41_424 VGND VGND VPWR VPWR sky130_fd_sc_hd__decap_8
X_2762_ _1537_ _1436_ _1432_ _1548_ VGND VGND VPWR VPWR _1867_ sky130_fd_sc_hd__and4bb_4
XFILLER_0_26_421 VGND VGND VPWR VPWR sky130_fd_sc_hd__decap_6
XFILLER_0_26_410 VGND VGND VPWR VPWR sky130_fd_sc_hd__decap_8
XFILLER_0_5_315 VGND VGND VPWR VPWR sky130_fd_sc_hd__decap_8
XFILLER_0_5_337 VPWR VGND VPWR VGND sky130_ef_sc_hd__decap_12
XFILLER_0_67_75 VGND VGND VPWR VPWR sky130_fd_sc_hd__decap_4
X_2693_ _1798_ VGND VGND VPWR VPWR _1799_ sky130_fd_sc_hd__buf_4
X_3314_ _0251_ _0196_ _0092_ VGND VGND VPWR VPWR _0352_ sky130_fd_sc_hd__o21a_1
X_3245_ _0719_ _0282_ _1799_ VGND VGND VPWR VPWR _0286_ sky130_fd_sc_hd__o21ai_1
X_2127_ net53 net21 VGND VGND VPWR VPWR _0740_ sky130_fd_sc_hd__nor2_2
XFILLER_0_67_86 VPWR VGND VPWR VGND sky130_ef_sc_hd__decap_12
X_3176_ _0218_ _1910_ _1708_ VGND VGND VPWR VPWR _0219_ sky130_fd_sc_hd__a21oi_1
XFILLER_0_13_3 VPWR VGND VPWR VGND sky130_ef_sc_hd__decap_12
XFILLER_0_29_281 VGND VGND VPWR VPWR sky130_fd_sc_hd__decap_8
XTAP_TAPCELL_ROW_24_338 VGND VPWR sky130_fd_sc_hd__tapvpwrvgnd_1
XFILLER_0_44_251 VGND VGND VPWR VPWR sky130_fd_sc_hd__fill_1
XFILLER_0_8_197 VGND VGND VPWR VPWR sky130_fd_sc_hd__fill_1
XFILLER_0_12_59 VPWR VGND VPWR VGND sky130_ef_sc_hd__decap_12
Xoutput92 net92 VGND VGND VPWR VPWR result[25] sky130_fd_sc_hd__buf_2
X_3030_ _1877_ _1481_ _1717_ VGND VGND VPWR VPWR _0075_ sky130_fd_sc_hd__o21a_1
Xoutput81 net81 VGND VGND VPWR VPWR result[15] sky130_fd_sc_hd__buf_2
XFILLER_0_58_365 VGND VGND VPWR VPWR sky130_fd_sc_hd__decap_4
XFILLER_0_53_77 VGND VGND VPWR VPWR sky130_fd_sc_hd__decap_3
XFILLER_0_53_55 VGND VGND VPWR VPWR sky130_fd_sc_hd__fill_1
X_3932_ _0001_ _0622_ _0611_ _1926_ VGND VGND VPWR VPWR _1015_ sky130_fd_sc_hd__a2bb2o_1
X_3863_ _1471_ _0872_ _0889_ VGND VGND VPWR VPWR _0941_ sky130_fd_sc_hd__or3_1
X_2814_ _1917_ _1918_ _1629_ VGND VGND VPWR VPWR _1919_ sky130_fd_sc_hd__mux2_1
X_2676_ _1780_ _1781_ VGND VGND VPWR VPWR _1782_ sky130_fd_sc_hd__nor2_1
XFILLER_0_41_221 VGND VGND VPWR VPWR sky130_fd_sc_hd__decap_3
X_3794_ _0867_ _0243_ VGND VGND VPWR VPWR _0868_ sky130_fd_sc_hd__nand2_1
XFILLER_0_26_295 VPWR VGND VPWR VGND sky130_ef_sc_hd__decap_12
XTAP_TAPCELL_ROW_21_319 VGND VPWR sky130_fd_sc_hd__tapvpwrvgnd_1
XFILLER_0_5_189 VGND VGND VPWR VPWR sky130_fd_sc_hd__fill_2
X_2745_ net6 _1563_ VGND VGND VPWR VPWR _1850_ sky130_fd_sc_hd__nand2b_2
X_3159_ _0087_ _1674_ _0200_ _1930_ _0201_ VGND VGND VPWR VPWR _0202_ sky130_fd_sc_hd__o221a_1
X_3228_ _0065_ _0266_ _0083_ _0269_ VGND VGND VPWR VPWR _0270_ sky130_fd_sc_hd__a211oi_1
XFILLER_0_64_335 VGND VGND VPWR VPWR sky130_fd_sc_hd__decap_3
XFILLER_0_32_265 VGND VGND VPWR VPWR sky130_fd_sc_hd__fill_2
XFILLER_0_32_243 VGND VGND VPWR VPWR sky130_fd_sc_hd__fill_1
XFILLER_0_2_3 VPWR VGND VPWR VGND sky130_ef_sc_hd__decap_12
XFILLER_0_67_162 VGND VGND VPWR VPWR sky130_fd_sc_hd__decap_6
XFILLER_0_59_129 VGND VGND VPWR VPWR sky130_fd_sc_hd__fill_2
XFILLER_0_55_335 VGND VGND VPWR VPWR sky130_fd_sc_hd__fill_1
XFILLER_0_55_368 VGND VGND VPWR VPWR sky130_fd_sc_hd__fill_1
XFILLER_0_55_357 VGND VGND VPWR VPWR sky130_fd_sc_hd__fill_1
XFILLER_0_23_232 VGND VGND VPWR VPWR sky130_fd_sc_hd__fill_2
X_2530_ _1635_ VGND VGND VPWR VPWR _1636_ sky130_fd_sc_hd__buf_4
X_4131_ _1452_ _0427_ _1676_ _1672_ _1209_ VGND VGND VPWR VPWR _1228_ sky130_fd_sc_hd__o32a_1
XFILLER_0_48_11 VGND VGND VPWR VPWR sky130_fd_sc_hd__fill_2
X_2392_ net40 _1330_ VGND VGND VPWR VPWR _1498_ sky130_fd_sc_hd__or2b_1
X_4200_ clknet_2_1__leaf_clk _2065_ net121 VGND VGND VPWR VPWR net82 sky130_fd_sc_hd__dfrtp_1
X_2461_ _1566_ VGND VGND VPWR VPWR _1567_ sky130_fd_sc_hd__buf_4
X_3013_ _0740_ _0762_ VGND VGND VPWR VPWR _0058_ sky130_fd_sc_hd__nor2_1
X_4062_ _1480_ _2017_ _1929_ _1153_ VGND VGND VPWR VPWR _1154_ sky130_fd_sc_hd__o211a_1
XFILLER_0_3_57 VPWR VGND VPWR VGND sky130_ef_sc_hd__decap_12
XFILLER_0_73_154 VPWR VGND VPWR VGND sky130_ef_sc_hd__decap_12
XFILLER_0_58_195 VGND VGND VPWR VPWR sky130_fd_sc_hd__fill_1
XFILLER_0_58_162 VGND VGND VPWR VPWR sky130_fd_sc_hd__fill_1
X_3915_ _1474_ _1443_ _1940_ _1941_ VGND VGND VPWR VPWR _0998_ sky130_fd_sc_hd__o211a_1
XTAP_TAPCELL_ROW_34_411 VGND VPWR sky130_fd_sc_hd__tapvpwrvgnd_1
XFILLER_0_6_421 VPWR VGND VPWR VGND sky130_ef_sc_hd__decap_12
XFILLER_0_13_91 VGND VGND VPWR VPWR sky130_fd_sc_hd__fill_2
X_3846_ _1740_ _1930_ _1672_ _1061_ _0923_ VGND VGND VPWR VPWR _0924_ sky130_fd_sc_hd__o221a_1
X_3777_ _1317_ _1960_ _0037_ VGND VGND VPWR VPWR _0850_ sky130_fd_sc_hd__or3_1
X_2728_ _1562_ _1459_ _1832_ VGND VGND VPWR VPWR _1833_ sky130_fd_sc_hd__a21oi_1
X_2659_ _1755_ _1757_ _1758_ _1764_ VGND VGND VPWR VPWR _1765_ sky130_fd_sc_hd__a31oi_4
Xfanout123 net124 VGND VGND VPWR VPWR net123 sky130_fd_sc_hd__clkbuf_2
XFILLER_0_1_181 VPWR VGND VPWR VGND sky130_ef_sc_hd__decap_12
XTAP_TAPCELL_ROW_40_458 VGND VPWR sky130_fd_sc_hd__tapvpwrvgnd_1
XFILLER_0_60_371 VGND VGND VPWR VPWR sky130_fd_sc_hd__fill_1
XPHY_EDGE_ROW_0_Left_74 VGND VGND VPWR VPWR sky130_fd_sc_hd__decap_3
XTAP_TAPCELL_ROW_56_580 VGND VPWR sky130_fd_sc_hd__tapvpwrvgnd_1
XFILLER_0_55_154 VGND VGND VPWR VPWR sky130_fd_sc_hd__decap_3
XFILLER_0_43_305 VGND VGND VPWR VPWR sky130_fd_sc_hd__decap_8
XFILLER_0_34_57 VGND VGND VPWR VPWR sky130_fd_sc_hd__decap_8
X_3700_ _1313_ _1421_ net64 VGND VGND VPWR VPWR _0767_ sky130_fd_sc_hd__a21o_1
XFILLER_0_7_207 VGND VGND VPWR VPWR sky130_fd_sc_hd__decap_3
XFILLER_0_51_393 VGND VGND VPWR VPWR sky130_fd_sc_hd__fill_1
XFILLER_0_51_360 VGND VGND VPWR VPWR sky130_fd_sc_hd__decap_6
X_3631_ _1316_ _1842_ _1636_ _1611_ VGND VGND VPWR VPWR _0693_ sky130_fd_sc_hd__or4_2
XFILLER_0_43_349 VPWR VGND VPWR VGND sky130_ef_sc_hd__decap_12
X_3493_ _1634_ _0340_ _0338_ _1985_ _0543_ VGND VGND VPWR VPWR _0544_ sky130_fd_sc_hd__o221a_1
XFILLER_0_3_435 VGND VGND VPWR VPWR sky130_fd_sc_hd__fill_2
X_2513_ _1200_ _1563_ VGND VGND VPWR VPWR _1619_ sky130_fd_sc_hd__or2b_1
XFILLER_0_11_246 VGND VGND VPWR VPWR sky130_fd_sc_hd__fill_1
X_3562_ _0612_ _0613_ _0614_ _0616_ _0618_ VGND VGND VPWR VPWR _0619_ sky130_fd_sc_hd__o2111a_1
X_4114_ _0417_ _0438_ VGND VGND VPWR VPWR _1209_ sky130_fd_sc_hd__or2_2
X_2444_ _1540_ _1548_ _1549_ VGND VGND VPWR VPWR _1550_ sky130_fd_sc_hd__and3_1
X_2375_ net10 VGND VGND VPWR VPWR _1481_ sky130_fd_sc_hd__clkbuf_4
XFILLER_0_66_419 VGND VGND VPWR VPWR sky130_fd_sc_hd__fill_1
X_4045_ _1135_ _2024_ _1789_ VGND VGND VPWR VPWR _1137_ sky130_fd_sc_hd__a21oi_1
X_3829_ _0891_ _0892_ _0897_ _0900_ _0905_ VGND VGND VPWR VPWR _0906_ sky130_fd_sc_hd__o2111a_1
XFILLER_0_69_213 VGND VGND VPWR VPWR sky130_fd_sc_hd__fill_1
XPHY_EDGE_ROW_27_Left_101 VGND VGND VPWR VPWR sky130_fd_sc_hd__decap_3
XTAP_TAPCELL_ROW_2_172 VGND VPWR sky130_fd_sc_hd__tapvpwrvgnd_1
XFILLER_0_69_268 VGND VGND VPWR VPWR sky130_fd_sc_hd__fill_1
XFILLER_0_37_176 VGND VGND VPWR VPWR sky130_fd_sc_hd__fill_2
XFILLER_0_25_305 VGND VGND VPWR VPWR sky130_fd_sc_hd__decap_4
XFILLER_0_60_190 VGND VGND VPWR VPWR sky130_fd_sc_hd__decap_6
XPHY_EDGE_ROW_36_Left_110 VGND VGND VPWR VPWR sky130_fd_sc_hd__decap_3
XFILLER_0_25_349 VPWR VGND VPWR VGND sky130_ef_sc_hd__decap_12
XFILLER_0_0_405 VPWR VGND VPWR VGND sky130_ef_sc_hd__decap_12
XFILLER_0_29_57 VGND VGND VPWR VPWR sky130_fd_sc_hd__decap_8
X_2160_ net63 net31 VGND VGND VPWR VPWR _1093_ sky130_fd_sc_hd__or2b_1
XFILLER_0_61_11 VGND VGND VPWR VPWR sky130_fd_sc_hd__fill_2
XFILLER_0_0_14 VGND VGND VPWR VPWR sky130_fd_sc_hd__decap_3
XFILLER_0_68_290 VPWR VGND VPWR VGND sky130_ef_sc_hd__decap_12
XFILLER_0_61_66 VPWR VGND VPWR VGND sky130_ef_sc_hd__decap_12
X_2993_ _1849_ _1853_ _1851_ _1858_ _1628_ _1604_ VGND VGND VPWR VPWR _0039_ sky130_fd_sc_hd__mux4_2
XFILLER_0_31_308 VGND VGND VPWR VPWR sky130_fd_sc_hd__decap_3
X_3614_ _0142_ _0672_ _0674_ VGND VGND VPWR VPWR _0675_ sky130_fd_sc_hd__a21bo_1
XFILLER_0_28_154 VGND VGND VPWR VPWR sky130_fd_sc_hd__decap_4
XFILLER_0_28_110 VGND VGND VPWR VPWR sky130_fd_sc_hd__decap_8
XFILLER_0_0_69 VGND VGND VPWR VPWR sky130_fd_sc_hd__decap_8
XFILLER_0_9_67 VGND VGND VPWR VPWR sky130_fd_sc_hd__decap_6
XFILLER_0_16_305 VGND VGND VPWR VPWR sky130_fd_sc_hd__decap_3
X_3545_ _0596_ _0597_ _0599_ VGND VGND VPWR VPWR _0601_ sky130_fd_sc_hd__a21bo_1
XFILLER_0_24_371 VGND VGND VPWR VPWR sky130_fd_sc_hd__fill_2
XFILLER_0_3_298 VGND VGND VPWR VPWR sky130_fd_sc_hd__decap_6
X_3476_ _1749_ _1299_ _0524_ VGND VGND VPWR VPWR _0527_ sky130_fd_sc_hd__or3_1
XFILLER_0_10_70 VGND VGND VPWR VPWR sky130_fd_sc_hd__fill_1
X_2427_ _1408_ _1532_ _1407_ VGND VGND VPWR VPWR _1533_ sky130_fd_sc_hd__a21oi_1
XTAP_TAPCELL_ROW_67_664 VGND VPWR sky130_fd_sc_hd__tapvpwrvgnd_1
XFILLER_0_43_3 VPWR VGND VPWR VGND sky130_ef_sc_hd__decap_12
X_4028_ _0324_ _0596_ _1830_ _2055_ VGND VGND VPWR VPWR _1118_ sky130_fd_sc_hd__or4_1
X_2289_ net64 VGND VGND VPWR VPWR _1395_ sky130_fd_sc_hd__inv_2
X_2358_ _1463_ VGND VGND VPWR VPWR _1464_ sky130_fd_sc_hd__inv_2
XTAP_TAPCELL_ROW_50_531 VGND VPWR sky130_fd_sc_hd__tapvpwrvgnd_1
XFILLER_0_62_433 VGND VGND VPWR VPWR sky130_fd_sc_hd__decap_4
XFILLER_0_42_190 VGND VGND VPWR VPWR sky130_fd_sc_hd__decap_6
XFILLER_0_15_393 VGND VGND VPWR VPWR sky130_fd_sc_hd__decap_4
XFILLER_0_30_396 VGND VGND VPWR VPWR sky130_fd_sc_hd__decap_4
XFILLER_0_30_374 VGND VGND VPWR VPWR sky130_fd_sc_hd__decap_8
XTAP_TAPCELL_ROW_13_255 VGND VPWR sky130_fd_sc_hd__tapvpwrvgnd_1
XFILLER_0_40_138 VGND VGND VPWR VPWR sky130_fd_sc_hd__fill_2
X_3330_ _0267_ _1444_ _1447_ VGND VGND VPWR VPWR _0368_ sky130_fd_sc_hd__o21ai_1
XFILLER_0_21_374 VGND VGND VPWR VPWR sky130_fd_sc_hd__decap_3
XFILLER_0_0_279 VGND VGND VPWR VPWR sky130_fd_sc_hd__fill_1
XFILLER_0_0_202 VGND VGND VPWR VPWR sky130_fd_sc_hd__decap_4
X_2143_ _0890_ _0901_ VGND VGND VPWR VPWR _0911_ sky130_fd_sc_hd__nand2b_4
X_3192_ _0055_ _0054_ _0804_ VGND VGND VPWR VPWR _0235_ sky130_fd_sc_hd__a21oi_2
X_2212_ _0665_ _0686_ VGND VGND VPWR VPWR _1318_ sky130_fd_sc_hd__nand2_2
X_3261_ net86 net75 net100 net97 VGND VGND VPWR VPWR _0300_ sky130_fd_sc_hd__or4_1
XFILLER_0_72_65 VPWR VGND VPWR VGND sky130_ef_sc_hd__decap_12
X_2976_ _1628_ VGND VGND VPWR VPWR _0022_ sky130_fd_sc_hd__buf_4
X_3528_ _2030_ _0537_ _0538_ _0567_ _0582_ VGND VGND VPWR VPWR _0583_ sky130_fd_sc_hd__o311a_1
X_3459_ _0333_ _1928_ _0256_ VGND VGND VPWR VPWR _0508_ sky130_fd_sc_hd__a21oi_1
XTAP_TAPCELL_ROW_27_358 VGND VPWR sky130_fd_sc_hd__tapvpwrvgnd_1
XFILLER_0_22_138 VGND VGND VPWR VPWR sky130_fd_sc_hd__fill_2
XFILLER_0_22_116 VGND VGND VPWR VPWR sky130_fd_sc_hd__decap_8
XTAP_TAPCELL_ROW_10_236 VGND VPWR sky130_fd_sc_hd__tapvpwrvgnd_1
X_2830_ net50 _1444_ _1447_ VGND VGND VPWR VPWR _1935_ sky130_fd_sc_hd__o21a_1
XTAP_TAPCELL_ROW_61_615 VGND VPWR sky130_fd_sc_hd__tapvpwrvgnd_1
XFILLER_0_42_57 VGND VGND VPWR VPWR sky130_fd_sc_hd__fill_1
X_2761_ _1561_ _1854_ _1864_ _1865_ VGND VGND VPWR VPWR _1866_ sky130_fd_sc_hd__a211o_1
XANTENNA_1 _0022_ VGND VGND VPWR VPWR sky130_fd_sc_hd__diode_2
X_2692_ _1553_ _1539_ _1664_ VGND VGND VPWR VPWR _1798_ sky130_fd_sc_hd__and3_1
XFILLER_0_5_349 VPWR VGND VPWR VGND sky130_ef_sc_hd__decap_12
XFILLER_0_13_127 VGND VGND VPWR VPWR sky130_fd_sc_hd__decap_8
X_3244_ _2024_ net57 _0200_ _0230_ VGND VGND VPWR VPWR _0285_ sky130_fd_sc_hd__o22a_1
XFILLER_0_67_98 VPWR VGND VPWR VGND sky130_ef_sc_hd__decap_12
XFILLER_0_67_54 VGND VGND VPWR VPWR sky130_fd_sc_hd__fill_2
XFILLER_0_21_182 VGND VGND VPWR VPWR sky130_fd_sc_hd__decap_4
X_3313_ _0066_ _1926_ _2014_ VGND VGND VPWR VPWR _0351_ sky130_fd_sc_hd__a21oi_1
XFILLER_0_6_57 VGND VGND VPWR VPWR sky130_fd_sc_hd__fill_1
XFILLER_0_6_79 VGND VGND VPWR VPWR sky130_fd_sc_hd__decap_4
X_2126_ _0697_ _0719_ VGND VGND VPWR VPWR _0729_ sky130_fd_sc_hd__nor2_2
X_3175_ _1711_ _1601_ _1595_ _1603_ _1586_ _1582_ VGND VGND VPWR VPWR _0218_ sky130_fd_sc_hd__mux4_2
X_2959_ net52 _1679_ _0004_ _0890_ VGND VGND VPWR VPWR _0005_ sky130_fd_sc_hd__a22oi_1
XFILLER_0_29_260 VGND VGND VPWR VPWR sky130_fd_sc_hd__fill_1
XTAP_TAPCELL_ROW_24_339 VGND VPWR sky130_fd_sc_hd__tapvpwrvgnd_1
XFILLER_0_16_91 VPWR VGND VPWR VGND sky130_ef_sc_hd__decap_12
XFILLER_0_44_296 VGND VGND VPWR VPWR sky130_fd_sc_hd__fill_1
Xoutput93 net93 VGND VGND VPWR VPWR result[26] sky130_fd_sc_hd__buf_2
XFILLER_0_37_24 VGND VGND VPWR VPWR sky130_fd_sc_hd__decap_8
Xoutput82 net82 VGND VGND VPWR VPWR result[16] sky130_fd_sc_hd__buf_2
XFILLER_0_10_108 VGND VGND VPWR VPWR sky130_fd_sc_hd__decap_3
XFILLER_0_37_57 VGND VGND VPWR VPWR sky130_fd_sc_hd__decap_4
X_2813_ net18 net19 _1347_ net21 _1572_ _1586_ VGND VGND VPWR VPWR _1918_ sky130_fd_sc_hd__mux4_1
X_3931_ _0622_ net118 _2009_ _0349_ _0632_ VGND VGND VPWR VPWR _1014_ sky130_fd_sc_hd__a32o_1
X_3862_ _1471_ _0872_ _0889_ _0939_ _1486_ VGND VGND VPWR VPWR _0940_ sky130_fd_sc_hd__o311a_1
X_2675_ _1497_ _1327_ _0557_ _0600_ _0632_ VGND VGND VPWR VPWR _1781_ sky130_fd_sc_hd__o2111ai_4
XFILLER_0_41_244 VGND VGND VPWR VPWR sky130_fd_sc_hd__fill_1
X_3793_ _0731_ _0489_ _0486_ _0865_ _0866_ VGND VGND VPWR VPWR _0867_ sky130_fd_sc_hd__o221ai_2
XFILLER_0_26_285 VGND VGND VPWR VPWR sky130_fd_sc_hd__fill_1
XFILLER_0_5_113 VPWR VGND VPWR VGND sky130_ef_sc_hd__decap_12
X_2744_ _1570_ _1411_ _1848_ VGND VGND VPWR VPWR _1849_ sky130_fd_sc_hd__o21ai_4
X_3227_ _0251_ _0267_ _1986_ _1643_ _0268_ VGND VGND VPWR VPWR _0269_ sky130_fd_sc_hd__o311a_1
X_3158_ _0676_ _1922_ _0686_ _1682_ VGND VGND VPWR VPWR _0201_ sky130_fd_sc_hd__o2bb2a_1
X_2109_ net42 net10 VGND VGND VPWR VPWR _0546_ sky130_fd_sc_hd__nand2b_2
X_3089_ _1839_ _1849_ _1837_ _1847_ _1628_ _1587_ VGND VGND VPWR VPWR _0133_ sky130_fd_sc_hd__mux4_2
XTAP_TAPCELL_ROW_43_478 VGND VPWR sky130_fd_sc_hd__tapvpwrvgnd_1
XFILLER_0_23_37 VGND VGND VPWR VPWR sky130_fd_sc_hd__decap_4
XFILLER_0_70_328 VPWR VGND VPWR VGND sky130_ef_sc_hd__decap_12
XFILLER_0_63_391 VGND VGND VPWR VPWR sky130_fd_sc_hd__fill_1
X_2460_ _1305_ VGND VGND VPWR VPWR _1566_ sky130_fd_sc_hd__buf_4
XFILLER_0_11_428 VGND VGND VPWR VPWR sky130_fd_sc_hd__decap_4
X_4130_ _1809_ _1808_ _0438_ _0347_ VGND VGND VPWR VPWR _1227_ sky130_fd_sc_hd__or4_1
X_4061_ _1336_ _1480_ VGND VGND VPWR VPWR _1153_ sky130_fd_sc_hd__nand2_1
X_2391_ _1326_ net43 VGND VGND VPWR VPWR _1497_ sky130_fd_sc_hd__and2b_1
X_3012_ _0740_ _0762_ _0054_ _0055_ VGND VGND VPWR VPWR _0057_ sky130_fd_sc_hd__or4bb_1
XFILLER_0_58_141 VPWR VGND VPWR VGND sky130_ef_sc_hd__decap_12
XTAP_TAPCELL_ROW_34_412 VGND VPWR sky130_fd_sc_hd__tapvpwrvgnd_1
XFILLER_0_3_69 VPWR VGND VPWR VGND sky130_ef_sc_hd__decap_12
XFILLER_0_73_166 VGND VGND VPWR VPWR sky130_fd_sc_hd__fill_2
XFILLER_0_73_133 VGND VGND VPWR VPWR sky130_fd_sc_hd__decap_3
X_3914_ _2026_ _0979_ _0980_ _0995_ VGND VGND VPWR VPWR _0996_ sky130_fd_sc_hd__o31a_1
X_3776_ _0846_ _2026_ _0848_ VGND VGND VPWR VPWR _0849_ sky130_fd_sc_hd__or3b_1
XFILLER_0_6_433 VGND VGND VPWR VPWR sky130_fd_sc_hd__decap_4
X_3845_ _1740_ _1925_ _1922_ _1050_ _0921_ VGND VGND VPWR VPWR _0923_ sky130_fd_sc_hd__a221oi_1
XFILLER_0_73_3 VPWR VGND VPWR VGND sky130_ef_sc_hd__decap_12
X_2727_ _1566_ _1463_ VGND VGND VPWR VPWR _1832_ sky130_fd_sc_hd__and2_1
XFILLER_0_1_193 VGND VGND VPWR VPWR sky130_fd_sc_hd__fill_2
X_2658_ _1759_ _1385_ _1761_ _1763_ VGND VGND VPWR VPWR _1764_ sky130_fd_sc_hd__a31o_1
X_2589_ _1693_ _1459_ _1461_ _1463_ _1586_ _1694_ VGND VGND VPWR VPWR _1695_ sky130_fd_sc_hd__mux4_2
Xfanout124 net70 VGND VGND VPWR VPWR net124 sky130_fd_sc_hd__clkbuf_2
XFILLER_0_49_185 VGND VGND VPWR VPWR sky130_fd_sc_hd__fill_2
XFILLER_0_49_141 VGND VGND VPWR VPWR sky130_fd_sc_hd__fill_1
XFILLER_0_64_166 VGND VGND VPWR VPWR sky130_fd_sc_hd__fill_2
XFILLER_0_60_350 VPWR VGND VPWR VGND sky130_ef_sc_hd__decap_12
XTAP_TAPCELL_ROW_40_459 VGND VPWR sky130_fd_sc_hd__tapvpwrvgnd_1
XFILLER_0_20_225 VGND VGND VPWR VPWR sky130_fd_sc_hd__decap_4
XTAP_TAPCELL_ROW_56_581 VGND VPWR sky130_fd_sc_hd__tapvpwrvgnd_1
XTAP_TAPCELL_ROW_48_515 VGND VPWR sky130_fd_sc_hd__tapvpwrvgnd_1
XFILLER_0_34_69 VPWR VGND VPWR VGND sky130_ef_sc_hd__decap_12
XFILLER_0_34_25 VGND VGND VPWR VPWR sky130_fd_sc_hd__decap_3
XFILLER_0_55_133 VGND VGND VPWR VPWR sky130_fd_sc_hd__fill_1
XFILLER_0_50_24 VGND VGND VPWR VPWR sky130_fd_sc_hd__decap_4
XFILLER_0_28_303 VGND VGND VPWR VPWR sky130_fd_sc_hd__decap_4
XFILLER_0_3_403 VPWR VGND VPWR VGND sky130_ef_sc_hd__decap_12
X_3630_ net62 _1923_ _0004_ _1762_ _0691_ VGND VGND VPWR VPWR _0692_ sky130_fd_sc_hd__a221oi_1
X_2512_ _1575_ VGND VGND VPWR VPWR _1618_ sky130_fd_sc_hd__buf_4
XFILLER_0_51_372 VGND VGND VPWR VPWR sky130_fd_sc_hd__fill_1
X_2443_ net69 VGND VGND VPWR VPWR _1549_ sky130_fd_sc_hd__inv_2
X_3492_ _1583_ _0329_ _1842_ _0542_ VGND VGND VPWR VPWR _0543_ sky130_fd_sc_hd__a211o_1
XFILLER_0_11_225 VPWR VGND VPWR VGND sky130_ef_sc_hd__decap_12
X_3561_ _1284_ _1929_ _2017_ _1696_ _0617_ VGND VGND VPWR VPWR _0618_ sky130_fd_sc_hd__o221a_1
X_2374_ _1479_ VGND VGND VPWR VPWR _1480_ sky130_fd_sc_hd__buf_2
X_4113_ _1191_ _1199_ _1206_ _1208_ VGND VGND VPWR VPWR _2071_ sky130_fd_sc_hd__nand4_1
X_4044_ _0642_ _1785_ _1009_ _1477_ VGND VGND VPWR VPWR _1135_ sky130_fd_sc_hd__or4_1
XFILLER_0_61_169 VGND VGND VPWR VPWR sky130_fd_sc_hd__fill_1
XFILLER_0_42_350 VGND VGND VPWR VPWR sky130_fd_sc_hd__fill_1
XFILLER_0_34_306 VGND VGND VPWR VPWR sky130_fd_sc_hd__fill_2
X_3759_ _0813_ _0824_ _0828_ _0830_ VGND VGND VPWR VPWR _0831_ sky130_fd_sc_hd__nand4b_2
XFILLER_0_27_391 VGND VGND VPWR VPWR sky130_fd_sc_hd__fill_1
XFILLER_0_19_358 VGND VGND VPWR VPWR sky130_fd_sc_hd__fill_1
XFILLER_0_6_274 VGND VGND VPWR VPWR sky130_fd_sc_hd__decap_6
X_3828_ _1071_ _0903_ _0904_ VGND VGND VPWR VPWR _0905_ sky130_fd_sc_hd__o21bai_1
XFILLER_0_10_291 VPWR VGND VPWR VGND sky130_ef_sc_hd__decap_12
XFILLER_0_69_225 VGND VGND VPWR VPWR sky130_fd_sc_hd__decap_8
XTAP_TAPCELL_ROW_2_173 VGND VPWR sky130_fd_sc_hd__tapvpwrvgnd_1
XFILLER_0_37_166 VGND VGND VPWR VPWR sky130_fd_sc_hd__fill_2
XFILLER_0_0_417 VGND VGND VPWR VPWR sky130_fd_sc_hd__decap_3
X_2992_ _1913_ _0036_ _0037_ VGND VGND VPWR VPWR _0038_ sky130_fd_sc_hd__o21ai_2
XFILLER_0_0_37 VGND VGND VPWR VPWR sky130_fd_sc_hd__fill_1
XTAP_TAPCELL_ROW_16_275 VGND VPWR sky130_fd_sc_hd__tapvpwrvgnd_1
XFILLER_0_61_78 VGND VGND VPWR VPWR sky130_fd_sc_hd__decap_8
XFILLER_0_43_169 VGND VGND VPWR VPWR sky130_fd_sc_hd__decap_6
XFILLER_0_9_57 VGND VGND VPWR VPWR sky130_fd_sc_hd__decap_6
XFILLER_0_16_317 VGND VGND VPWR VPWR sky130_fd_sc_hd__decap_3
X_3613_ _1634_ _0673_ _0439_ _1642_ _1636_ VGND VGND VPWR VPWR _0674_ sky130_fd_sc_hd__o221a_1
X_3544_ _1634_ _0598_ _1642_ _0386_ _1636_ VGND VGND VPWR VPWR _0599_ sky130_fd_sc_hd__o221a_1
X_3475_ _1299_ _0524_ _1749_ VGND VGND VPWR VPWR _0526_ sky130_fd_sc_hd__o21ai_1
X_2426_ _1029_ net6 VGND VGND VPWR VPWR _1532_ sky130_fd_sc_hd__and2b_1
XFILLER_0_39_409 VGND VGND VPWR VPWR sky130_fd_sc_hd__decap_3
X_4027_ _1116_ _0488_ VGND VGND VPWR VPWR _1117_ sky130_fd_sc_hd__nand2_1
XFILLER_0_36_3 VGND VGND VPWR VPWR sky130_fd_sc_hd__decap_4
X_2357_ net23 VGND VGND VPWR VPWR _1463_ sky130_fd_sc_hd__buf_2
X_2288_ _1189_ _1391_ _1392_ _1393_ VGND VGND VPWR VPWR _1394_ sky130_fd_sc_hd__o22ai_4
XFILLER_0_19_80 VGND VGND VPWR VPWR sky130_fd_sc_hd__decap_8
XTAP_TAPCELL_ROW_50_532 VGND VPWR sky130_fd_sc_hd__tapvpwrvgnd_1
XFILLER_0_47_431 VGND VGND VPWR VPWR sky130_fd_sc_hd__fill_2
XFILLER_0_34_125 VGND VGND VPWR VPWR sky130_fd_sc_hd__decap_8
XFILLER_0_19_111 VGND VGND VPWR VPWR sky130_fd_sc_hd__fill_1
XFILLER_0_22_309 VGND VGND VPWR VPWR sky130_fd_sc_hd__fill_1
XTAP_TAPCELL_ROW_7_210 VGND VPWR sky130_fd_sc_hd__tapvpwrvgnd_1
XFILLER_0_57_217 VGND VGND VPWR VPWR sky130_fd_sc_hd__fill_1
XFILLER_0_15_27 VGND VGND VPWR VPWR sky130_fd_sc_hd__decap_6
XFILLER_0_72_209 VPWR VGND VPWR VGND sky130_ef_sc_hd__decap_12
XFILLER_0_53_401 VGND VGND VPWR VPWR sky130_fd_sc_hd__fill_1
XFILLER_0_40_106 VPWR VGND VPWR VGND sky130_ef_sc_hd__decap_12
XTAP_TAPCELL_ROW_13_256 VGND VPWR sky130_fd_sc_hd__tapvpwrvgnd_1
X_3260_ net102 net101 net104 net103 VGND VGND VPWR VPWR _0299_ sky130_fd_sc_hd__or4_1
XFILLER_0_21_353 VGND VGND VPWR VPWR sky130_fd_sc_hd__fill_2
XFILLER_0_0_225 VGND VGND VPWR VPWR sky130_fd_sc_hd__decap_8
X_2142_ net52 net20 VGND VGND VPWR VPWR _0901_ sky130_fd_sc_hd__nand2_2
X_3191_ _0178_ _0154_ _0233_ VGND VGND VPWR VPWR _0234_ sky130_fd_sc_hd__o21ai_2
XTAP_TAPCELL_ROW_64_635 VGND VPWR sky130_fd_sc_hd__tapvpwrvgnd_1
XFILLER_0_56_78 VGND VGND VPWR VPWR sky130_fd_sc_hd__decap_6
X_2211_ _1316_ VGND VGND VPWR VPWR _1317_ sky130_fd_sc_hd__clkbuf_4
XFILLER_0_72_77 VGND VGND VPWR VPWR sky130_fd_sc_hd__decap_6
X_2975_ _1326_ net13 net14 _1451_ _1575_ _1585_ VGND VGND VPWR VPWR _0021_ sky130_fd_sc_hd__mux4_1
XFILLER_0_8_369 VGND VGND VPWR VPWR sky130_fd_sc_hd__decap_4
XFILLER_0_16_103 VPWR VGND VPWR VGND sky130_ef_sc_hd__decap_12
X_3527_ _0573_ _0581_ _0243_ VGND VGND VPWR VPWR _0582_ sky130_fd_sc_hd__o21ai_1
XFILLER_0_21_81 VGND VGND VPWR VPWR sky130_fd_sc_hd__decap_4
XFILLER_0_16_136 VGND VGND VPWR VPWR sky130_fd_sc_hd__decap_4
XPHY_EDGE_ROW_55_Left_129 VGND VGND VPWR VPWR sky130_fd_sc_hd__decap_3
X_3389_ _1592_ _1989_ _0431_ VGND VGND VPWR VPWR _0432_ sky130_fd_sc_hd__o21a_1
X_3458_ _0398_ _0506_ _1868_ _0505_ VGND VGND VPWR VPWR _0507_ sky130_fd_sc_hd__o2bb2a_1
X_2409_ _1514_ _1373_ _1375_ _1367_ VGND VGND VPWR VPWR _1515_ sky130_fd_sc_hd__a31oi_2
XPHY_EDGE_ROW_64_Left_138 VGND VGND VPWR VPWR sky130_fd_sc_hd__decap_3
XFILLER_0_39_206 VGND VGND VPWR VPWR sky130_fd_sc_hd__decap_4
XTAP_TAPCELL_ROW_27_359 VGND VPWR sky130_fd_sc_hd__tapvpwrvgnd_1
XFILLER_0_62_264 VGND VGND VPWR VPWR sky130_fd_sc_hd__decap_8
XFILLER_0_62_253 VGND VGND VPWR VPWR sky130_fd_sc_hd__decap_8
XFILLER_0_62_231 VGND VGND VPWR VPWR sky130_fd_sc_hd__fill_1
XTAP_TAPCELL_ROW_10_237 VGND VPWR sky130_fd_sc_hd__tapvpwrvgnd_1
XPHY_EDGE_ROW_73_Left_147 VGND VGND VPWR VPWR sky130_fd_sc_hd__decap_3
XFILLER_0_30_172 VGND VGND VPWR VPWR sky130_fd_sc_hd__decap_8
XFILLER_0_26_37 VGND VGND VPWR VPWR sky130_fd_sc_hd__decap_4
XFILLER_0_26_15 VGND VGND VPWR VPWR sky130_fd_sc_hd__fill_1
XTAP_TAPCELL_ROW_61_616 VGND VPWR sky130_fd_sc_hd__tapvpwrvgnd_1
XFILLER_0_38_250 VGND VGND VPWR VPWR sky130_fd_sc_hd__fill_2
X_2691_ _1778_ _1782_ _1796_ VGND VGND VPWR VPWR _1797_ sky130_fd_sc_hd__a21oi_4
XFILLER_0_53_231 VPWR VGND VPWR VGND sky130_ef_sc_hd__decap_12
X_2760_ _1551_ _1555_ _1636_ VGND VGND VPWR VPWR _1865_ sky130_fd_sc_hd__o21ai_4
XANTENNA_2 _0072_ VGND VGND VPWR VPWR sky130_fd_sc_hd__diode_2
X_3243_ _0240_ _0241_ _0280_ _0284_ VGND VGND VPWR VPWR _2082_ sky130_fd_sc_hd__o211ai_1
XFILLER_0_67_11 VGND VGND VPWR VPWR sky130_fd_sc_hd__decap_3
XFILLER_0_21_161 VGND VGND VPWR VPWR sky130_fd_sc_hd__decap_6
X_3312_ _0349_ _1544_ _1828_ _1369_ _1956_ VGND VGND VPWR VPWR _0350_ sky130_fd_sc_hd__o32a_1
X_2125_ _0708_ VGND VGND VPWR VPWR _0719_ sky130_fd_sc_hd__buf_2
X_3174_ _1981_ _1980_ _1732_ _0075_ _0074_ _1731_ VGND VGND VPWR VPWR _0217_ sky130_fd_sc_hd__mux4_1
XFILLER_0_16_81 VGND VGND VPWR VPWR sky130_fd_sc_hd__decap_3
X_2958_ _1434_ _1432_ _1670_ _1436_ VGND VGND VPWR VPWR _0004_ sky130_fd_sc_hd__and4bb_4
XFILLER_0_44_275 VGND VGND VPWR VPWR sky130_fd_sc_hd__decap_8
XFILLER_0_44_253 VGND VGND VPWR VPWR sky130_fd_sc_hd__decap_4
XFILLER_0_32_404 VPWR VGND VPWR VGND sky130_ef_sc_hd__decap_12
XTAP_TAPCELL_ROW_32_395 VGND VPWR sky130_fd_sc_hd__tapvpwrvgnd_1
XFILLER_0_17_401 VPWR VGND VPWR VGND sky130_ef_sc_hd__decap_12
X_2889_ _1659_ _1892_ _1658_ _1730_ _1992_ VGND VGND VPWR VPWR _1993_ sky130_fd_sc_hd__o221ai_2
XFILLER_0_67_334 VGND VGND VPWR VPWR sky130_fd_sc_hd__fill_2
XFILLER_0_50_267 VPWR VGND VPWR VGND sky130_ef_sc_hd__decap_12
XFILLER_0_35_275 VGND VGND VPWR VPWR sky130_fd_sc_hd__decap_4
Xoutput72 net72 VGND VGND VPWR VPWR carry sky130_fd_sc_hd__clkbuf_4
Xoutput94 net94 VGND VGND VPWR VPWR result[27] sky130_fd_sc_hd__buf_2
Xoutput83 net83 VGND VGND VPWR VPWR result[17] sky130_fd_sc_hd__buf_2
XFILLER_0_53_57 VPWR VGND VPWR VGND sky130_ef_sc_hd__decap_12
X_3930_ _1009_ _0426_ _0478_ _1012_ VGND VGND VPWR VPWR _1013_ sky130_fd_sc_hd__o211a_1
XFILLER_0_73_359 VGND VGND VPWR VPWR sky130_fd_sc_hd__fill_1
X_2812_ _1877_ _1878_ _1894_ _1869_ VGND VGND VPWR VPWR _1917_ sky130_fd_sc_hd__o22ai_4
X_3792_ _1709_ _1891_ _0070_ _0009_ VGND VGND VPWR VPWR _0866_ sky130_fd_sc_hd__nand4_1
XFILLER_0_26_253 VGND VGND VPWR VPWR sky130_fd_sc_hd__decap_8
XFILLER_0_5_125 VGND VGND VPWR VPWR sky130_fd_sc_hd__decap_8
X_2743_ _1472_ _1566_ VGND VGND VPWR VPWR _1848_ sky130_fd_sc_hd__or2b_2
X_3861_ _1475_ VGND VGND VPWR VPWR _0939_ sky130_fd_sc_hd__buf_2
X_2674_ _1779_ _1501_ _1503_ _1502_ VGND VGND VPWR VPWR _1780_ sky130_fd_sc_hd__nand4_1
XFILLER_0_1_353 VGND VGND VPWR VPWR sky130_fd_sc_hd__decap_3
XFILLER_0_5_169 VPWR VGND VPWR VGND sky130_ef_sc_hd__decap_12
X_3157_ _0676_ _0087_ VGND VGND VPWR VPWR _0200_ sky130_fd_sc_hd__and2_2
X_3226_ _1862_ _1856_ _1853_ _1858_ _0074_ _1662_ VGND VGND VPWR VPWR _0268_ sky130_fd_sc_hd__mux4_2
X_3088_ _0037_ VGND VGND VPWR VPWR _0132_ sky130_fd_sc_hd__clkbuf_4
XFILLER_0_49_301 VGND VGND VPWR VPWR sky130_fd_sc_hd__fill_2
X_2108_ net10 net42 VGND VGND VPWR VPWR _0535_ sky130_fd_sc_hd__nand2b_2
XTAP_TAPCELL_ROW_20_310 VGND VPWR sky130_fd_sc_hd__tapvpwrvgnd_1
XFILLER_0_17_286 VPWR VGND VPWR VGND sky130_ef_sc_hd__decap_12
XFILLER_0_67_197 VPWR VGND VPWR VGND sky130_ef_sc_hd__decap_12
XFILLER_0_67_175 VGND VGND VPWR VPWR sky130_fd_sc_hd__decap_6
XFILLER_0_67_142 VGND VGND VPWR VPWR sky130_fd_sc_hd__decap_6
XFILLER_0_55_326 VGND VGND VPWR VPWR sky130_fd_sc_hd__fill_1
XTAP_TAPCELL_ROW_43_479 VGND VPWR sky130_fd_sc_hd__tapvpwrvgnd_1
XFILLER_0_23_201 VGND VGND VPWR VPWR sky130_fd_sc_hd__decap_6
X_3011_ _0740_ _0762_ _0054_ _0055_ VGND VGND VPWR VPWR _0056_ sky130_fd_sc_hd__a2bb2o_1
X_2390_ _0879_ VGND VGND VPWR VPWR _1496_ sky130_fd_sc_hd__clkbuf_2
X_4060_ _1480_ _1667_ _2014_ _1336_ _1151_ VGND VGND VPWR VPWR _1152_ sky130_fd_sc_hd__a221oi_1
XFILLER_0_48_46 VPWR VGND VPWR VGND sky130_ef_sc_hd__decap_12
XFILLER_0_3_15 VGND VGND VPWR VPWR sky130_fd_sc_hd__fill_1
XFILLER_0_58_153 VGND VGND VPWR VPWR sky130_fd_sc_hd__decap_4
XTAP_TAPCELL_ROW_34_413 VGND VPWR sky130_fd_sc_hd__tapvpwrvgnd_1
X_3913_ _0311_ _0982_ _0984_ _0994_ VGND VGND VPWR VPWR _0995_ sky130_fd_sc_hd__o211a_1
XFILLER_0_73_189 VGND VGND VPWR VPWR sky130_fd_sc_hd__decap_6
XFILLER_0_61_307 VGND VGND VPWR VPWR sky130_fd_sc_hd__fill_1
XFILLER_0_58_197 VGND VGND VPWR VPWR sky130_fd_sc_hd__decap_8
X_2726_ _1668_ _1613_ _1551_ VGND VGND VPWR VPWR _1831_ sky130_fd_sc_hd__a21oi_4
X_3775_ _1457_ _1469_ _0745_ _1467_ _1489_ VGND VGND VPWR VPWR _0848_ sky130_fd_sc_hd__o311ai_1
X_3844_ _1741_ _1884_ _1666_ _1471_ VGND VGND VPWR VPWR _0921_ sky130_fd_sc_hd__a2bb2o_1
XFILLER_0_66_3 VPWR VGND VPWR VGND sky130_ef_sc_hd__decap_12
X_2657_ _1364_ _1762_ _1291_ VGND VGND VPWR VPWR _1763_ sky130_fd_sc_hd__o21ai_1
X_2588_ _1599_ VGND VGND VPWR VPWR _1694_ sky130_fd_sc_hd__buf_4
X_4189_ clknet_2_0__leaf_clk _2085_ net120 VGND VGND VPWR VPWR net102 sky130_fd_sc_hd__dfrtp_1
X_3209_ _1890_ VGND VGND VPWR VPWR _0251_ sky130_fd_sc_hd__buf_4
XFILLER_0_52_307 VGND VGND VPWR VPWR sky130_fd_sc_hd__fill_1
XFILLER_0_49_197 VGND VGND VPWR VPWR sky130_fd_sc_hd__decap_8
XFILLER_0_9_250 VPWR VGND VPWR VGND sky130_ef_sc_hd__decap_12
XFILLER_0_64_189 VGND VGND VPWR VPWR sky130_fd_sc_hd__decap_3
XFILLER_0_60_362 VGND VGND VPWR VPWR sky130_fd_sc_hd__fill_2
XTAP_TAPCELL_ROW_48_516 VGND VPWR sky130_fd_sc_hd__tapvpwrvgnd_1
XFILLER_0_18_27 VGND VGND VPWR VPWR sky130_fd_sc_hd__fill_1
XTAP_TAPCELL_ROW_56_582 VGND VPWR sky130_fd_sc_hd__tapvpwrvgnd_1
XTAP_TAPCELL_ROW_5_193 VGND VPWR sky130_fd_sc_hd__tapvpwrvgnd_1
XPHY_EDGE_ROW_16_Right_16 VGND VGND VPWR VPWR sky130_fd_sc_hd__decap_3
XFILLER_0_70_137 VGND VGND VPWR VPWR sky130_fd_sc_hd__decap_3
XFILLER_0_55_167 VGND VGND VPWR VPWR sky130_fd_sc_hd__fill_1
XFILLER_0_55_145 VGND VGND VPWR VPWR sky130_fd_sc_hd__decap_6
XFILLER_0_50_47 VGND VGND VPWR VPWR sky130_fd_sc_hd__decap_8
XPHY_EDGE_ROW_25_Right_25 VGND VGND VPWR VPWR sky130_fd_sc_hd__decap_3
XFILLER_0_3_415 VPWR VGND VPWR VGND sky130_ef_sc_hd__decap_12
X_3560_ _0001_ _1676_ _1264_ VGND VGND VPWR VPWR _0617_ sky130_fd_sc_hd__mux2_1
X_2373_ net13 VGND VGND VPWR VPWR _1479_ sky130_fd_sc_hd__clkbuf_4
XFILLER_0_52_9 VGND VGND VPWR VPWR sky130_fd_sc_hd__decap_3
X_2442_ net67 net68 VGND VGND VPWR VPWR _1548_ sky130_fd_sc_hd__nor2b_2
X_3491_ _0341_ _0342_ _1588_ VGND VGND VPWR VPWR _0542_ sky130_fd_sc_hd__a21oi_1
X_2511_ _1599_ _1468_ _1616_ VGND VGND VPWR VPWR _1617_ sky130_fd_sc_hd__a21oi_2
X_4112_ _1177_ _1938_ _1207_ VGND VGND VPWR VPWR _1208_ sky130_fd_sc_hd__o21ai_1
X_4043_ _1110_ _1111_ _1115_ net109 VGND VGND VPWR VPWR _1134_ sky130_fd_sc_hd__o211a_1
XPHY_EDGE_ROW_34_Right_34 VGND VGND VPWR VPWR sky130_fd_sc_hd__decap_3
XFILLER_0_19_337 VPWR VGND VPWR VGND sky130_ef_sc_hd__decap_12
X_2709_ _0869_ _1546_ _1813_ VGND VGND VPWR VPWR _1814_ sky130_fd_sc_hd__and3_1
XFILLER_0_61_159 VGND VGND VPWR VPWR sky130_fd_sc_hd__decap_8
XPHY_EDGE_ROW_43_Right_43 VGND VGND VPWR VPWR sky130_fd_sc_hd__decap_3
XFILLER_0_42_395 VGND VGND VPWR VPWR sky130_fd_sc_hd__decap_3
XFILLER_0_42_362 VGND VGND VPWR VPWR sky130_fd_sc_hd__fill_2
XFILLER_0_40_91 VGND VGND VPWR VPWR sky130_fd_sc_hd__fill_1
XFILLER_0_40_80 VGND VGND VPWR VPWR sky130_fd_sc_hd__decap_4
X_3758_ _1692_ _1614_ _0816_ _0829_ VGND VGND VPWR VPWR _0830_ sky130_fd_sc_hd__a22o_1
X_3827_ _0903_ _1410_ _1743_ _2037_ VGND VGND VPWR VPWR _0904_ sky130_fd_sc_hd__a31o_1
X_3689_ _1114_ _0349_ _1667_ _0245_ _0755_ VGND VGND VPWR VPWR _0756_ sky130_fd_sc_hd__a221o_1
XPHY_EDGE_ROW_52_Right_52 VGND VGND VPWR VPWR sky130_fd_sc_hd__decap_3
XTAP_TAPCELL_ROW_2_174 VGND VPWR sky130_fd_sc_hd__tapvpwrvgnd_1
XFILLER_0_65_432 VGND VGND VPWR VPWR sky130_fd_sc_hd__fill_1
XPHY_EDGE_ROW_61_Right_61 VGND VGND VPWR VPWR sky130_fd_sc_hd__decap_3
XFILLER_0_37_189 VGND VGND VPWR VPWR sky130_fd_sc_hd__fill_1
XFILLER_0_20_17 VGND VGND VPWR VPWR sky130_fd_sc_hd__decap_8
XPHY_EDGE_ROW_70_Right_70 VGND VGND VPWR VPWR sky130_fd_sc_hd__decap_3
XFILLER_0_61_57 VGND VGND VPWR VPWR sky130_fd_sc_hd__decap_3
XFILLER_0_56_421 VPWR VGND VPWR VGND sky130_ef_sc_hd__decap_12
X_2991_ _1636_ VGND VGND VPWR VPWR _0037_ sky130_fd_sc_hd__clkbuf_4
XFILLER_0_0_27 VGND VGND VPWR VPWR sky130_fd_sc_hd__fill_1
XTAP_TAPCELL_ROW_16_276 VGND VPWR sky130_fd_sc_hd__tapvpwrvgnd_1
X_3612_ _1468_ _1200_ _1472_ _1411_ _1566_ _1632_ VGND VGND VPWR VPWR _0673_ sky130_fd_sc_hd__mux4_1
XFILLER_0_9_36 VPWR VGND VPWR VGND sky130_ef_sc_hd__decap_12
X_3543_ _1604_ _0377_ _0387_ VGND VGND VPWR VPWR _0598_ sky130_fd_sc_hd__o21ai_1
X_2425_ _1530_ _1412_ _1472_ _1409_ VGND VGND VPWR VPWR _1531_ sky130_fd_sc_hd__a31oi_4
X_3474_ _0324_ _0383_ _1303_ _0416_ VGND VGND VPWR VPWR _0524_ sky130_fd_sc_hd__o22a_1
XFILLER_0_10_83 VGND VGND VPWR VPWR sky130_fd_sc_hd__fill_1
X_2356_ _1253_ _1461_ VGND VGND VPWR VPWR _1462_ sky130_fd_sc_hd__nor2_1
X_4026_ _1664_ _1706_ _1613_ _1541_ VGND VGND VPWR VPWR _1116_ sky130_fd_sc_hd__and4_1
XFILLER_0_29_3 VGND VGND VPWR VPWR sky130_fd_sc_hd__decap_8
X_2287_ net34 net2 VGND VGND VPWR VPWR _1393_ sky130_fd_sc_hd__nor2_1
XFILLER_0_66_229 VGND VGND VPWR VPWR sky130_fd_sc_hd__fill_1
XFILLER_0_59_281 VGND VGND VPWR VPWR sky130_fd_sc_hd__decap_4
XFILLER_0_51_90 VGND VGND VPWR VPWR sky130_fd_sc_hd__decap_3
XTAP_TAPCELL_ROW_50_533 VGND VPWR sky130_fd_sc_hd__tapvpwrvgnd_1
XFILLER_0_47_410 VGND VGND VPWR VPWR sky130_fd_sc_hd__fill_1
XFILLER_0_30_365 VGND VGND VPWR VPWR sky130_fd_sc_hd__decap_4
XTAP_TAPCELL_ROW_7_211 VGND VPWR sky130_fd_sc_hd__tapvpwrvgnd_1
XFILLER_0_15_39 VGND VGND VPWR VPWR sky130_fd_sc_hd__fill_2
XFILLER_0_65_284 VPWR VGND VPWR VGND sky130_ef_sc_hd__decap_12
XFILLER_0_40_118 VGND VGND VPWR VPWR sky130_fd_sc_hd__decap_4
XFILLER_0_31_27 VPWR VGND VPWR VGND sky130_ef_sc_hd__decap_12
XFILLER_0_25_148 VGND VGND VPWR VPWR sky130_fd_sc_hd__fill_2
XTAP_TAPCELL_ROW_13_257 VGND VPWR sky130_fd_sc_hd__tapvpwrvgnd_1
X_3190_ net54 _1357_ VGND VGND VPWR VPWR _0233_ sky130_fd_sc_hd__or2_1
X_2210_ _1315_ VGND VGND VPWR VPWR _1316_ sky130_fd_sc_hd__inv_2
X_2141_ net52 net20 VGND VGND VPWR VPWR _0890_ sky130_fd_sc_hd__nor2_2
XTAP_TAPCELL_ROW_64_636 VGND VPWR sky130_fd_sc_hd__tapvpwrvgnd_1
XFILLER_0_71_210 VGND VGND VPWR VPWR sky130_fd_sc_hd__decap_4
X_2974_ _1449_ net17 _1805_ _1945_ _1567_ _1697_ VGND VGND VPWR VPWR _0020_ sky130_fd_sc_hd__mux4_1
XFILLER_0_56_273 VGND VGND VPWR VPWR sky130_fd_sc_hd__fill_2
XFILLER_0_56_251 VGND VGND VPWR VPWR sky130_fd_sc_hd__fill_1
XFILLER_0_29_432 VGND VGND VPWR VPWR sky130_fd_sc_hd__fill_1
XFILLER_0_16_115 VPWR VGND VPWR VGND sky130_ef_sc_hd__decap_12
X_3526_ _0107_ _0574_ _0064_ _0580_ VGND VGND VPWR VPWR _0581_ sky130_fd_sc_hd__a2bb2o_1
XFILLER_0_12_343 VGND VGND VPWR VPWR sky130_fd_sc_hd__decap_8
XFILLER_0_12_365 VPWR VGND VPWR VGND sky130_ef_sc_hd__decap_12
X_3457_ _0033_ _1485_ _0021_ _0020_ _0324_ _1960_ VGND VGND VPWR VPWR _0506_ sky130_fd_sc_hd__mux4_2
X_3388_ _1974_ _1975_ _1960_ VGND VGND VPWR VPWR _0431_ sky130_fd_sc_hd__a21o_1
X_2339_ _1437_ _1433_ _1435_ VGND VGND VPWR VPWR _1445_ sky130_fd_sc_hd__and3b_1
XPHY_EDGE_ROW_2_Right_2 VGND VGND VPWR VPWR sky130_fd_sc_hd__decap_3
X_2408_ _1295_ _1297_ _1513_ _1371_ VGND VGND VPWR VPWR _1514_ sky130_fd_sc_hd__o211ai_2
X_4009_ _1088_ _1092_ _1096_ _1097_ VGND VGND VPWR VPWR _1098_ sky130_fd_sc_hd__and4_1
XFILLER_0_1_81 VPWR VGND VPWR VGND sky130_ef_sc_hd__decap_12
XFILLER_0_22_107 VGND VGND VPWR VPWR sky130_fd_sc_hd__fill_2
XTAP_TAPCELL_ROW_61_617 VGND VPWR sky130_fd_sc_hd__tapvpwrvgnd_1
XFILLER_0_53_210 VGND VGND VPWR VPWR sky130_fd_sc_hd__fill_1
X_2690_ _1780_ _1791_ _1795_ VGND VGND VPWR VPWR _1796_ sky130_fd_sc_hd__o21ai_2
XFILLER_0_53_243 VGND VGND VPWR VPWR sky130_fd_sc_hd__decap_8
XFILLER_0_6_15 VGND VGND VPWR VPWR sky130_fd_sc_hd__decap_6
XANTENNA_3 _0094_ VGND VGND VPWR VPWR sky130_fd_sc_hd__diode_2
X_3311_ _0094_ VGND VGND VPWR VPWR _0349_ sky130_fd_sc_hd__clkbuf_4
X_3242_ _1799_ _1801_ _0729_ _0282_ _0283_ VGND VGND VPWR VPWR _0284_ sky130_fd_sc_hd__o221ai_1
X_2124_ net25 net57 VGND VGND VPWR VPWR _0708_ sky130_fd_sc_hd__and2_1
X_3173_ _1645_ _0213_ _1706_ _0215_ VGND VGND VPWR VPWR _0216_ sky130_fd_sc_hd__a211o_1
X_2957_ net52 _2048_ _1929_ VGND VGND VPWR VPWR _0003_ sky130_fd_sc_hd__a21o_1
X_2888_ _1724_ _1620_ VGND VGND VPWR VPWR _1992_ sky130_fd_sc_hd__nand2_1
XFILLER_0_32_416 VGND VGND VPWR VPWR sky130_fd_sc_hd__decap_4
XTAP_TAPCELL_ROW_32_396 VGND VPWR sky130_fd_sc_hd__tapvpwrvgnd_1
XFILLER_0_32_81 VGND VGND VPWR VPWR sky130_fd_sc_hd__decap_3
XFILLER_0_29_273 VGND VGND VPWR VPWR sky130_fd_sc_hd__decap_6
XFILLER_0_4_351 VGND VGND VPWR VPWR sky130_fd_sc_hd__decap_6
XFILLER_0_8_156 VGND VGND VPWR VPWR sky130_fd_sc_hd__decap_3
XFILLER_0_17_413 VGND VGND VPWR VPWR sky130_fd_sc_hd__fill_2
XFILLER_0_17_435 VGND VGND VPWR VPWR sky130_fd_sc_hd__fill_2
X_3509_ _1287_ _1672_ _0001_ _0560_ _0561_ VGND VGND VPWR VPWR _0562_ sky130_fd_sc_hd__o221a_1
XFILLER_0_4_362 VGND VGND VPWR VPWR sky130_fd_sc_hd__fill_2
XFILLER_0_12_195 VGND VGND VPWR VPWR sky130_fd_sc_hd__fill_1
XFILLER_0_67_379 VPWR VGND VPWR VGND sky130_ef_sc_hd__decap_12
XFILLER_0_67_324 VGND VGND VPWR VPWR sky130_fd_sc_hd__fill_1
XTAP_TAPCELL_ROW_23_330 VGND VPWR sky130_fd_sc_hd__tapvpwrvgnd_1
XFILLER_0_12_29 VGND VGND VPWR VPWR sky130_fd_sc_hd__decap_4
XFILLER_0_35_265 VGND VGND VPWR VPWR sky130_fd_sc_hd__fill_1
Xoutput73 net73 VGND VGND VPWR VPWR negative sky130_fd_sc_hd__clkbuf_4
Xoutput95 net95 VGND VGND VPWR VPWR result[28] sky130_fd_sc_hd__clkbuf_4
Xoutput84 net84 VGND VGND VPWR VPWR result[18] sky130_fd_sc_hd__buf_2
XFILLER_0_53_69 VGND VGND VPWR VPWR sky130_fd_sc_hd__decap_8
XFILLER_0_41_213 VGND VGND VPWR VPWR sky130_fd_sc_hd__decap_8
X_2811_ _1607_ _1614_ _1556_ VGND VGND VPWR VPWR _1916_ sky130_fd_sc_hd__a21oi_4
X_3791_ _1694_ _1719_ _1649_ _1636_ _1910_ VGND VGND VPWR VPWR _0865_ sky130_fd_sc_hd__a311o_4
X_3860_ _0909_ _0936_ _0938_ VGND VGND VPWR VPWR _2062_ sky130_fd_sc_hd__nand3b_1
X_2742_ _1567_ _1467_ _1846_ VGND VGND VPWR VPWR _1847_ sky130_fd_sc_hd__o21ai_2
X_2673_ _0384_ _0395_ VGND VGND VPWR VPWR _1779_ sky130_fd_sc_hd__and2_1
XFILLER_0_41_268 VGND VGND VPWR VPWR sky130_fd_sc_hd__decap_8
X_3087_ _1417_ _1429_ _1353_ _1948_ _1357_ VGND VGND VPWR VPWR _0131_ sky130_fd_sc_hd__o221a_1
X_3156_ _0196_ _0665_ _1318_ _1672_ _0198_ VGND VGND VPWR VPWR _0199_ sky130_fd_sc_hd__o221a_1
X_2107_ _0503_ _0514_ VGND VGND VPWR VPWR _0525_ sky130_fd_sc_hd__nand2_1
XTAP_TAPCELL_ROW_37_433 VGND VPWR sky130_fd_sc_hd__tapvpwrvgnd_1
X_3225_ _1874_ VGND VGND VPWR VPWR _0267_ sky130_fd_sc_hd__clkbuf_4
XFILLER_0_27_92 VGND VGND VPWR VPWR sky130_fd_sc_hd__fill_2
XFILLER_0_64_305 VGND VGND VPWR VPWR sky130_fd_sc_hd__decap_3
XFILLER_0_49_335 VGND VGND VPWR VPWR sky130_fd_sc_hd__fill_1
XFILLER_0_9_421 VGND VGND VPWR VPWR sky130_fd_sc_hd__decap_8
XFILLER_0_11_3 VGND VGND VPWR VPWR sky130_fd_sc_hd__fill_1
XFILLER_0_72_360 VGND VGND VPWR VPWR sky130_fd_sc_hd__decap_4
X_3989_ _0443_ _1075_ _0107_ VGND VGND VPWR VPWR _1076_ sky130_fd_sc_hd__a21o_1
XFILLER_0_32_235 VGND VGND VPWR VPWR sky130_fd_sc_hd__fill_2
XTAP_TAPCELL_ROW_20_311 VGND VPWR sky130_fd_sc_hd__tapvpwrvgnd_1
XFILLER_0_17_254 VPWR VGND VPWR VGND sky130_ef_sc_hd__decap_12
XFILLER_0_17_298 VGND VGND VPWR VPWR sky130_fd_sc_hd__decap_6
XFILLER_0_7_80 VGND VGND VPWR VPWR sky130_fd_sc_hd__decap_8
XFILLER_0_67_110 VGND VGND VPWR VPWR sky130_fd_sc_hd__fill_2
XFILLER_0_48_58 VGND VGND VPWR VPWR sky130_fd_sc_hd__decap_6
XFILLER_0_23_279 VGND VGND VPWR VPWR sky130_fd_sc_hd__fill_1
X_3010_ _1508_ _1536_ _0976_ VGND VGND VPWR VPWR _0055_ sky130_fd_sc_hd__o21bai_2
XFILLER_0_73_113 VPWR VGND VPWR VGND sky130_ef_sc_hd__decap_12
XFILLER_0_58_187 VGND VGND VPWR VPWR sky130_fd_sc_hd__decap_8
XFILLER_0_58_121 VGND VGND VPWR VPWR sky130_fd_sc_hd__fill_1
XTAP_TAPCELL_ROW_34_414 VGND VPWR sky130_fd_sc_hd__tapvpwrvgnd_1
X_3912_ _0275_ _0413_ _0987_ _0038_ _0993_ VGND VGND VPWR VPWR _0994_ sky130_fd_sc_hd__o221a_1
X_3843_ _1050_ _1676_ _1674_ VGND VGND VPWR VPWR _0920_ sky130_fd_sc_hd__o21a_1
X_2725_ _1636_ VGND VGND VPWR VPWR _1830_ sky130_fd_sc_hd__buf_2
X_3774_ _1486_ _1469_ _0825_ _1467_ VGND VGND VPWR VPWR _0846_ sky130_fd_sc_hd__a211oi_1
X_2656_ net62 net30 VGND VGND VPWR VPWR _1762_ sky130_fd_sc_hd__nor2_1
XFILLER_0_13_83 VGND VGND VPWR VPWR sky130_fd_sc_hd__decap_8
XFILLER_0_59_3 VGND VGND VPWR VPWR sky130_fd_sc_hd__decap_6
X_2587_ _1302_ VGND VGND VPWR VPWR _1693_ sky130_fd_sc_hd__clkbuf_4
X_3139_ _0762_ _0154_ _0061_ _0182_ _2038_ VGND VGND VPWR VPWR _0183_ sky130_fd_sc_hd__a221oi_1
X_3208_ _0243_ _1555_ _0247_ _1592_ _0249_ VGND VGND VPWR VPWR _0250_ sky130_fd_sc_hd__o221a_1
X_4188_ clknet_2_1__leaf_clk _2084_ net120 VGND VGND VPWR VPWR net101 sky130_fd_sc_hd__dfrtp_1
XPHY_EDGE_ROW_19_Left_93 VGND VGND VPWR VPWR sky130_fd_sc_hd__decap_3
XFILLER_0_9_262 VPWR VGND VPWR VGND sky130_ef_sc_hd__decap_12
XFILLER_0_9_284 VPWR VGND VPWR VGND sky130_ef_sc_hd__decap_12
XFILLER_0_60_396 VGND VGND VPWR VPWR sky130_fd_sc_hd__fill_1
XTAP_TAPCELL_ROW_48_517 VGND VPWR sky130_fd_sc_hd__tapvpwrvgnd_1
XFILLER_0_0_3 VGND VGND VPWR VPWR sky130_fd_sc_hd__decap_6
XTAP_TAPCELL_ROW_5_194 VGND VPWR sky130_fd_sc_hd__tapvpwrvgnd_1
XFILLER_0_50_15 VGND VGND VPWR VPWR sky130_fd_sc_hd__fill_1
X_3490_ _1830_ _1613_ _2010_ _1916_ VGND VGND VPWR VPWR _0541_ sky130_fd_sc_hd__a31o_1
XFILLER_0_36_371 VPWR VGND VPWR VGND sky130_ef_sc_hd__decap_12
XFILLER_0_3_427 VGND VGND VPWR VPWR sky130_fd_sc_hd__decap_8
X_2510_ _1563_ net32 VGND VGND VPWR VPWR _1616_ sky130_fd_sc_hd__and2_1
X_2441_ _1496_ _1508_ _1536_ _1545_ _1546_ VGND VGND VPWR VPWR _1547_ sky130_fd_sc_hd__o311a_1
X_2372_ net14 VGND VGND VPWR VPWR _1478_ sky130_fd_sc_hd__clkbuf_4
XFILLER_0_59_57 VGND VGND VPWR VPWR sky130_fd_sc_hd__fill_1
XFILLER_0_59_35 VGND VGND VPWR VPWR sky130_fd_sc_hd__decap_6
X_4111_ _1338_ _1939_ _0428_ _0429_ VGND VGND VPWR VPWR _1207_ sky130_fd_sc_hd__o211a_1
X_4042_ _0506_ _1032_ _0151_ _1119_ _1132_ VGND VGND VPWR VPWR _1133_ sky130_fd_sc_hd__a2111oi_1
XFILLER_0_27_360 VGND VGND VPWR VPWR sky130_fd_sc_hd__fill_1
XFILLER_0_19_349 VGND VGND VPWR VPWR sky130_fd_sc_hd__fill_2
X_3826_ _0902_ _1765_ _1771_ VGND VGND VPWR VPWR _0903_ sky130_fd_sc_hd__o21a_1
X_2708_ _0826_ _0847_ VGND VGND VPWR VPWR _1813_ sky130_fd_sc_hd__nor2_1
X_3757_ _0032_ _1830_ _1974_ VGND VGND VPWR VPWR _0829_ sky130_fd_sc_hd__or3_1
XFILLER_0_27_393 VGND VGND VPWR VPWR sky130_fd_sc_hd__fill_2
X_2639_ _1527_ _1529_ _1742_ _1744_ VGND VGND VPWR VPWR _1745_ sky130_fd_sc_hd__nand4_1
X_3688_ _1925_ _0353_ _0754_ VGND VGND VPWR VPWR _0755_ sky130_fd_sc_hd__mux2_1
XFILLER_0_69_205 VGND VGND VPWR VPWR sky130_fd_sc_hd__decap_8
XTAP_TAPCELL_ROW_53_553 VGND VPWR sky130_fd_sc_hd__tapvpwrvgnd_1
XFILLER_0_37_113 VGND VGND VPWR VPWR sky130_fd_sc_hd__fill_2
XPHY_EDGE_ROW_4_Left_78 VGND VGND VPWR VPWR sky130_fd_sc_hd__decap_3
XTAP_TAPCELL_ROW_2_175 VGND VPWR sky130_fd_sc_hd__tapvpwrvgnd_1
XFILLER_0_52_149 VGND VGND VPWR VPWR sky130_fd_sc_hd__fill_2
XFILLER_0_52_138 VGND VGND VPWR VPWR sky130_fd_sc_hd__fill_2
XFILLER_0_33_341 VGND VGND VPWR VPWR sky130_fd_sc_hd__fill_1
XFILLER_0_68_282 VGND VGND VPWR VPWR sky130_fd_sc_hd__decap_3
X_2990_ _1537_ _1433_ _1613_ _1437_ VGND VGND VPWR VPWR _0036_ sky130_fd_sc_hd__and4bb_2
XTAP_TAPCELL_ROW_16_277 VGND VPWR sky130_fd_sc_hd__tapvpwrvgnd_1
X_3542_ _1905_ _1906_ _0375_ _0374_ _1581_ _1840_ VGND VGND VPWR VPWR _0597_ sky130_fd_sc_hd__mux4_1
X_3611_ _1718_ _0315_ _1715_ _1713_ _1627_ _1582_ VGND VGND VPWR VPWR _0672_ sky130_fd_sc_hd__mux4_2
XFILLER_0_24_363 VGND VGND VPWR VPWR sky130_fd_sc_hd__fill_1
XFILLER_0_9_48 VGND VGND VPWR VPWR sky130_fd_sc_hd__decap_8
X_3473_ _1295_ _0508_ _0509_ _0512_ _0522_ VGND VGND VPWR VPWR _0523_ sky130_fd_sc_hd__o2111a_1
X_2355_ net27 VGND VGND VPWR VPWR _1461_ sky130_fd_sc_hd__clkbuf_2
X_2424_ net36 VGND VGND VPWR VPWR _1530_ sky130_fd_sc_hd__inv_2
X_2286_ net34 net2 VGND VGND VPWR VPWR _1392_ sky130_fd_sc_hd__and2_1
XFILLER_0_59_271 VGND VGND VPWR VPWR sky130_fd_sc_hd__decap_8
X_4025_ _1543_ _1821_ _1112_ _0525_ _1113_ VGND VGND VPWR VPWR _1115_ sky130_fd_sc_hd__o221ai_1
XFILLER_0_19_113 VGND VGND VPWR VPWR sky130_fd_sc_hd__fill_2
XTAP_TAPCELL_ROW_50_534 VGND VPWR sky130_fd_sc_hd__tapvpwrvgnd_1
XFILLER_0_34_105 VPWR VGND VPWR VGND sky130_ef_sc_hd__decap_12
X_3809_ _1485_ _0398_ _1986_ _1667_ _0872_ VGND VGND VPWR VPWR _0884_ sky130_fd_sc_hd__a32o_1
XFILLER_0_19_124 VGND VGND VPWR VPWR sky130_fd_sc_hd__decap_4
XFILLER_0_30_344 VPWR VGND VPWR VGND sky130_ef_sc_hd__decap_12
XFILLER_0_30_333 VGND VGND VPWR VPWR sky130_fd_sc_hd__decap_3
XTAP_TAPCELL_ROW_7_212 VGND VPWR sky130_fd_sc_hd__tapvpwrvgnd_1
XFILLER_0_65_274 VGND VGND VPWR VPWR sky130_fd_sc_hd__fill_1
XFILLER_0_38_433 VGND VGND VPWR VPWR sky130_fd_sc_hd__decap_4
XFILLER_0_31_39 VPWR VGND VPWR VGND sky130_ef_sc_hd__decap_12
XFILLER_0_65_296 VGND VGND VPWR VPWR sky130_fd_sc_hd__decap_4
Xwire110 _1184_ VGND VGND VPWR VPWR net110 sky130_fd_sc_hd__clkbuf_1
XFILLER_0_25_127 VGND VGND VPWR VPWR sky130_fd_sc_hd__decap_4
XFILLER_0_21_333 VGND VGND VPWR VPWR sky130_fd_sc_hd__decap_3
XFILLER_0_21_311 VGND VGND VPWR VPWR sky130_fd_sc_hd__decap_6
XTAP_TAPCELL_ROW_13_258 VGND VPWR sky130_fd_sc_hd__tapvpwrvgnd_1
X_2140_ _0858_ _0869_ VGND VGND VPWR VPWR _0879_ sky130_fd_sc_hd__and2_1
XFILLER_0_0_238 VGND VGND VPWR VPWR sky130_fd_sc_hd__decap_3
XTAP_TAPCELL_ROW_64_637 VGND VPWR sky130_fd_sc_hd__tapvpwrvgnd_1
X_2973_ _1645_ _0016_ _0018_ _2002_ VGND VGND VPWR VPWR _0019_ sky130_fd_sc_hd__o211a_1
XFILLER_0_8_338 VGND VGND VPWR VPWR sky130_fd_sc_hd__decap_6
XFILLER_0_16_127 VGND VGND VPWR VPWR sky130_fd_sc_hd__decap_3
X_3525_ _0577_ _0578_ _1726_ VGND VGND VPWR VPWR _0580_ sky130_fd_sc_hd__mux2_1
XFILLER_0_24_160 VPWR VGND VPWR VGND sky130_ef_sc_hd__decap_12
X_3456_ _0433_ _0499_ _0504_ VGND VGND VPWR VPWR _0505_ sky130_fd_sc_hd__o21ai_1
XFILLER_0_12_377 VPWR VGND VPWR VGND sky130_ef_sc_hd__decap_12
X_2338_ _1443_ VGND VGND VPWR VPWR _1444_ sky130_fd_sc_hd__clkbuf_4
XFILLER_0_41_3 VPWR VGND VPWR VGND sky130_ef_sc_hd__decap_12
X_4008_ _0211_ _0085_ _1868_ _0432_ VGND VGND VPWR VPWR _1097_ sky130_fd_sc_hd__o22a_1
X_3387_ _0324_ _0426_ _0428_ _0429_ VGND VGND VPWR VPWR _0430_ sky130_fd_sc_hd__o211a_1
X_2407_ _1511_ _1512_ VGND VGND VPWR VPWR _1513_ sky130_fd_sc_hd__nand2_1
X_2269_ _1374_ net26 VGND VGND VPWR VPWR _1375_ sky130_fd_sc_hd__nand2_1
XFILLER_0_1_93 VGND VGND VPWR VPWR sky130_fd_sc_hd__decap_8
XFILLER_0_30_141 VPWR VGND VPWR VGND sky130_ef_sc_hd__decap_12
XTAP_TAPCELL_ROW_61_618 VGND VPWR sky130_fd_sc_hd__tapvpwrvgnd_1
XFILLER_0_38_263 VPWR VGND VPWR VGND sky130_ef_sc_hd__decap_12
XTAP_TAPCELL_ROW_26_350 VGND VPWR sky130_fd_sc_hd__tapvpwrvgnd_1
XPHY_EDGE_ROW_7_Left_81 VGND VGND VPWR VPWR sky130_fd_sc_hd__decap_3
XFILLER_0_67_57 VPWR VGND VPWR VGND sky130_ef_sc_hd__decap_12
XANTENNA_4 _0164_ VGND VGND VPWR VPWR sky130_fd_sc_hd__diode_2
X_3310_ _1417_ _1429_ _1537_ _1553_ _1539_ VGND VGND VPWR VPWR _0348_ sky130_fd_sc_hd__o2111ai_1
XFILLER_0_21_130 VPWR VGND VPWR VGND sky130_ef_sc_hd__decap_12
X_3241_ _0200_ _0230_ _0729_ VGND VGND VPWR VPWR _0283_ sky130_fd_sc_hd__o21ai_1
X_2123_ net25 net57 VGND VGND VPWR VPWR _0697_ sky130_fd_sc_hd__nor2_2
XFILLER_0_67_79 VGND VGND VPWR VPWR sky130_fd_sc_hd__fill_1
X_3172_ _1662_ _1996_ _0214_ _1726_ VGND VGND VPWR VPWR _0215_ sky130_fd_sc_hd__a211oi_2
XFILLER_0_8_102 VPWR VGND VPWR VGND sky130_ef_sc_hd__decap_12
XFILLER_0_16_61 VPWR VGND VPWR VGND sky130_ef_sc_hd__decap_12
X_2956_ _1348_ _1665_ _1490_ _0890_ _0001_ VGND VGND VPWR VPWR _0002_ sky130_fd_sc_hd__o32a_1
X_2887_ _1978_ _1626_ _1657_ VGND VGND VPWR VPWR _1991_ sky130_fd_sc_hd__mux2_1
XTAP_TAPCELL_ROW_32_397 VGND VPWR sky130_fd_sc_hd__tapvpwrvgnd_1
XFILLER_0_4_330 VGND VGND VPWR VPWR sky130_fd_sc_hd__fill_2
XFILLER_0_4_374 VGND VGND VPWR VPWR sky130_fd_sc_hd__fill_2
XFILLER_0_8_168 VPWR VGND VPWR VGND sky130_ef_sc_hd__decap_12
XFILLER_0_12_130 VGND VGND VPWR VPWR sky130_fd_sc_hd__decap_4
X_3439_ _1905_ _1908_ _1907_ _1871_ _0078_ _1662_ VGND VGND VPWR VPWR _0486_ sky130_fd_sc_hd__mux4_2
X_3508_ _0337_ _1666_ _1679_ _1556_ VGND VGND VPWR VPWR _0561_ sky130_fd_sc_hd__a22oi_1
XFILLER_0_12_141 VGND VGND VPWR VPWR sky130_fd_sc_hd__decap_4
XFILLER_0_12_152 VPWR VGND VPWR VGND sky130_ef_sc_hd__decap_12
XFILLER_0_35_211 VGND VGND VPWR VPWR sky130_fd_sc_hd__decap_6
XTAP_TAPCELL_ROW_23_331 VGND VPWR sky130_fd_sc_hd__tapvpwrvgnd_1
XFILLER_0_50_247 VGND VGND VPWR VPWR sky130_fd_sc_hd__decap_4
XFILLER_0_35_288 VPWR VGND VPWR VGND sky130_ef_sc_hd__decap_12
Xoutput96 net96 VGND VGND VPWR VPWR result[29] sky130_fd_sc_hd__clkbuf_4
Xoutput74 net74 VGND VGND VPWR VPWR overflow sky130_fd_sc_hd__clkbuf_4
Xoutput85 net85 VGND VGND VPWR VPWR result[19] sky130_fd_sc_hd__buf_2
XFILLER_0_73_317 VGND VGND VPWR VPWR sky130_fd_sc_hd__fill_1
XFILLER_0_73_328 VGND VGND VPWR VPWR sky130_fd_sc_hd__decap_8
X_2810_ _1912_ _1914_ VGND VGND VPWR VPWR _1915_ sky130_fd_sc_hd__nand2_1
X_3790_ _1692_ _1614_ _0852_ _0863_ VGND VGND VPWR VPWR _0864_ sky130_fd_sc_hd__a22o_1
XFILLER_0_26_244 VGND VGND VPWR VPWR sky130_fd_sc_hd__decap_8
X_2672_ _1748_ _1765_ _1777_ VGND VGND VPWR VPWR _1778_ sky130_fd_sc_hd__o21bai_4
X_2741_ net2 _1563_ VGND VGND VPWR VPWR _1846_ sky130_fd_sc_hd__nand2b_2
X_3224_ _1869_ _1873_ _1871_ _1907_ _1580_ _1628_ VGND VGND VPWR VPWR _0266_ sky130_fd_sc_hd__mux4_2
XFILLER_0_1_333 VGND VGND VPWR VPWR sky130_fd_sc_hd__decap_3
.ends
